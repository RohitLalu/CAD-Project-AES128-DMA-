* NGSPICE file created from picorv32.ext - technology: sky130A

* Black-box entry subcircuit for sky130_fd_sc_hd__a21oi_1 abstract view
.subckt sky130_fd_sc_hd__a21oi_1 A1 A2 B1 VGND VNB VPB VPWR Y
.ends

* Black-box entry subcircuit for sky130_fd_sc_hd__fill_1 abstract view
.subckt sky130_fd_sc_hd__fill_1 VGND VNB VPB VPWR
.ends

* Black-box entry subcircuit for sky130_fd_sc_hd__fill_2 abstract view
.subckt sky130_fd_sc_hd__fill_2 VGND VNB VPB VPWR
.ends

* Black-box entry subcircuit for sky130_fd_sc_hd__tapvpwrvgnd_1 abstract view
.subckt sky130_fd_sc_hd__tapvpwrvgnd_1 VGND VPWR
.ends

* Black-box entry subcircuit for sky130_fd_sc_hd__nor2_1 abstract view
.subckt sky130_fd_sc_hd__nor2_1 A B VGND VNB VPB VPWR Y
.ends

* Black-box entry subcircuit for sky130_fd_sc_hd__decap_4 abstract view
.subckt sky130_fd_sc_hd__decap_4 VGND VNB VPB VPWR
.ends

* Black-box entry subcircuit for sky130_fd_sc_hd__mux2_1 abstract view
.subckt sky130_fd_sc_hd__mux2_1 A0 A1 S VGND VNB VPB VPWR X
.ends

* Black-box entry subcircuit for sky130_fd_sc_hd__a31o_1 abstract view
.subckt sky130_fd_sc_hd__a31o_1 A1 A2 A3 B1 VGND VNB VPB VPWR X
.ends

* Black-box entry subcircuit for sky130_fd_sc_hd__decap_8 abstract view
.subckt sky130_fd_sc_hd__decap_8 VGND VNB VPB VPWR
.ends

* Black-box entry subcircuit for sky130_fd_sc_hd__o22a_1 abstract view
.subckt sky130_fd_sc_hd__o22a_1 A1 A2 B1 B2 VGND VNB VPB VPWR X
.ends

* Black-box entry subcircuit for sky130_ef_sc_hd__decap_12 abstract view
.subckt sky130_ef_sc_hd__decap_12 VPWR VGND VPB VNB
.ends

* Black-box entry subcircuit for sky130_fd_sc_hd__o21ba_1 abstract view
.subckt sky130_fd_sc_hd__o21ba_1 A1 A2 B1_N VGND VNB VPB VPWR X
.ends

* Black-box entry subcircuit for sky130_fd_sc_hd__a211o_1 abstract view
.subckt sky130_fd_sc_hd__a211o_1 A1 A2 B1 C1 VGND VNB VPB VPWR X
.ends

* Black-box entry subcircuit for sky130_fd_sc_hd__and3_1 abstract view
.subckt sky130_fd_sc_hd__and3_1 A B C VGND VNB VPB VPWR X
.ends

* Black-box entry subcircuit for sky130_fd_sc_hd__mux4_1 abstract view
.subckt sky130_fd_sc_hd__mux4_1 A0 A1 A2 A3 S0 S1 VGND VNB VPB VPWR X
.ends

* Black-box entry subcircuit for sky130_fd_sc_hd__o21a_1 abstract view
.subckt sky130_fd_sc_hd__o21a_1 A1 A2 B1 VGND VNB VPB VPWR X
.ends

* Black-box entry subcircuit for sky130_fd_sc_hd__decap_3 abstract view
.subckt sky130_fd_sc_hd__decap_3 VGND VNB VPB VPWR
.ends

* Black-box entry subcircuit for sky130_fd_sc_hd__dfxtp_4 abstract view
.subckt sky130_fd_sc_hd__dfxtp_4 CLK D VGND VNB VPB VPWR Q
.ends

* Black-box entry subcircuit for sky130_fd_sc_hd__decap_6 abstract view
.subckt sky130_fd_sc_hd__decap_6 VGND VNB VPB VPWR
.ends

* Black-box entry subcircuit for sky130_fd_sc_hd__dfxtp_1 abstract view
.subckt sky130_fd_sc_hd__dfxtp_1 CLK D VGND VNB VPB VPWR Q
.ends

* Black-box entry subcircuit for sky130_fd_sc_hd__dlygate4sd1_1 abstract view
.subckt sky130_fd_sc_hd__dlygate4sd1_1 A VGND VNB VPB VPWR X
.ends

* Black-box entry subcircuit for sky130_fd_sc_hd__nor2_2 abstract view
.subckt sky130_fd_sc_hd__nor2_2 A B VGND VNB VPB VPWR Y
.ends

* Black-box entry subcircuit for sky130_fd_sc_hd__or2_1 abstract view
.subckt sky130_fd_sc_hd__or2_1 A B VGND VNB VPB VPWR X
.ends

* Black-box entry subcircuit for sky130_fd_sc_hd__o31a_1 abstract view
.subckt sky130_fd_sc_hd__o31a_1 A1 A2 A3 B1 VGND VNB VPB VPWR X
.ends

* Black-box entry subcircuit for sky130_fd_sc_hd__nand2_1 abstract view
.subckt sky130_fd_sc_hd__nand2_1 A B VGND VNB VPB VPWR Y
.ends

* Black-box entry subcircuit for sky130_fd_sc_hd__a22oi_1 abstract view
.subckt sky130_fd_sc_hd__a22oi_1 A1 A2 B1 B2 VGND VNB VPB VPWR Y
.ends

* Black-box entry subcircuit for sky130_fd_sc_hd__o21bai_1 abstract view
.subckt sky130_fd_sc_hd__o21bai_1 A1 A2 B1_N VGND VNB VPB VPWR Y
.ends

* Black-box entry subcircuit for sky130_fd_sc_hd__a221o_1 abstract view
.subckt sky130_fd_sc_hd__a221o_1 A1 A2 B1 B2 C1 VGND VNB VPB VPWR X
.ends

* Black-box entry subcircuit for sky130_fd_sc_hd__conb_1 abstract view
.subckt sky130_fd_sc_hd__conb_1 VGND VNB VPB VPWR HI LO
.ends

* Black-box entry subcircuit for sky130_fd_sc_hd__and2_4 abstract view
.subckt sky130_fd_sc_hd__and2_4 A B VGND VNB VPB VPWR X
.ends

* Black-box entry subcircuit for sky130_fd_sc_hd__and2b_1 abstract view
.subckt sky130_fd_sc_hd__and2b_1 A_N B VGND VNB VPB VPWR X
.ends

* Black-box entry subcircuit for sky130_fd_sc_hd__a21o_1 abstract view
.subckt sky130_fd_sc_hd__a21o_1 A1 A2 B1 VGND VNB VPB VPWR X
.ends

* Black-box entry subcircuit for sky130_fd_sc_hd__or3_1 abstract view
.subckt sky130_fd_sc_hd__or3_1 A B C VGND VNB VPB VPWR X
.ends

* Black-box entry subcircuit for sky130_fd_sc_hd__clkbuf_8 abstract view
.subckt sky130_fd_sc_hd__clkbuf_8 A VGND VNB VPB VPWR X
.ends

* Black-box entry subcircuit for sky130_fd_sc_hd__buf_2 abstract view
.subckt sky130_fd_sc_hd__buf_2 A VGND VNB VPB VPWR X
.ends

* Black-box entry subcircuit for sky130_fd_sc_hd__inv_2 abstract view
.subckt sky130_fd_sc_hd__inv_2 A VGND VNB VPB VPWR Y
.ends

* Black-box entry subcircuit for sky130_fd_sc_hd__a22o_1 abstract view
.subckt sky130_fd_sc_hd__a22o_1 A1 A2 B1 B2 VGND VNB VPB VPWR X
.ends

* Black-box entry subcircuit for sky130_fd_sc_hd__or4_1 abstract view
.subckt sky130_fd_sc_hd__or4_1 A B C D VGND VNB VPB VPWR X
.ends

* Black-box entry subcircuit for sky130_fd_sc_hd__and2_1 abstract view
.subckt sky130_fd_sc_hd__and2_1 A B VGND VNB VPB VPWR X
.ends

* Black-box entry subcircuit for sky130_fd_sc_hd__a21bo_1 abstract view
.subckt sky130_fd_sc_hd__a21bo_1 A1 A2 B1_N VGND VNB VPB VPWR X
.ends

* Black-box entry subcircuit for sky130_fd_sc_hd__clkbuf_4 abstract view
.subckt sky130_fd_sc_hd__clkbuf_4 A VGND VNB VPB VPWR X
.ends

* Black-box entry subcircuit for sky130_fd_sc_hd__dfxtp_2 abstract view
.subckt sky130_fd_sc_hd__dfxtp_2 CLK D VGND VNB VPB VPWR Q
.ends

* Black-box entry subcircuit for sky130_fd_sc_hd__a211oi_1 abstract view
.subckt sky130_fd_sc_hd__a211oi_1 A1 A2 B1 C1 VGND VNB VPB VPWR Y
.ends

* Black-box entry subcircuit for sky130_fd_sc_hd__or2_2 abstract view
.subckt sky130_fd_sc_hd__or2_2 A B VGND VNB VPB VPWR X
.ends

* Black-box entry subcircuit for sky130_fd_sc_hd__and4b_1 abstract view
.subckt sky130_fd_sc_hd__and4b_1 A_N B C D VGND VNB VPB VPWR X
.ends

* Black-box entry subcircuit for sky130_fd_sc_hd__o21ai_1 abstract view
.subckt sky130_fd_sc_hd__o21ai_1 A1 A2 B1 VGND VNB VPB VPWR Y
.ends

* Black-box entry subcircuit for sky130_fd_sc_hd__inv_16 abstract view
.subckt sky130_fd_sc_hd__inv_16 A VGND VNB VPB VPWR Y
.ends

* Black-box entry subcircuit for sky130_fd_sc_hd__diode_2 abstract view
.subckt sky130_fd_sc_hd__diode_2 DIODE VGND VNB VPB VPWR
.ends

* Black-box entry subcircuit for sky130_fd_sc_hd__dlymetal6s2s_1 abstract view
.subckt sky130_fd_sc_hd__dlymetal6s2s_1 A VGND VNB VPB VPWR X
.ends

* Black-box entry subcircuit for sky130_fd_sc_hd__a311o_1 abstract view
.subckt sky130_fd_sc_hd__a311o_1 A1 A2 A3 B1 C1 VGND VNB VPB VPWR X
.ends

* Black-box entry subcircuit for sky130_fd_sc_hd__mux2_8 abstract view
.subckt sky130_fd_sc_hd__mux2_8 A0 A1 S VGND VNB VPB VPWR X
.ends

* Black-box entry subcircuit for sky130_fd_sc_hd__nand3_1 abstract view
.subckt sky130_fd_sc_hd__nand3_1 A B C VGND VNB VPB VPWR Y
.ends

* Black-box entry subcircuit for sky130_fd_sc_hd__buf_12 abstract view
.subckt sky130_fd_sc_hd__buf_12 A VGND VNB VPB VPWR X
.ends

* Black-box entry subcircuit for sky130_fd_sc_hd__clkbuf_1 abstract view
.subckt sky130_fd_sc_hd__clkbuf_1 A VGND VNB VPB VPWR X
.ends

* Black-box entry subcircuit for sky130_fd_sc_hd__nand2_8 abstract view
.subckt sky130_fd_sc_hd__nand2_8 A B VGND VNB VPB VPWR Y
.ends

* Black-box entry subcircuit for sky130_fd_sc_hd__nor2_8 abstract view
.subckt sky130_fd_sc_hd__nor2_8 A B VGND VNB VPB VPWR Y
.ends

* Black-box entry subcircuit for sky130_fd_sc_hd__xnor2_1 abstract view
.subckt sky130_fd_sc_hd__xnor2_1 A B VGND VNB VPB VPWR Y
.ends

* Black-box entry subcircuit for sky130_fd_sc_hd__or2_4 abstract view
.subckt sky130_fd_sc_hd__or2_4 A B VGND VNB VPB VPWR X
.ends

* Black-box entry subcircuit for sky130_fd_sc_hd__a21oi_2 abstract view
.subckt sky130_fd_sc_hd__a21oi_2 A1 A2 B1 VGND VNB VPB VPWR Y
.ends

* Black-box entry subcircuit for sky130_fd_sc_hd__o21ba_4 abstract view
.subckt sky130_fd_sc_hd__o21ba_4 A1 A2 B1_N VGND VNB VPB VPWR X
.ends

* Black-box entry subcircuit for sky130_fd_sc_hd__or4_2 abstract view
.subckt sky130_fd_sc_hd__or4_2 A B C D VGND VNB VPB VPWR X
.ends

* Black-box entry subcircuit for sky130_fd_sc_hd__a32o_1 abstract view
.subckt sky130_fd_sc_hd__a32o_1 A1 A2 A3 B1 B2 VGND VNB VPB VPWR X
.ends

* Black-box entry subcircuit for sky130_fd_sc_hd__xor2_1 abstract view
.subckt sky130_fd_sc_hd__xor2_1 A B VGND VNB VPB VPWR X
.ends

* Black-box entry subcircuit for sky130_fd_sc_hd__inv_8 abstract view
.subckt sky130_fd_sc_hd__inv_8 A VGND VNB VPB VPWR Y
.ends

* Black-box entry subcircuit for sky130_fd_sc_hd__and4_1 abstract view
.subckt sky130_fd_sc_hd__and4_1 A B C D VGND VNB VPB VPWR X
.ends

* Black-box entry subcircuit for sky130_fd_sc_hd__clkinv_16 abstract view
.subckt sky130_fd_sc_hd__clkinv_16 A VGND VNB VPB VPWR Y
.ends

* Black-box entry subcircuit for sky130_fd_sc_hd__o221a_1 abstract view
.subckt sky130_fd_sc_hd__o221a_1 A1 A2 B1 B2 C1 VGND VNB VPB VPWR X
.ends

* Black-box entry subcircuit for sky130_fd_sc_hd__nor2_4 abstract view
.subckt sky130_fd_sc_hd__nor2_4 A B VGND VNB VPB VPWR Y
.ends

* Black-box entry subcircuit for sky130_fd_sc_hd__o311a_1 abstract view
.subckt sky130_fd_sc_hd__o311a_1 A1 A2 A3 B1 C1 VGND VNB VPB VPWR X
.ends

* Black-box entry subcircuit for sky130_fd_sc_hd__o211a_1 abstract view
.subckt sky130_fd_sc_hd__o211a_1 A1 A2 B1 C1 VGND VNB VPB VPWR X
.ends

* Black-box entry subcircuit for sky130_fd_sc_hd__mux2_2 abstract view
.subckt sky130_fd_sc_hd__mux2_2 A0 A1 S VGND VNB VPB VPWR X
.ends

* Black-box entry subcircuit for sky130_fd_sc_hd__nor3_4 abstract view
.subckt sky130_fd_sc_hd__nor3_4 A B C VGND VNB VPB VPWR Y
.ends

* Black-box entry subcircuit for sky130_fd_sc_hd__o211ai_1 abstract view
.subckt sky130_fd_sc_hd__o211ai_1 A1 A2 B1 C1 VGND VNB VPB VPWR Y
.ends

* Black-box entry subcircuit for sky130_fd_sc_hd__a41o_1 abstract view
.subckt sky130_fd_sc_hd__a41o_1 A1 A2 A3 A4 B1 VGND VNB VPB VPWR X
.ends

* Black-box entry subcircuit for sky130_fd_sc_hd__o211ai_2 abstract view
.subckt sky130_fd_sc_hd__o211ai_2 A1 A2 B1 C1 VGND VNB VPB VPWR Y
.ends

* Black-box entry subcircuit for sky130_fd_sc_hd__o41a_1 abstract view
.subckt sky130_fd_sc_hd__o41a_1 A1 A2 A3 A4 B1 VGND VNB VPB VPWR X
.ends

* Black-box entry subcircuit for sky130_fd_sc_hd__inv_6 abstract view
.subckt sky130_fd_sc_hd__inv_6 A VGND VNB VPB VPWR Y
.ends

* Black-box entry subcircuit for sky130_fd_sc_hd__clkinvlp_4 abstract view
.subckt sky130_fd_sc_hd__clkinvlp_4 A VGND VNB VPB VPWR Y
.ends

* Black-box entry subcircuit for sky130_fd_sc_hd__and3b_1 abstract view
.subckt sky130_fd_sc_hd__and3b_1 A_N B C VGND VNB VPB VPWR X
.ends

* Black-box entry subcircuit for sky130_fd_sc_hd__clkinv_4 abstract view
.subckt sky130_fd_sc_hd__clkinv_4 A VGND VNB VPB VPWR Y
.ends

* Black-box entry subcircuit for sky130_fd_sc_hd__dlymetal6s4s_1 abstract view
.subckt sky130_fd_sc_hd__dlymetal6s4s_1 A VGND VNB VPB VPWR X
.ends

* Black-box entry subcircuit for sky130_fd_sc_hd__xor2_2 abstract view
.subckt sky130_fd_sc_hd__xor2_2 A B VGND VNB VPB VPWR X
.ends

* Black-box entry subcircuit for sky130_fd_sc_hd__buf_6 abstract view
.subckt sky130_fd_sc_hd__buf_6 A VGND VNB VPB VPWR X
.ends

* Black-box entry subcircuit for sky130_fd_sc_hd__and2b_4 abstract view
.subckt sky130_fd_sc_hd__and2b_4 A_N B VGND VNB VPB VPWR X
.ends

* Black-box entry subcircuit for sky130_fd_sc_hd__and3_4 abstract view
.subckt sky130_fd_sc_hd__and3_4 A B C VGND VNB VPB VPWR X
.ends

* Black-box entry subcircuit for sky130_fd_sc_hd__and4bb_1 abstract view
.subckt sky130_fd_sc_hd__and4bb_1 A_N B_N C D VGND VNB VPB VPWR X
.ends

* Black-box entry subcircuit for sky130_fd_sc_hd__or4_4 abstract view
.subckt sky130_fd_sc_hd__or4_4 A B C D VGND VNB VPB VPWR X
.ends

* Black-box entry subcircuit for sky130_fd_sc_hd__clkinv_8 abstract view
.subckt sky130_fd_sc_hd__clkinv_8 A VGND VNB VPB VPWR Y
.ends

* Black-box entry subcircuit for sky130_fd_sc_hd__or4b_1 abstract view
.subckt sky130_fd_sc_hd__or4b_1 A B C D_N VGND VNB VPB VPWR X
.ends

* Black-box entry subcircuit for sky130_fd_sc_hd__nand4b_1 abstract view
.subckt sky130_fd_sc_hd__nand4b_1 A_N B C D VGND VNB VPB VPWR Y
.ends

* Black-box entry subcircuit for sky130_fd_sc_hd__buf_4 abstract view
.subckt sky130_fd_sc_hd__buf_4 A VGND VNB VPB VPWR X
.ends

* Black-box entry subcircuit for sky130_fd_sc_hd__a2bb2o_4 abstract view
.subckt sky130_fd_sc_hd__a2bb2o_4 A1_N A2_N B1 B2 VGND VNB VPB VPWR X
.ends

* Black-box entry subcircuit for sky130_fd_sc_hd__a2bb2o_1 abstract view
.subckt sky130_fd_sc_hd__a2bb2o_1 A1_N A2_N B1 B2 VGND VNB VPB VPWR X
.ends

* Black-box entry subcircuit for sky130_fd_sc_hd__o2bb2a_1 abstract view
.subckt sky130_fd_sc_hd__o2bb2a_1 A1_N A2_N B1 B2 VGND VNB VPB VPWR X
.ends

* Black-box entry subcircuit for sky130_fd_sc_hd__nor4_4 abstract view
.subckt sky130_fd_sc_hd__nor4_4 A B C D VGND VNB VPB VPWR Y
.ends

* Black-box entry subcircuit for sky130_fd_sc_hd__bufinv_16 abstract view
.subckt sky130_fd_sc_hd__bufinv_16 A VGND VNB VPB VPWR Y
.ends

* Black-box entry subcircuit for sky130_fd_sc_hd__a2111o_1 abstract view
.subckt sky130_fd_sc_hd__a2111o_1 A1 A2 B1 C1 D1 VGND VNB VPB VPWR X
.ends

* Black-box entry subcircuit for sky130_fd_sc_hd__nand2b_4 abstract view
.subckt sky130_fd_sc_hd__nand2b_4 A_N B VGND VNB VPB VPWR Y
.ends

* Black-box entry subcircuit for sky130_fd_sc_hd__inv_12 abstract view
.subckt sky130_fd_sc_hd__inv_12 A VGND VNB VPB VPWR Y
.ends

* Black-box entry subcircuit for sky130_fd_sc_hd__nor3_1 abstract view
.subckt sky130_fd_sc_hd__nor3_1 A B C VGND VNB VPB VPWR Y
.ends

* Black-box entry subcircuit for sky130_fd_sc_hd__xnor2_2 abstract view
.subckt sky130_fd_sc_hd__xnor2_2 A B VGND VNB VPB VPWR Y
.ends

* Black-box entry subcircuit for sky130_fd_sc_hd__or3b_1 abstract view
.subckt sky130_fd_sc_hd__or3b_1 A B C_N VGND VNB VPB VPWR X
.ends

* Black-box entry subcircuit for sky130_fd_sc_hd__a31oi_1 abstract view
.subckt sky130_fd_sc_hd__a31oi_1 A1 A2 A3 B1 VGND VNB VPB VPWR Y
.ends

* Black-box entry subcircuit for sky130_fd_sc_hd__buf_8 abstract view
.subckt sky130_fd_sc_hd__buf_8 A VGND VNB VPB VPWR X
.ends

* Black-box entry subcircuit for sky130_fd_sc_hd__nand2_2 abstract view
.subckt sky130_fd_sc_hd__nand2_2 A B VGND VNB VPB VPWR Y
.ends

* Black-box entry subcircuit for sky130_fd_sc_hd__nand2b_1 abstract view
.subckt sky130_fd_sc_hd__nand2b_1 A_N B VGND VNB VPB VPWR Y
.ends

* Black-box entry subcircuit for sky130_fd_sc_hd__a21bo_4 abstract view
.subckt sky130_fd_sc_hd__a21bo_4 A1 A2 B1_N VGND VNB VPB VPWR X
.ends

* Black-box entry subcircuit for sky130_fd_sc_hd__a311oi_4 abstract view
.subckt sky130_fd_sc_hd__a311oi_4 A1 A2 A3 B1 C1 VGND VNB VPB VPWR Y
.ends

* Black-box entry subcircuit for sky130_fd_sc_hd__a21boi_2 abstract view
.subckt sky130_fd_sc_hd__a21boi_2 A1 A2 B1_N VGND VNB VPB VPWR Y
.ends

* Black-box entry subcircuit for sky130_fd_sc_hd__clkbuf_16 abstract view
.subckt sky130_fd_sc_hd__clkbuf_16 A VGND VNB VPB VPWR X
.ends

* Black-box entry subcircuit for sky130_fd_sc_hd__a22o_4 abstract view
.subckt sky130_fd_sc_hd__a22o_4 A1 A2 B1 B2 VGND VNB VPB VPWR X
.ends

* Black-box entry subcircuit for sky130_fd_sc_hd__o21a_2 abstract view
.subckt sky130_fd_sc_hd__o21a_2 A1 A2 B1 VGND VNB VPB VPWR X
.ends

* Black-box entry subcircuit for sky130_fd_sc_hd__o32a_1 abstract view
.subckt sky130_fd_sc_hd__o32a_1 A1 A2 A3 B1 B2 VGND VNB VPB VPWR X
.ends

* Black-box entry subcircuit for sky130_fd_sc_hd__clkinv_2 abstract view
.subckt sky130_fd_sc_hd__clkinv_2 A VGND VNB VPB VPWR Y
.ends

* Black-box entry subcircuit for sky130_fd_sc_hd__nand3b_1 abstract view
.subckt sky130_fd_sc_hd__nand3b_1 A_N B C VGND VNB VPB VPWR Y
.ends

* Black-box entry subcircuit for sky130_fd_sc_hd__o22a_2 abstract view
.subckt sky130_fd_sc_hd__o22a_2 A1 A2 B1 B2 VGND VNB VPB VPWR X
.ends

* Black-box entry subcircuit for sky130_fd_sc_hd__inv_4 abstract view
.subckt sky130_fd_sc_hd__inv_4 A VGND VNB VPB VPWR Y
.ends

* Black-box entry subcircuit for sky130_fd_sc_hd__a211o_2 abstract view
.subckt sky130_fd_sc_hd__a211o_2 A1 A2 B1 C1 VGND VNB VPB VPWR X
.ends

* Black-box entry subcircuit for sky130_fd_sc_hd__nand2_4 abstract view
.subckt sky130_fd_sc_hd__nand2_4 A B VGND VNB VPB VPWR Y
.ends

* Black-box entry subcircuit for sky130_fd_sc_hd__or3_2 abstract view
.subckt sky130_fd_sc_hd__or3_2 A B C VGND VNB VPB VPWR X
.ends

* Black-box entry subcircuit for sky130_fd_sc_hd__clkinv_1 abstract view
.subckt sky130_fd_sc_hd__clkinv_1 A VGND VNB VPB VPWR Y
.ends

* Black-box entry subcircuit for sky130_fd_sc_hd__buf_1 abstract view
.subckt sky130_fd_sc_hd__buf_1 A VGND VNB VPB VPWR X
.ends

* Black-box entry subcircuit for sky130_fd_sc_hd__o31ai_1 abstract view
.subckt sky130_fd_sc_hd__o31ai_1 A1 A2 A3 B1 VGND VNB VPB VPWR Y
.ends

* Black-box entry subcircuit for sky130_fd_sc_hd__clkbuf_2 abstract view
.subckt sky130_fd_sc_hd__clkbuf_2 A VGND VNB VPB VPWR X
.ends

* Black-box entry subcircuit for sky130_fd_sc_hd__nand3_4 abstract view
.subckt sky130_fd_sc_hd__nand3_4 A B C VGND VNB VPB VPWR Y
.ends

* Black-box entry subcircuit for sky130_fd_sc_hd__nand3b_4 abstract view
.subckt sky130_fd_sc_hd__nand3b_4 A_N B C VGND VNB VPB VPWR Y
.ends

* Black-box entry subcircuit for sky130_fd_sc_hd__a211o_4 abstract view
.subckt sky130_fd_sc_hd__a211o_4 A1 A2 B1 C1 VGND VNB VPB VPWR X
.ends

* Black-box entry subcircuit for sky130_fd_sc_hd__nand3_2 abstract view
.subckt sky130_fd_sc_hd__nand3_2 A B C VGND VNB VPB VPWR Y
.ends

* Black-box entry subcircuit for sky130_fd_sc_hd__and3_2 abstract view
.subckt sky130_fd_sc_hd__and3_2 A B C VGND VNB VPB VPWR X
.ends

* Black-box entry subcircuit for sky130_fd_sc_hd__or3_4 abstract view
.subckt sky130_fd_sc_hd__or3_4 A B C VGND VNB VPB VPWR X
.ends

* Black-box entry subcircuit for sky130_fd_sc_hd__o211a_2 abstract view
.subckt sky130_fd_sc_hd__o211a_2 A1 A2 B1 C1 VGND VNB VPB VPWR X
.ends

* Black-box entry subcircuit for sky130_fd_sc_hd__nand4_1 abstract view
.subckt sky130_fd_sc_hd__nand4_1 A B C D VGND VNB VPB VPWR Y
.ends

* Black-box entry subcircuit for sky130_fd_sc_hd__or4bb_4 abstract view
.subckt sky130_fd_sc_hd__or4bb_4 A B C_N D_N VGND VNB VPB VPWR X
.ends

* Black-box entry subcircuit for sky130_fd_sc_hd__o311ai_4 abstract view
.subckt sky130_fd_sc_hd__o311ai_4 A1 A2 A3 B1 C1 VGND VNB VPB VPWR Y
.ends

* Black-box entry subcircuit for sky130_fd_sc_hd__o2111a_1 abstract view
.subckt sky130_fd_sc_hd__o2111a_1 A1 A2 B1 C1 D1 VGND VNB VPB VPWR X
.ends

* Black-box entry subcircuit for sky130_fd_sc_hd__o21a_4 abstract view
.subckt sky130_fd_sc_hd__o21a_4 A1 A2 B1 VGND VNB VPB VPWR X
.ends

* Black-box entry subcircuit for sky130_fd_sc_hd__a21o_2 abstract view
.subckt sky130_fd_sc_hd__a21o_2 A1 A2 B1 VGND VNB VPB VPWR X
.ends

* Black-box entry subcircuit for sky130_fd_sc_hd__o31ai_2 abstract view
.subckt sky130_fd_sc_hd__o31ai_2 A1 A2 A3 B1 VGND VNB VPB VPWR Y
.ends

* Black-box entry subcircuit for sky130_fd_sc_hd__nand2b_2 abstract view
.subckt sky130_fd_sc_hd__nand2b_2 A_N B VGND VNB VPB VPWR Y
.ends

* Black-box entry subcircuit for sky130_fd_sc_hd__and3b_4 abstract view
.subckt sky130_fd_sc_hd__and3b_4 A_N B C VGND VNB VPB VPWR X
.ends

* Black-box entry subcircuit for sky130_fd_sc_hd__and4b_2 abstract view
.subckt sky130_fd_sc_hd__and4b_2 A_N B C D VGND VNB VPB VPWR X
.ends

* Black-box entry subcircuit for sky130_fd_sc_hd__and4_4 abstract view
.subckt sky130_fd_sc_hd__and4_4 A B C D VGND VNB VPB VPWR X
.ends

* Black-box entry subcircuit for sky130_fd_sc_hd__nor3b_1 abstract view
.subckt sky130_fd_sc_hd__nor3b_1 A B C_N VGND VNB VPB VPWR Y
.ends

* Black-box entry subcircuit for sky130_fd_sc_hd__a221oi_4 abstract view
.subckt sky130_fd_sc_hd__a221oi_4 A1 A2 B1 B2 C1 VGND VNB VPB VPWR Y
.ends

* Black-box entry subcircuit for sky130_fd_sc_hd__nor3_2 abstract view
.subckt sky130_fd_sc_hd__nor3_2 A B C VGND VNB VPB VPWR Y
.ends

* Black-box entry subcircuit for sky130_fd_sc_hd__mux2_4 abstract view
.subckt sky130_fd_sc_hd__mux2_4 A0 A1 S VGND VNB VPB VPWR X
.ends

* Black-box entry subcircuit for sky130_fd_sc_hd__o2111ai_4 abstract view
.subckt sky130_fd_sc_hd__o2111ai_4 A1 A2 B1 C1 D1 VGND VNB VPB VPWR Y
.ends

* Black-box entry subcircuit for sky130_fd_sc_hd__or4bb_1 abstract view
.subckt sky130_fd_sc_hd__or4bb_1 A B C_N D_N VGND VNB VPB VPWR X
.ends

* Black-box entry subcircuit for sky130_fd_sc_hd__a21boi_1 abstract view
.subckt sky130_fd_sc_hd__a21boi_1 A1 A2 B1_N VGND VNB VPB VPWR Y
.ends

* Black-box entry subcircuit for sky130_fd_sc_hd__a211oi_4 abstract view
.subckt sky130_fd_sc_hd__a211oi_4 A1 A2 B1 C1 VGND VNB VPB VPWR Y
.ends

* Black-box entry subcircuit for sky130_fd_sc_hd__a311o_4 abstract view
.subckt sky130_fd_sc_hd__a311o_4 A1 A2 A3 B1 C1 VGND VNB VPB VPWR X
.ends

* Black-box entry subcircuit for sky130_fd_sc_hd__o21ai_2 abstract view
.subckt sky130_fd_sc_hd__o21ai_2 A1 A2 B1 VGND VNB VPB VPWR Y
.ends

* Black-box entry subcircuit for sky130_fd_sc_hd__nor3b_4 abstract view
.subckt sky130_fd_sc_hd__nor3b_4 A B C_N VGND VNB VPB VPWR Y
.ends

* Black-box entry subcircuit for sky130_fd_sc_hd__or3b_4 abstract view
.subckt sky130_fd_sc_hd__or3b_4 A B C_N VGND VNB VPB VPWR X
.ends

* Black-box entry subcircuit for sky130_fd_sc_hd__and4_2 abstract view
.subckt sky130_fd_sc_hd__and4_2 A B C D VGND VNB VPB VPWR X
.ends

* Black-box entry subcircuit for sky130_fd_sc_hd__a21o_4 abstract view
.subckt sky130_fd_sc_hd__a21o_4 A1 A2 B1 VGND VNB VPB VPWR X
.ends

* Black-box entry subcircuit for sky130_fd_sc_hd__and2_2 abstract view
.subckt sky130_fd_sc_hd__and2_2 A B VGND VNB VPB VPWR X
.ends

* Black-box entry subcircuit for sky130_fd_sc_hd__or3b_2 abstract view
.subckt sky130_fd_sc_hd__or3b_2 A B C_N VGND VNB VPB VPWR X
.ends

* Black-box entry subcircuit for sky130_fd_sc_hd__xor2_4 abstract view
.subckt sky130_fd_sc_hd__xor2_4 A B VGND VNB VPB VPWR X
.ends

* Black-box entry subcircuit for sky130_fd_sc_hd__a21oi_4 abstract view
.subckt sky130_fd_sc_hd__a21oi_4 A1 A2 B1 VGND VNB VPB VPWR Y
.ends

* Black-box entry subcircuit for sky130_fd_sc_hd__nor4_1 abstract view
.subckt sky130_fd_sc_hd__nor4_1 A B C D VGND VNB VPB VPWR Y
.ends

.subckt picorv32 VGND VPWR clk eoi[0] eoi[10] eoi[11] eoi[12] eoi[13] eoi[14] eoi[15]
+ eoi[16] eoi[17] eoi[18] eoi[19] eoi[1] eoi[20] eoi[21] eoi[22] eoi[23] eoi[24] eoi[25]
+ eoi[26] eoi[27] eoi[28] eoi[29] eoi[2] eoi[30] eoi[31] eoi[3] eoi[4] eoi[5] eoi[6]
+ eoi[7] eoi[8] eoi[9] irq[0] irq[10] irq[11] irq[12] irq[13] irq[14] irq[15] irq[16]
+ irq[17] irq[18] irq[19] irq[1] irq[20] irq[21] irq[22] irq[23] irq[24] irq[25] irq[26]
+ irq[27] irq[28] irq[29] irq[2] irq[30] irq[31] irq[3] irq[4] irq[5] irq[6] irq[7]
+ irq[8] irq[9] mem_addr[0] mem_addr[10] mem_addr[11] mem_addr[12] mem_addr[13] mem_addr[14]
+ mem_addr[15] mem_addr[16] mem_addr[17] mem_addr[18] mem_addr[19] mem_addr[1] mem_addr[20]
+ mem_addr[21] mem_addr[22] mem_addr[23] mem_addr[24] mem_addr[25] mem_addr[26] mem_addr[27]
+ mem_addr[28] mem_addr[29] mem_addr[2] mem_addr[30] mem_addr[31] mem_addr[3] mem_addr[4]
+ mem_addr[5] mem_addr[6] mem_addr[7] mem_addr[8] mem_addr[9] mem_instr mem_la_addr[0]
+ mem_la_addr[10] mem_la_addr[11] mem_la_addr[12] mem_la_addr[13] mem_la_addr[14]
+ mem_la_addr[15] mem_la_addr[16] mem_la_addr[17] mem_la_addr[18] mem_la_addr[19]
+ mem_la_addr[1] mem_la_addr[20] mem_la_addr[21] mem_la_addr[22] mem_la_addr[23] mem_la_addr[24]
+ mem_la_addr[25] mem_la_addr[26] mem_la_addr[27] mem_la_addr[28] mem_la_addr[29]
+ mem_la_addr[2] mem_la_addr[30] mem_la_addr[31] mem_la_addr[3] mem_la_addr[4] mem_la_addr[5]
+ mem_la_addr[6] mem_la_addr[7] mem_la_addr[8] mem_la_addr[9] mem_la_read mem_la_wdata[0]
+ mem_la_wdata[10] mem_la_wdata[11] mem_la_wdata[12] mem_la_wdata[13] mem_la_wdata[14]
+ mem_la_wdata[15] mem_la_wdata[16] mem_la_wdata[17] mem_la_wdata[18] mem_la_wdata[19]
+ mem_la_wdata[1] mem_la_wdata[20] mem_la_wdata[21] mem_la_wdata[22] mem_la_wdata[23]
+ mem_la_wdata[24] mem_la_wdata[25] mem_la_wdata[26] mem_la_wdata[27] mem_la_wdata[28]
+ mem_la_wdata[29] mem_la_wdata[2] mem_la_wdata[30] mem_la_wdata[31] mem_la_wdata[3]
+ mem_la_wdata[4] mem_la_wdata[5] mem_la_wdata[6] mem_la_wdata[7] mem_la_wdata[8]
+ mem_la_wdata[9] mem_la_write mem_la_wstrb[0] mem_la_wstrb[1] mem_la_wstrb[2] mem_la_wstrb[3]
+ mem_rdata[0] mem_rdata[10] mem_rdata[11] mem_rdata[12] mem_rdata[13] mem_rdata[14]
+ mem_rdata[15] mem_rdata[16] mem_rdata[17] mem_rdata[18] mem_rdata[19] mem_rdata[1]
+ mem_rdata[20] mem_rdata[21] mem_rdata[22] mem_rdata[23] mem_rdata[24] mem_rdata[25]
+ mem_rdata[26] mem_rdata[27] mem_rdata[28] mem_rdata[29] mem_rdata[2] mem_rdata[30]
+ mem_rdata[31] mem_rdata[3] mem_rdata[4] mem_rdata[5] mem_rdata[6] mem_rdata[7] mem_rdata[8]
+ mem_rdata[9] mem_ready mem_valid mem_wdata[0] mem_wdata[10] mem_wdata[11] mem_wdata[12]
+ mem_wdata[13] mem_wdata[14] mem_wdata[15] mem_wdata[16] mem_wdata[17] mem_wdata[18]
+ mem_wdata[19] mem_wdata[1] mem_wdata[20] mem_wdata[21] mem_wdata[22] mem_wdata[23]
+ mem_wdata[24] mem_wdata[25] mem_wdata[26] mem_wdata[27] mem_wdata[28] mem_wdata[29]
+ mem_wdata[2] mem_wdata[30] mem_wdata[31] mem_wdata[3] mem_wdata[4] mem_wdata[5]
+ mem_wdata[6] mem_wdata[7] mem_wdata[8] mem_wdata[9] mem_wstrb[0] mem_wstrb[1] mem_wstrb[2]
+ mem_wstrb[3] pcpi_insn[0] pcpi_insn[10] pcpi_insn[11] pcpi_insn[12] pcpi_insn[13]
+ pcpi_insn[14] pcpi_insn[15] pcpi_insn[16] pcpi_insn[17] pcpi_insn[18] pcpi_insn[19]
+ pcpi_insn[1] pcpi_insn[20] pcpi_insn[21] pcpi_insn[22] pcpi_insn[23] pcpi_insn[24]
+ pcpi_insn[25] pcpi_insn[26] pcpi_insn[27] pcpi_insn[28] pcpi_insn[29] pcpi_insn[2]
+ pcpi_insn[30] pcpi_insn[31] pcpi_insn[3] pcpi_insn[4] pcpi_insn[5] pcpi_insn[6]
+ pcpi_insn[7] pcpi_insn[8] pcpi_insn[9] pcpi_rd[0] pcpi_rd[10] pcpi_rd[11] pcpi_rd[12]
+ pcpi_rd[13] pcpi_rd[14] pcpi_rd[15] pcpi_rd[16] pcpi_rd[17] pcpi_rd[18] pcpi_rd[19]
+ pcpi_rd[1] pcpi_rd[20] pcpi_rd[21] pcpi_rd[22] pcpi_rd[23] pcpi_rd[24] pcpi_rd[25]
+ pcpi_rd[26] pcpi_rd[27] pcpi_rd[28] pcpi_rd[29] pcpi_rd[2] pcpi_rd[30] pcpi_rd[31]
+ pcpi_rd[3] pcpi_rd[4] pcpi_rd[5] pcpi_rd[6] pcpi_rd[7] pcpi_rd[8] pcpi_rd[9] pcpi_ready
+ pcpi_rs1[0] pcpi_rs1[10] pcpi_rs1[11] pcpi_rs1[12] pcpi_rs1[13] pcpi_rs1[14] pcpi_rs1[15]
+ pcpi_rs1[16] pcpi_rs1[17] pcpi_rs1[18] pcpi_rs1[19] pcpi_rs1[1] pcpi_rs1[20] pcpi_rs1[21]
+ pcpi_rs1[22] pcpi_rs1[23] pcpi_rs1[24] pcpi_rs1[25] pcpi_rs1[26] pcpi_rs1[27] pcpi_rs1[28]
+ pcpi_rs1[29] pcpi_rs1[2] pcpi_rs1[30] pcpi_rs1[31] pcpi_rs1[3] pcpi_rs1[4] pcpi_rs1[5]
+ pcpi_rs1[6] pcpi_rs1[7] pcpi_rs1[8] pcpi_rs1[9] pcpi_rs2[0] pcpi_rs2[10] pcpi_rs2[11]
+ pcpi_rs2[12] pcpi_rs2[13] pcpi_rs2[14] pcpi_rs2[15] pcpi_rs2[16] pcpi_rs2[17] pcpi_rs2[18]
+ pcpi_rs2[19] pcpi_rs2[1] pcpi_rs2[20] pcpi_rs2[21] pcpi_rs2[22] pcpi_rs2[23] pcpi_rs2[24]
+ pcpi_rs2[25] pcpi_rs2[26] pcpi_rs2[27] pcpi_rs2[28] pcpi_rs2[29] pcpi_rs2[2] pcpi_rs2[30]
+ pcpi_rs2[31] pcpi_rs2[3] pcpi_rs2[4] pcpi_rs2[5] pcpi_rs2[6] pcpi_rs2[7] pcpi_rs2[8]
+ pcpi_rs2[9] pcpi_valid pcpi_wait pcpi_wr resetn trace_data[0] trace_data[10] trace_data[11]
+ trace_data[12] trace_data[13] trace_data[14] trace_data[15] trace_data[16] trace_data[17]
+ trace_data[18] trace_data[19] trace_data[1] trace_data[20] trace_data[21] trace_data[22]
+ trace_data[23] trace_data[24] trace_data[25] trace_data[26] trace_data[27] trace_data[28]
+ trace_data[29] trace_data[2] trace_data[30] trace_data[31] trace_data[32] trace_data[33]
+ trace_data[34] trace_data[35] trace_data[3] trace_data[4] trace_data[5] trace_data[6]
+ trace_data[7] trace_data[8] trace_data[9] trace_valid trap
X_05903_ _02073_ _02240_ _02237_ VGND VGND VPWR VPWR _02457_ sky130_fd_sc_hd__a21oi_1
XFILLER_79_391 VGND VGND VPWR VPWR sky130_fd_sc_hd__fill_1
XFILLER_39_222 VGND VGND VPWR VPWR sky130_fd_sc_hd__fill_2
XTAP_TAPCELL_ROW_124_2311 VGND VPWR sky130_fd_sc_hd__tapvpwrvgnd_1
X_06883_ _03271_ _03297_ VGND VGND VPWR VPWR _03300_ sky130_fd_sc_hd__nor2_1
XFILLER_95_895 VGND VGND VPWR VPWR sky130_fd_sc_hd__fill_1
XFILLER_94_350 VGND VGND VPWR VPWR sky130_fd_sc_hd__decap_4
XFILLER_82_501 VGND VGND VPWR VPWR sky130_fd_sc_hd__decap_4
X_09671_ cpuregs\[4\]\[10\] _02624_ net238 VGND VGND VPWR VPWR _01328_ sky130_fd_sc_hd__mux2_1
XTAP_TAPCELL_ROW_124_2322 VGND VPWR sky130_fd_sc_hd__tapvpwrvgnd_1
X_05834_ net255 _02392_ _02393_ _02395_ VGND VGND VPWR VPWR alu_out\[21\] sky130_fd_sc_hd__a31o_1
XFILLER_27_439 VGND VGND VPWR VPWR sky130_fd_sc_hd__decap_8
XTAP_TAPCELL_ROW_38_935 VGND VPWR sky130_fd_sc_hd__tapvpwrvgnd_1
XTAP_TAPCELL_ROW_38_946 VGND VPWR sky130_fd_sc_hd__tapvpwrvgnd_1
X_08622_ net126 _01585_ _04315_ _04316_ VGND VGND VPWR VPWR _00813_ sky130_fd_sc_hd__o22a_1
XFILLER_82_556 VPWR VGND VPWR VGND sky130_ef_sc_hd__decap_12
X_05765_ _02151_ _02154_ _02150_ VGND VGND VPWR VPWR _02334_ sky130_fd_sc_hd__o21ba_1
X_08553_ _04252_ _04253_ _02526_ _04245_ VGND VGND VPWR VPWR _04254_ sky130_fd_sc_hd__a211o_1
X_07504_ cpuregs\[26\]\[22\] _02675_ _03568_ VGND VGND VPWR VPWR _00442_ sky130_fd_sc_hd__mux2_1
XFILLER_82_589 VPWR VGND VPWR VGND sky130_ef_sc_hd__decap_12
X_08484_ net68 net37 _04208_ VGND VGND VPWR VPWR _00782_ sky130_fd_sc_hd__mux2_1
X_07435_ cpuregs\[27\]\[19\] _02662_ _03566_ VGND VGND VPWR VPWR _00375_ sky130_fd_sc_hd__mux2_1
XFILLER_52_29 VPWR VGND VPWR VGND sky130_ef_sc_hd__decap_12
X_05696_ _02169_ _02273_ VGND VGND VPWR VPWR _02274_ sky130_fd_sc_hd__nor2_1
XTAP_TAPCELL_ROW_102_1963 VGND VPWR sky130_fd_sc_hd__tapvpwrvgnd_1
XFILLER_50_453 VGND VGND VPWR VPWR sky130_fd_sc_hd__fill_2
XFILLER_149_853 VPWR VGND VPWR VGND sky130_ef_sc_hd__decap_12
X_07366_ _02654_ cpuregs\[9\]\[17\] _03563_ VGND VGND VPWR VPWR _00309_ sky130_fd_sc_hd__mux2_1
XFILLER_149_897 VPWR VGND VPWR VGND sky130_ef_sc_hd__decap_12
X_09105_ mem_rdata_q\[14\] mem_rdata_q\[13\] _01557_ VGND VGND VPWR VPWR _04756_ sky130_fd_sc_hd__and3_1
X_07297_ cpuregs\[28\]\[15\] _02646_ net249 VGND VGND VPWR VPWR _00243_ sky130_fd_sc_hd__mux2_1
X_06317_ cpuregs\[12\]\[1\] cpuregs\[13\]\[1\] cpuregs\[14\]\[1\] cpuregs\[15\]\[1\]
+ net268 net262 VGND VGND VPWR VPWR _02754_ sky130_fd_sc_hd__mux4_1
X_06248_ _02691_ cpuregs\[11\]\[26\] _02582_ VGND VGND VPWR VPWR _00063_ sky130_fd_sc_hd__mux2_1
XTAP_TAPCELL_ROW_135_2484 VGND VPWR sky130_fd_sc_hd__tapvpwrvgnd_1
X_09036_ _01558_ _04704_ _01559_ VGND VGND VPWR VPWR _04708_ sky130_fd_sc_hd__o21a_1
XTAP_TAPCELL_ROW_135_2495 VGND VPWR sky130_fd_sc_hd__tapvpwrvgnd_1
XFILLER_151_539 VGND VGND VPWR VPWR sky130_fd_sc_hd__fill_2
XFILLER_123_219 VGND VGND VPWR VPWR sky130_fd_sc_hd__decap_4
XFILLER_89_111 VGND VGND VPWR VPWR sky130_fd_sc_hd__fill_1
X_06179_ reg_pc\[13\] reg_pc\[12\] _02629_ VGND VGND VPWR VPWR _02636_ sky130_fd_sc_hd__and3_1
XFILLER_2_516 VPWR VGND VPWR VGND sky130_ef_sc_hd__decap_12
XFILLER_132_753 VGND VGND VPWR VPWR sky130_fd_sc_hd__decap_3
XFILLER_117_55 VGND VGND VPWR VPWR sky130_fd_sc_hd__fill_1
XFILLER_104_477 VPWR VGND VPWR VGND sky130_ef_sc_hd__decap_12
XFILLER_104_466 VGND VGND VPWR VPWR sky130_fd_sc_hd__fill_1
XFILLER_77_317 VGND VGND VPWR VPWR sky130_fd_sc_hd__fill_1
X_09938_ clknet_leaf_118_clk _00031_ VGND VGND VPWR VPWR _00011_ sky130_fd_sc_hd__dfxtp_4
XFILLER_100_650 VPWR VGND VPWR VGND sky130_ef_sc_hd__decap_12
XFILLER_92_309 VPWR VGND VPWR VGND sky130_ef_sc_hd__decap_12
XFILLER_86_862 VGND VGND VPWR VPWR sky130_fd_sc_hd__decap_6
XFILLER_18_417 VGND VGND VPWR VPWR sky130_fd_sc_hd__decap_3
X_09869_ decoded_imm_j\[3\] _01117_ _02513_ VGND VGND VPWR VPWR _00910_ sky130_fd_sc_hd__mux2_1
XFILLER_100_694 VGND VGND VPWR VPWR sky130_fd_sc_hd__decap_6
XFILLER_93_36 VPWR VGND VPWR VGND sky130_ef_sc_hd__decap_12
XFILLER_45_225 VPWR VGND VPWR VGND sky130_ef_sc_hd__decap_12
XFILLER_46_748 VGND VGND VPWR VPWR sky130_fd_sc_hd__decap_8
XFILLER_93_69 VGND VGND VPWR VPWR sky130_fd_sc_hd__fill_1
XFILLER_26_41 VPWR VGND VPWR VGND sky130_ef_sc_hd__decap_12
XFILLER_14_634 VGND VGND VPWR VPWR sky130_fd_sc_hd__fill_1
XFILLER_26_96 VGND VGND VPWR VPWR sky130_fd_sc_hd__decap_8
XFILLER_13_166 VGND VGND VPWR VPWR sky130_fd_sc_hd__fill_2
X_10713_ clknet_leaf_126_clk _00810_ VGND VGND VPWR VPWR net123 sky130_fd_sc_hd__dfxtp_4
XFILLER_9_137 VGND VGND VPWR VPWR sky130_fd_sc_hd__decap_6
X_10644_ clknet_leaf_110_clk _04900_ VGND VGND VPWR VPWR reg_out\[2\] sky130_fd_sc_hd__dfxtp_1
XFILLER_127_514 VGND VGND VPWR VPWR sky130_fd_sc_hd__fill_2
XFILLER_127_503 VGND VGND VPWR VPWR sky130_fd_sc_hd__fill_1
X_10575_ clknet_leaf_59_clk _00705_ VGND VGND VPWR VPWR reg_next_pc\[30\] sky130_fd_sc_hd__dfxtp_1
XFILLER_6_811 VGND VGND VPWR VPWR sky130_fd_sc_hd__fill_1
Xrebuffer7 _03590_ VGND VGND VPWR VPWR net393 sky130_fd_sc_hd__dlygate4sd1_1
XTAP_TAPCELL_ROW_75_1531 VGND VPWR sky130_fd_sc_hd__tapvpwrvgnd_1
XFILLER_123_753 VGND VGND VPWR VPWR sky130_fd_sc_hd__fill_1
XFILLER_69_818 VGND VGND VPWR VPWR sky130_fd_sc_hd__fill_1
XFILLER_123_797 VPWR VGND VPWR VGND sky130_ef_sc_hd__decap_12
X_11127_ clknet_leaf_19_clk _01174_ VGND VGND VPWR VPWR cpuregs\[31\]\[16\] sky130_fd_sc_hd__dfxtp_1
XFILLER_110_458 VGND VGND VPWR VPWR sky130_fd_sc_hd__decap_6
XFILLER_1_593 VPWR VGND VPWR VGND sky130_ef_sc_hd__decap_12
XFILLER_95_169 VGND VGND VPWR VPWR sky130_fd_sc_hd__decap_4
X_11058_ clknet_leaf_111_clk _01115_ VGND VGND VPWR VPWR mem_rdata_q\[21\] sky130_fd_sc_hd__dfxtp_1
XTAP_TAPCELL_ROW_106_2030 VGND VPWR sky130_fd_sc_hd__tapvpwrvgnd_1
X_10009_ clknet_leaf_143_clk _00139_ VGND VGND VPWR VPWR cpuregs\[30\]\[7\] sky130_fd_sc_hd__dfxtp_1
XFILLER_92_876 VGND VGND VPWR VPWR sky130_fd_sc_hd__decap_4
XFILLER_91_331 VGND VGND VPWR VPWR sky130_fd_sc_hd__decap_4
XFILLER_64_556 VPWR VGND VPWR VGND sky130_ef_sc_hd__decap_12
XFILLER_64_589 VGND VGND VPWR VPWR sky130_fd_sc_hd__decap_8
X_05550_ _02131_ _02132_ VGND VGND VPWR VPWR _02133_ sky130_fd_sc_hd__nor2_2
XFILLER_17_461 VGND VGND VPWR VPWR sky130_fd_sc_hd__fill_2
XFILLER_17_472 VGND VGND VPWR VPWR sky130_fd_sc_hd__decap_4
XFILLER_32_442 VGND VGND VPWR VPWR sky130_fd_sc_hd__decap_8
XFILLER_44_280 VGND VGND VPWR VPWR sky130_fd_sc_hd__fill_1
XFILLER_149_105 VGND VGND VPWR VPWR sky130_fd_sc_hd__decap_6
X_05481_ net190 net222 VGND VGND VPWR VPWR _02064_ sky130_fd_sc_hd__nor2_1
XFILLER_149_149 VPWR VGND VPWR VGND sky130_ef_sc_hd__decap_12
X_07220_ cpuregs\[13\]\[4\] _02598_ net251 VGND VGND VPWR VPWR _00168_ sky130_fd_sc_hd__mux2_1
X_07151_ cpuregs\[12\]\[5\] _02603_ net253 VGND VGND VPWR VPWR _00105_ sky130_fd_sc_hd__mux2_1
XFILLER_146_867 VGND VGND VPWR VPWR sky130_fd_sc_hd__fill_1
XFILLER_9_682 VGND VGND VPWR VPWR sky130_fd_sc_hd__fill_1
X_06102_ cpuregs\[24\]\[4\] cpuregs\[25\]\[4\] cpuregs\[26\]\[4\] cpuregs\[27\]\[4\]
+ net278 net273 VGND VGND VPWR VPWR _02573_ sky130_fd_sc_hd__mux4_1
X_07082_ cpuregs\[0\]\[28\] cpuregs\[1\]\[28\] cpuregs\[2\]\[28\] cpuregs\[3\]\[28\]
+ net266 net261 VGND VGND VPWR VPWR _03492_ sky130_fd_sc_hd__mux4_1
XFILLER_145_399 VGND VGND VPWR VPWR sky130_fd_sc_hd__fill_1
X_06033_ mem_rdata_q\[16\] net8 _01609_ VGND VGND VPWR VPWR _01110_ sky130_fd_sc_hd__mux2_1
XFILLER_87_637 VGND VGND VPWR VPWR sky130_fd_sc_hd__fill_2
XFILLER_87_615 VGND VGND VPWR VPWR sky130_fd_sc_hd__fill_1
XFILLER_86_125 VGND VGND VPWR VPWR sky130_fd_sc_hd__fill_1
X_07984_ decoded_imm_j\[10\] _03697_ VGND VGND VPWR VPWR _03807_ sky130_fd_sc_hd__or2_1
X_09723_ _02704_ cpuregs\[5\]\[29\] _04872_ VGND VGND VPWR VPWR _01379_ sky130_fd_sc_hd__mux2_1
XFILLER_101_458 VGND VGND VPWR VPWR sky130_fd_sc_hd__decap_3
X_06935_ net190 net254 VGND VGND VPWR VPWR _03350_ sky130_fd_sc_hd__or2_1
XFILLER_68_873 VGND VGND VPWR VPWR sky130_fd_sc_hd__fill_1
XFILLER_55_501 VGND VGND VPWR VPWR sky130_fd_sc_hd__decap_3
X_06866_ cpuregs\[24\]\[20\] cpuregs\[25\]\[20\] cpuregs\[26\]\[20\] cpuregs\[27\]\[20\]
+ net267 _00013_ VGND VGND VPWR VPWR _03284_ sky130_fd_sc_hd__mux4_1
X_09654_ _02696_ cpuregs\[22\]\[27\] _04869_ VGND VGND VPWR VPWR _01313_ sky130_fd_sc_hd__mux2_1
XFILLER_67_372 VGND VGND VPWR VPWR sky130_fd_sc_hd__fill_1
XFILLER_27_225 VGND VGND VPWR VPWR sky130_fd_sc_hd__decap_4
X_05817_ _02364_ _02378_ _02379_ VGND VGND VPWR VPWR _02380_ sky130_fd_sc_hd__o21a_1
XFILLER_103_57 VPWR VGND VPWR VGND sky130_ef_sc_hd__decap_12
XFILLER_83_876 VGND VGND VPWR VPWR sky130_fd_sc_hd__decap_8
XTAP_TAPCELL_ROW_2_368 VGND VPWR sky130_fd_sc_hd__tapvpwrvgnd_1
XTAP_TAPCELL_ROW_2_357 VGND VPWR sky130_fd_sc_hd__tapvpwrvgnd_1
X_08605_ _01558_ _04299_ VGND VGND VPWR VPWR _04300_ sky130_fd_sc_hd__or2_1
X_09585_ cpuregs\[29\]\[24\] _02683_ _04867_ VGND VGND VPWR VPWR _01246_ sky130_fd_sc_hd__mux2_1
X_06797_ _03188_ _03213_ _03214_ _03216_ VGND VGND VPWR VPWR _03217_ sky130_fd_sc_hd__o31a_1
X_05748_ _02156_ _02318_ VGND VGND VPWR VPWR _02319_ sky130_fd_sc_hd__nand2_1
X_08536_ net97 _04237_ _01585_ VGND VGND VPWR VPWR _00806_ sky130_fd_sc_hd__mux2_1
X_08467_ reg_pc\[31\] _02751_ _04202_ _04203_ VGND VGND VPWR VPWR _04204_ sky130_fd_sc_hd__a22oi_1
X_05679_ _02166_ _02252_ _02165_ VGND VGND VPWR VPWR _02259_ sky130_fd_sc_hd__o21bai_1
XFILLER_11_615 VGND VGND VPWR VPWR sky130_fd_sc_hd__fill_1
XTAP_TAPCELL_ROW_42_1007 VGND VPWR sky130_fd_sc_hd__tapvpwrvgnd_1
XTAP_TAPCELL_ROW_137_2524 VGND VPWR sky130_fd_sc_hd__tapvpwrvgnd_1
X_08398_ count_cycle\[50\] _04144_ count_cycle\[51\] VGND VGND VPWR VPWR _04148_ sky130_fd_sc_hd__and3_1
XFILLER_11_648 VGND VGND VPWR VPWR sky130_fd_sc_hd__fill_1
X_07418_ cpuregs\[27\]\[2\] _02590_ _03566_ VGND VGND VPWR VPWR _00358_ sky130_fd_sc_hd__mux2_1
X_07349_ _02586_ cpuregs\[9\]\[0\] _03563_ VGND VGND VPWR VPWR _00292_ sky130_fd_sc_hd__mux2_1
XTAP_TAPCELL_ROW_21_665 VGND VPWR sky130_fd_sc_hd__tapvpwrvgnd_1
XTAP_TAPCELL_ROW_150_2735 VGND VPWR sky130_fd_sc_hd__tapvpwrvgnd_1
XTAP_TAPCELL_ROW_150_2724 VGND VPWR sky130_fd_sc_hd__tapvpwrvgnd_1
XFILLER_137_889 VGND VGND VPWR VPWR sky130_fd_sc_hd__decap_6
XFILLER_12_65 VPWR VGND VPWR VGND sky130_ef_sc_hd__decap_12
X_10360_ clknet_leaf_13_clk _00490_ VGND VGND VPWR VPWR cpuregs\[25\]\[6\] sky130_fd_sc_hd__dfxtp_1
XFILLER_152_837 VPWR VGND VPWR VGND sky130_ef_sc_hd__decap_12
XFILLER_128_65 VPWR VGND VPWR VGND sky130_ef_sc_hd__decap_12
X_09019_ _04682_ _04690_ _04691_ _01560_ _00010_ VGND VGND VPWR VPWR _04692_ sky130_fd_sc_hd__a221o_1
X_10291_ clknet_leaf_117_clk _00421_ VGND VGND VPWR VPWR cpuregs\[26\]\[1\] sky130_fd_sc_hd__dfxtp_1
XFILLER_105_753 VGND VGND VPWR VPWR sky130_fd_sc_hd__decap_3
XTAP_TAPCELL_ROW_57_1250 VGND VPWR sky130_fd_sc_hd__tapvpwrvgnd_1
XFILLER_120_701 VPWR VGND VPWR VGND sky130_ef_sc_hd__decap_12
XFILLER_105_775 VGND VGND VPWR VPWR sky130_fd_sc_hd__decap_8
XFILLER_104_241 VGND VGND VPWR VPWR sky130_fd_sc_hd__decap_8
XFILLER_78_626 VGND VGND VPWR VPWR sky130_fd_sc_hd__fill_1
XFILLER_144_53 VPWR VGND VPWR VGND sky130_ef_sc_hd__decap_12
XFILLER_77_125 VPWR VGND VPWR VGND sky130_ef_sc_hd__decap_12
XTAP_TAPCELL_ROW_70_1450 VGND VPWR sky130_fd_sc_hd__tapvpwrvgnd_1
XTAP_TAPCELL_ROW_148_2697 VGND VPWR sky130_fd_sc_hd__tapvpwrvgnd_1
XFILLER_77_169 VPWR VGND VPWR VGND sky130_ef_sc_hd__decap_12
XFILLER_92_139 VGND VGND VPWR VPWR sky130_fd_sc_hd__fill_1
XFILLER_37_51 VGND VGND VPWR VPWR sky130_fd_sc_hd__decap_4
XFILLER_46_556 VGND VGND VPWR VPWR sky130_fd_sc_hd__decap_4
XTAP_TAPCELL_ROW_29_798 VGND VPWR sky130_fd_sc_hd__tapvpwrvgnd_1
XFILLER_37_95 VGND VGND VPWR VPWR sky130_fd_sc_hd__decap_8
XFILLER_46_589 VGND VGND VPWR VPWR sky130_fd_sc_hd__fill_1
XFILLER_61_559 VGND VGND VPWR VPWR sky130_fd_sc_hd__fill_1
XFILLER_14_475 VGND VGND VPWR VPWR sky130_fd_sc_hd__fill_1
X_10627_ clknet_leaf_85_clk _00757_ VGND VGND VPWR VPWR count_cycle\[50\] sky130_fd_sc_hd__dfxtp_1
XFILLER_10_670 VPWR VGND VPWR VGND sky130_ef_sc_hd__decap_12
XTAP_TAPCELL_ROW_40_974 VGND VPWR sky130_fd_sc_hd__tapvpwrvgnd_1
Xpicorv32_306 VGND VGND VPWR VPWR picorv32_306/HI eoi[25] sky130_fd_sc_hd__conb_1
Xpicorv32_317 VGND VGND VPWR VPWR picorv32_317/HI pcpi_insn[0] sky130_fd_sc_hd__conb_1
XFILLER_128_867 VGND VGND VPWR VPWR sky130_fd_sc_hd__fill_1
X_10558_ clknet_leaf_96_clk _00688_ VGND VGND VPWR VPWR reg_next_pc\[13\] sky130_fd_sc_hd__dfxtp_1
Xpicorv32_328 VGND VGND VPWR VPWR picorv32_328/HI pcpi_insn[11] sky130_fd_sc_hd__conb_1
XFILLER_115_517 VGND VGND VPWR VPWR sky130_fd_sc_hd__decap_4
Xpicorv32_339 VGND VGND VPWR VPWR picorv32_339/HI pcpi_insn[22] sky130_fd_sc_hd__conb_1
XFILLER_142_369 VGND VGND VPWR VPWR sky130_fd_sc_hd__fill_1
X_10489_ clknet_leaf_107_clk _00619_ VGND VGND VPWR VPWR count_instr\[38\] sky130_fd_sc_hd__dfxtp_1
XFILLER_123_561 VGND VGND VPWR VPWR sky130_fd_sc_hd__decap_4
XFILLER_111_723 VGND VGND VPWR VPWR sky130_fd_sc_hd__decap_4
XFILLER_111_712 VGND VGND VPWR VPWR sky130_fd_sc_hd__fill_2
XFILLER_111_778 VGND VGND VPWR VPWR sky130_fd_sc_hd__decap_6
XFILLER_68_158 VGND VGND VPWR VPWR sky130_fd_sc_hd__fill_2
X_04981_ net33 net134 VGND VGND VPWR VPWR _01609_ sky130_fd_sc_hd__and2_4
XTAP_TAPCELL_ROW_88_1744 VGND VPWR sky130_fd_sc_hd__tapvpwrvgnd_1
XTAP_TAPCELL_ROW_88_1733 VGND VPWR sky130_fd_sc_hd__tapvpwrvgnd_1
X_06720_ _01579_ _03142_ VGND VGND VPWR VPWR _03143_ sky130_fd_sc_hd__or2_1
X_06651_ _03068_ _03069_ _01579_ VGND VGND VPWR VPWR _03077_ sky130_fd_sc_hd__mux2_1
XFILLER_18_781 VPWR VGND VPWR VGND sky130_ef_sc_hd__decap_12
XFILLER_25_729 VGND VGND VPWR VPWR sky130_fd_sc_hd__decap_4
XFILLER_37_578 VGND VGND VPWR VPWR sky130_fd_sc_hd__fill_1
X_05602_ net123 net197 VGND VGND VPWR VPWR _02185_ sky130_fd_sc_hd__and2b_1
X_06582_ _02979_ _03007_ _03008_ _01621_ VGND VGND VPWR VPWR _03010_ sky130_fd_sc_hd__a31o_1
X_09370_ decoded_imm\[11\] _04746_ _04846_ _04847_ VGND VGND VPWR VPWR _01019_ sky130_fd_sc_hd__o22a_1
XFILLER_52_559 VGND VGND VPWR VPWR sky130_fd_sc_hd__decap_4
X_08321_ _04098_ _04099_ VGND VGND VPWR VPWR _00729_ sky130_fd_sc_hd__nor2_1
X_05533_ net173 net205 VGND VGND VPWR VPWR _02116_ sky130_fd_sc_hd__nand2_1
X_08252_ decoded_imm_j\[20\] _03718_ _04046_ VGND VGND VPWR VPWR _04054_ sky130_fd_sc_hd__a21o_1
X_05464_ instr_bgeu instr_bge is_slti_blt_slt VGND VGND VPWR VPWR _02047_ sky130_fd_sc_hd__or3_1
XFILLER_20_401 VPWR VGND VPWR VGND sky130_ef_sc_hd__decap_12
XTAP_TAPCELL_ROW_119_2243 VGND VPWR sky130_fd_sc_hd__tapvpwrvgnd_1
XTAP_TAPCELL_ROW_119_2232 VGND VPWR sky130_fd_sc_hd__tapvpwrvgnd_1
X_07203_ cpuregs\[30\]\[21\] _02670_ _03556_ VGND VGND VPWR VPWR _00153_ sky130_fd_sc_hd__mux2_1
XFILLER_146_642 VGND VGND VPWR VPWR sky130_fd_sc_hd__fill_2
X_08183_ _03712_ _03978_ VGND VGND VPWR VPWR _03991_ sky130_fd_sc_hd__nor2_1
Xclkbuf_4_12_0_clk clknet_0_clk VGND VGND VPWR VPWR clknet_4_12_0_clk sky130_fd_sc_hd__clkbuf_8
X_05395_ _01970_ _01973_ _01982_ VGND VGND VPWR VPWR _01984_ sky130_fd_sc_hd__a21o_1
XFILLER_119_889 VGND VGND VPWR VPWR sky130_fd_sc_hd__decap_6
X_07134_ _03533_ _03534_ _03538_ _03539_ _01579_ _01581_ VGND VGND VPWR VPWR _03542_
+ sky130_fd_sc_hd__mux4_1
XFILLER_134_837 VPWR VGND VPWR VGND sky130_ef_sc_hd__decap_12
XTAP_TAPCELL_ROW_132_2443 VGND VPWR sky130_fd_sc_hd__tapvpwrvgnd_1
XFILLER_106_517 VGND VGND VPWR VPWR sky130_fd_sc_hd__fill_2
X_07065_ decoded_imm\[28\] net191 VGND VGND VPWR VPWR _03475_ sky130_fd_sc_hd__or2_1
Xoutput220 net220 VGND VGND VPWR VPWR pcpi_rs2[25] sky130_fd_sc_hd__buf_2
X_06016_ net194 _02511_ _01582_ VGND VGND VPWR VPWR net87 sky130_fd_sc_hd__mux2_1
Xoutput231 net231 VGND VGND VPWR VPWR pcpi_rs2[6] sky130_fd_sc_hd__buf_2
XFILLER_142_881 VPWR VGND VPWR VGND sky130_ef_sc_hd__decap_12
XTAP_TAPCELL_ROW_7_438 VGND VPWR sky130_fd_sc_hd__tapvpwrvgnd_1
XFILLER_141_391 VGND VGND VPWR VPWR sky130_fd_sc_hd__fill_1
XFILLER_102_745 VGND VGND VPWR VPWR sky130_fd_sc_hd__decap_4
XFILLER_87_445 VGND VGND VPWR VPWR sky130_fd_sc_hd__decap_3
XTAP_TAPCELL_ROW_7_449 VGND VPWR sky130_fd_sc_hd__tapvpwrvgnd_1
XFILLER_0_839 VGND VGND VPWR VPWR sky130_fd_sc_hd__fill_1
X_07967_ instr_jal _03791_ VGND VGND VPWR VPWR _03792_ sky130_fd_sc_hd__nand2_1
XFILLER_59_158 VGND VGND VPWR VPWR sky130_fd_sc_hd__decap_8
X_06918_ cpuregs\[4\]\[22\] cpuregs\[5\]\[22\] cpuregs\[6\]\[22\] cpuregs\[7\]\[22\]
+ net267 net261 VGND VGND VPWR VPWR _03334_ sky130_fd_sc_hd__mux4_1
XFILLER_87_489 VGND VGND VPWR VPWR sky130_fd_sc_hd__fill_1
XFILLER_74_117 VGND VGND VPWR VPWR sky130_fd_sc_hd__decap_3
XFILLER_74_106 VGND VGND VPWR VPWR sky130_fd_sc_hd__decap_3
XFILLER_56_810 VGND VGND VPWR VPWR sky130_fd_sc_hd__fill_2
X_09706_ _02633_ cpuregs\[5\]\[12\] _04872_ VGND VGND VPWR VPWR _01362_ sky130_fd_sc_hd__mux2_1
XFILLER_28_523 VGND VGND VPWR VPWR sky130_fd_sc_hd__decap_8
XFILLER_74_27 VGND VGND VPWR VPWR sky130_fd_sc_hd__fill_1
XFILLER_56_876 VGND VGND VPWR VPWR sky130_fd_sc_hd__decap_4
X_07898_ _03721_ _03727_ VGND VGND VPWR VPWR _03729_ sky130_fd_sc_hd__nand2_1
X_06849_ _03266_ VGND VGND VPWR VPWR _03267_ sky130_fd_sc_hd__inv_2
XFILLER_83_673 VGND VGND VPWR VPWR sky130_fd_sc_hd__decap_3
X_09637_ _02624_ cpuregs\[22\]\[10\] _04869_ VGND VGND VPWR VPWR _01296_ sky130_fd_sc_hd__mux2_1
XFILLER_28_589 VGND VGND VPWR VPWR sky130_fd_sc_hd__decap_3
XFILLER_82_194 VGND VGND VPWR VPWR sky130_fd_sc_hd__fill_2
X_09568_ cpuregs\[29\]\[7\] _02612_ net239 VGND VGND VPWR VPWR _01229_ sky130_fd_sc_hd__mux2_1
XTAP_TAPCELL_ROW_26_746 VGND VPWR sky130_fd_sc_hd__tapvpwrvgnd_1
XFILLER_43_559 VGND VGND VPWR VPWR sky130_fd_sc_hd__fill_1
X_08519_ _01558_ _04220_ VGND VGND VPWR VPWR _04221_ sky130_fd_sc_hd__or2_1
XFILLER_90_59 VGND VGND VPWR VPWR sky130_fd_sc_hd__fill_1
X_09499_ cpuregs\[31\]\[4\] _02598_ net240 VGND VGND VPWR VPWR _01162_ sky130_fd_sc_hd__mux2_1
XFILLER_135_3 VPWR VGND VPWR VGND sky130_ef_sc_hd__decap_12
XFILLER_128_119 VGND VGND VPWR VPWR sky130_fd_sc_hd__decap_8
XPHY_EDGE_ROW_137_Right_137 VGND VGND VPWR VPWR sky130_fd_sc_hd__decap_3
X_11461_ clknet_leaf_35_clk _01505_ VGND VGND VPWR VPWR cpuregs\[0\]\[27\] sky130_fd_sc_hd__dfxtp_1
X_10412_ clknet_leaf_45_clk _00542_ VGND VGND VPWR VPWR cpuregs\[20\]\[26\] sky130_fd_sc_hd__dfxtp_1
X_11392_ clknet_leaf_46_clk _01436_ VGND VGND VPWR VPWR cpuregs\[7\]\[22\] sky130_fd_sc_hd__dfxtp_1
XFILLER_136_141 VGND VGND VPWR VPWR sky130_fd_sc_hd__fill_2
XFILLER_152_612 VGND VGND VPWR VPWR sky130_fd_sc_hd__decap_4
XFILLER_151_111 VGND VGND VPWR VPWR sky130_fd_sc_hd__fill_1
X_10343_ clknet_leaf_75_clk _00473_ VGND VGND VPWR VPWR cpuregs\[16\]\[21\] sky130_fd_sc_hd__dfxtp_1
XFILLER_109_377 VGND VGND VPWR VPWR sky130_fd_sc_hd__decap_4
XFILLER_99_57 VPWR VGND VPWR VGND sky130_ef_sc_hd__decap_12
XFILLER_152_645 VGND VGND VPWR VPWR sky130_fd_sc_hd__decap_3
XTAP_TAPCELL_ROW_55_1209 VGND VPWR sky130_fd_sc_hd__tapvpwrvgnd_1
XFILLER_2_121 VPWR VGND VPWR VGND sky130_ef_sc_hd__decap_12
XFILLER_105_561 VGND VGND VPWR VPWR sky130_fd_sc_hd__decap_4
X_10274_ clknet_leaf_20_clk _00404_ VGND VGND VPWR VPWR cpuregs\[15\]\[16\] sky130_fd_sc_hd__dfxtp_1
XFILLER_2_165 VPWR VGND VPWR VGND sky130_ef_sc_hd__decap_12
XFILLER_38_309 VGND VGND VPWR VPWR sky130_fd_sc_hd__fill_2
XPHY_EDGE_ROW_100_Left_254 VGND VGND VPWR VPWR sky130_fd_sc_hd__decap_3
XFILLER_0_57 VPWR VGND VPWR VGND sky130_ef_sc_hd__decap_12
XFILLER_46_353 VGND VGND VPWR VPWR sky130_fd_sc_hd__fill_1
XFILLER_73_194 VPWR VGND VPWR VGND sky130_ef_sc_hd__decap_12
XFILLER_73_183 VGND VGND VPWR VPWR sky130_fd_sc_hd__fill_2
XTAP_TAPCELL_ROW_83_1663 VGND VPWR sky130_fd_sc_hd__tapvpwrvgnd_1
XTAP_TAPCELL_ROW_83_1652 VGND VPWR sky130_fd_sc_hd__tapvpwrvgnd_1
XFILLER_147_406 VGND VGND VPWR VPWR sky130_fd_sc_hd__fill_1
XFILLER_9_55 VGND VGND VPWR VPWR sky130_fd_sc_hd__fill_1
XPHY_EDGE_ROW_104_Right_104 VGND VGND VPWR VPWR sky130_fd_sc_hd__decap_3
XFILLER_30_798 VPWR VGND VPWR VGND sky130_ef_sc_hd__decap_12
XFILLER_127_141 VGND VGND VPWR VPWR sky130_fd_sc_hd__fill_1
X_05180_ count_instr\[9\] instr_rdinstr count_cycle\[41\] instr_rdcycleh VGND VGND
+ VPWR VPWR _01786_ sky130_fd_sc_hd__a22o_1
XFILLER_127_163 VGND VGND VPWR VPWR sky130_fd_sc_hd__decap_4
XTAP_TAPCELL_ROW_114_2151 VGND VPWR sky130_fd_sc_hd__tapvpwrvgnd_1
XTAP_TAPCELL_ROW_114_2162 VGND VPWR sky130_fd_sc_hd__tapvpwrvgnd_1
XFILLER_143_689 VGND VGND VPWR VPWR sky130_fd_sc_hd__fill_2
XFILLER_124_881 VPWR VGND VPWR VGND sky130_ef_sc_hd__decap_12
XFILLER_130_339 VGND VGND VPWR VPWR sky130_fd_sc_hd__fill_1
XFILLER_123_391 VGND VGND VPWR VPWR sky130_fd_sc_hd__fill_1
X_08870_ cpuregs\[8\]\[21\] cpuregs\[9\]\[21\] cpuregs\[10\]\[21\] cpuregs\[11\]\[21\]
+ _00007_ net274 VGND VGND VPWR VPWR _04551_ sky130_fd_sc_hd__mux4_1
XFILLER_69_434 VPWR VGND VPWR VGND sky130_ef_sc_hd__decap_12
X_07821_ _03684_ _03685_ VGND VGND VPWR VPWR _00643_ sky130_fd_sc_hd__nor2_1
XFILLER_111_542 VGND VGND VPWR VPWR sky130_fd_sc_hd__fill_1
XFILLER_96_231 VGND VGND VPWR VPWR sky130_fd_sc_hd__fill_1
XFILLER_57_607 VGND VGND VPWR VPWR sky130_fd_sc_hd__decap_8
XFILLER_38_810 VGND VGND VPWR VPWR sky130_fd_sc_hd__fill_2
X_04964_ instr_lh instr_jalr instr_jal _01593_ VGND VGND VPWR VPWR _01594_ sky130_fd_sc_hd__or4_1
X_07752_ count_instr\[36\] _03639_ count_instr\[37\] VGND VGND VPWR VPWR _03642_ sky130_fd_sc_hd__a21o_1
X_06703_ _03122_ _03125_ _03126_ _01581_ _01580_ VGND VGND VPWR VPWR _03127_ sky130_fd_sc_hd__a221o_1
XFILLER_80_610 VGND VGND VPWR VPWR sky130_fd_sc_hd__fill_1
X_07683_ count_instr\[11\] net390 count_instr\[12\] VGND VGND VPWR VPWR _03598_ sky130_fd_sc_hd__a21o_1
XFILLER_64_161 VGND VGND VPWR VPWR sky130_fd_sc_hd__decap_6
XFILLER_38_898 VPWR VGND VPWR VGND sky130_ef_sc_hd__decap_12
X_09422_ _02691_ cpuregs\[18\]\[26\] _04862_ VGND VGND VPWR VPWR _01056_ sky130_fd_sc_hd__mux2_1
X_06634_ _03056_ _03057_ _03059_ _03033_ VGND VGND VPWR VPWR _03060_ sky130_fd_sc_hd__a211o_1
XFILLER_52_334 VGND VGND VPWR VPWR sky130_fd_sc_hd__decap_8
XFILLER_25_559 VGND VGND VPWR VPWR sky130_fd_sc_hd__fill_1
X_09353_ decoded_imm\[19\] _04746_ _04824_ _04838_ VGND VGND VPWR VPWR _01011_ sky130_fd_sc_hd__o22a_1
XTAP_TAPCELL_ROW_23_705 VGND VPWR sky130_fd_sc_hd__tapvpwrvgnd_1
X_08304_ _04083_ _04087_ VGND VGND VPWR VPWR _04088_ sky130_fd_sc_hd__and2_1
XFILLER_80_698 VGND VGND VPWR VPWR sky130_fd_sc_hd__fill_2
XFILLER_52_389 VPWR VGND VPWR VGND sky130_ef_sc_hd__decap_12
XFILLER_21_710 VGND VGND VPWR VPWR sky130_fd_sc_hd__decap_8
X_06565_ cpuregs\[12\]\[9\] cpuregs\[13\]\[9\] cpuregs\[14\]\[9\] cpuregs\[15\]\[9\]
+ net263 net259 VGND VGND VPWR VPWR _02994_ sky130_fd_sc_hd__mux4_1
X_05516_ net181 net213 VGND VGND VPWR VPWR _02099_ sky130_fd_sc_hd__nand2_1
X_09284_ net140 net102 _04206_ VGND VGND VPWR VPWR _00970_ sky130_fd_sc_hd__mux2_1
X_06496_ _02924_ _02926_ VGND VGND VPWR VPWR _02927_ sky130_fd_sc_hd__nand2_1
X_08235_ _01547_ reg_next_pc\[29\] _01645_ _03717_ VGND VGND VPWR VPWR _04039_ sky130_fd_sc_hd__a22o_1
X_05447_ net24 _01665_ _01856_ VGND VGND VPWR VPWR _02032_ sky130_fd_sc_hd__a21o_1
XFILLER_60_29 VPWR VGND VPWR VGND sky130_ef_sc_hd__decap_12
X_08166_ decoded_imm_j\[20\] _03710_ _03969_ VGND VGND VPWR VPWR _03975_ sky130_fd_sc_hd__a21bo_1
XFILLER_118_141 VPWR VGND VPWR VGND sky130_ef_sc_hd__decap_12
X_05378_ cpu_state\[3\] _01962_ _01968_ VGND VGND VPWR VPWR _04894_ sky130_fd_sc_hd__a21o_1
XFILLER_146_461 VGND VGND VPWR VPWR sky130_fd_sc_hd__decap_8
XFILLER_134_601 VGND VGND VPWR VPWR sky130_fd_sc_hd__fill_1
XFILLER_133_100 VPWR VGND VPWR VGND sky130_ef_sc_hd__decap_12
XFILLER_107_826 VGND VGND VPWR VPWR sky130_fd_sc_hd__decap_6
X_07117_ decoded_imm\[30\] net194 VGND VGND VPWR VPWR _03525_ sky130_fd_sc_hd__nand2_1
XFILLER_4_419 VGND VGND VPWR VPWR sky130_fd_sc_hd__fill_1
X_08097_ _03705_ _03902_ VGND VGND VPWR VPWR _03912_ sky130_fd_sc_hd__nand2_1
X_07048_ cpuregs\[20\]\[27\] cpuregs\[21\]\[27\] cpuregs\[22\]\[27\] cpuregs\[23\]\[27\]
+ net266 net261 VGND VGND VPWR VPWR _03459_ sky130_fd_sc_hd__mux4_1
Xclkload90 clknet_leaf_97_clk VGND VGND VPWR VPWR clkload90/X sky130_fd_sc_hd__clkbuf_4
XFILLER_102_531 VGND VGND VPWR VPWR sky130_fd_sc_hd__fill_1
XFILLER_88_732 VGND VGND VPWR VPWR sky130_fd_sc_hd__decap_3
XFILLER_0_625 VGND VGND VPWR VPWR sky130_fd_sc_hd__fill_1
XFILLER_125_55 VGND VGND VPWR VPWR sky130_fd_sc_hd__fill_1
XFILLER_88_754 VGND VGND VPWR VPWR sky130_fd_sc_hd__fill_2
XFILLER_85_15 VGND VGND VPWR VPWR sky130_fd_sc_hd__fill_2
XTAP_TAPCELL_ROW_50_1128 VGND VPWR sky130_fd_sc_hd__tapvpwrvgnd_1
XTAP_TAPCELL_ROW_145_2645 VGND VPWR sky130_fd_sc_hd__tapvpwrvgnd_1
X_08999_ net270 _04672_ VGND VGND VPWR VPWR _04673_ sky130_fd_sc_hd__or2_1
XFILLER_102_597 VGND VGND VPWR VPWR sky130_fd_sc_hd__decap_4
XFILLER_87_275 VGND VGND VPWR VPWR sky130_fd_sc_hd__decap_4
XTAP_TAPCELL_ROW_50_1139 VGND VPWR sky130_fd_sc_hd__tapvpwrvgnd_1
XTAP_TAPCELL_ROW_145_2656 VGND VPWR sky130_fd_sc_hd__tapvpwrvgnd_1
XFILLER_18_53 VPWR VGND VPWR VGND sky130_ef_sc_hd__decap_12
XFILLER_29_865 VPWR VGND VPWR VGND sky130_ef_sc_hd__decap_12
XFILLER_90_407 VPWR VGND VPWR VGND sky130_ef_sc_hd__decap_12
X_10961_ clknet_leaf_129_clk _01023_ VGND VGND VPWR VPWR decoded_imm\[7\] sky130_fd_sc_hd__dfxtp_2
XFILLER_16_526 VGND VGND VPWR VPWR sky130_fd_sc_hd__decap_6
XFILLER_18_97 VGND VGND VPWR VPWR sky130_fd_sc_hd__decap_6
X_10892_ clknet_leaf_113_clk _00954_ VGND VGND VPWR VPWR mem_state\[0\] sky130_fd_sc_hd__dfxtp_1
XTAP_TAPCELL_ROW_65_1371 VGND VPWR sky130_fd_sc_hd__tapvpwrvgnd_1
XFILLER_24_570 VPWR VGND VPWR VGND sky130_ef_sc_hd__decap_12
XFILLER_34_41 VPWR VGND VPWR VGND sky130_ef_sc_hd__decap_12
XFILLER_34_85 VGND VGND VPWR VPWR sky130_fd_sc_hd__decap_4
X_11444_ clknet_leaf_2_clk _01488_ VGND VGND VPWR VPWR cpuregs\[0\]\[10\] sky130_fd_sc_hd__dfxtp_1
XFILLER_7_279 VGND VGND VPWR VPWR sky130_fd_sc_hd__fill_1
X_11375_ clknet_leaf_145_clk _01419_ VGND VGND VPWR VPWR cpuregs\[7\]\[5\] sky130_fd_sc_hd__dfxtp_1
XFILLER_125_689 VGND VGND VPWR VPWR sky130_fd_sc_hd__decap_4
XFILLER_112_317 VGND VGND VPWR VPWR sky130_fd_sc_hd__fill_2
XFILLER_98_529 VGND VGND VPWR VPWR sky130_fd_sc_hd__decap_3
XFILLER_3_441 VGND VGND VPWR VPWR sky130_fd_sc_hd__decap_6
X_10326_ clknet_leaf_138_clk _00456_ VGND VGND VPWR VPWR cpuregs\[16\]\[4\] sky130_fd_sc_hd__dfxtp_1
XFILLER_112_339 VPWR VGND VPWR VGND sky130_ef_sc_hd__decap_12
X_10257_ clknet_leaf_16_clk _00387_ VGND VGND VPWR VPWR cpuregs\[27\]\[31\] sky130_fd_sc_hd__dfxtp_1
XFILLER_3_485 VGND VGND VPWR VPWR sky130_fd_sc_hd__fill_1
XFILLER_105_391 VGND VGND VPWR VPWR sky130_fd_sc_hd__fill_1
XFILLER_78_253 VGND VGND VPWR VPWR sky130_fd_sc_hd__decap_6
XFILLER_78_231 VPWR VGND VPWR VGND sky130_ef_sc_hd__decap_12
X_10188_ clknet_leaf_44_clk _00318_ VGND VGND VPWR VPWR cpuregs\[9\]\[26\] sky130_fd_sc_hd__dfxtp_1
XFILLER_121_895 VGND VGND VPWR VPWR sky130_fd_sc_hd__fill_1
XFILLER_39_629 VGND VGND VPWR VPWR sky130_fd_sc_hd__decap_4
XFILLER_93_223 VGND VGND VPWR VPWR sky130_fd_sc_hd__fill_1
XFILLER_81_407 VPWR VGND VPWR VGND sky130_ef_sc_hd__decap_12
XFILLER_19_353 VGND VGND VPWR VPWR sky130_fd_sc_hd__fill_1
XFILLER_62_632 VGND VGND VPWR VPWR sky130_fd_sc_hd__decap_4
XTAP_TAPCELL_ROW_17_598 VGND VPWR sky130_fd_sc_hd__tapvpwrvgnd_1
X_06350_ _01579_ _02781_ _02785_ _01581_ VGND VGND VPWR VPWR _02786_ sky130_fd_sc_hd__a211oi_1
X_05301_ reg_pc\[19\] decoded_imm\[19\] VGND VGND VPWR VPWR _01897_ sky130_fd_sc_hd__or2_1
X_06281_ instr_sra instr_srai VGND VGND VPWR VPWR _02719_ sky130_fd_sc_hd__or2_2
Xclkbuf_leaf_150_clk clknet_4_0_0_clk VGND VGND VPWR VPWR clknet_leaf_150_clk sky130_fd_sc_hd__clkbuf_8
X_08020_ instr_jal _03839_ VGND VGND VPWR VPWR _03840_ sky130_fd_sc_hd__nor2_1
X_05232_ _01831_ _01832_ _01833_ cpu_state\[3\] VGND VGND VPWR VPWR _01834_ sky130_fd_sc_hd__and4b_1
XFILLER_128_450 VGND VGND VPWR VPWR sky130_fd_sc_hd__decap_4
XTAP_TAPCELL_ROW_96_1865 VGND VPWR sky130_fd_sc_hd__tapvpwrvgnd_1
X_05163_ _01765_ _01768_ VGND VGND VPWR VPWR _01770_ sky130_fd_sc_hd__or2_1
XFILLER_7_780 VGND VGND VPWR VPWR sky130_fd_sc_hd__decap_4
X_09971_ clknet_leaf_112_clk _00101_ VGND VGND VPWR VPWR cpuregs\[12\]\[1\] sky130_fd_sc_hd__dfxtp_1
X_05094_ _01704_ _01705_ VGND VGND VPWR VPWR _01706_ sky130_fd_sc_hd__nand2_1
X_08922_ cpuregs\[4\]\[24\] cpuregs\[5\]\[24\] cpuregs\[6\]\[24\] cpuregs\[7\]\[24\]
+ net280 net274 VGND VGND VPWR VPWR _04600_ sky130_fd_sc_hd__mux4_1
X_08853_ _04529_ _04530_ _01558_ VGND VGND VPWR VPWR _04535_ sky130_fd_sc_hd__mux2_1
XTAP_TAPCELL_ROW_127_2364 VGND VPWR sky130_fd_sc_hd__tapvpwrvgnd_1
X_05996_ net183 _02501_ _01582_ VGND VGND VPWR VPWR net76 sky130_fd_sc_hd__mux2_1
X_07804_ count_instr\[56\] _03673_ net34 VGND VGND VPWR VPWR _03675_ sky130_fd_sc_hd__o21ai_1
X_08784_ _04467_ _04468_ _04469_ net269 _00010_ VGND VGND VPWR VPWR _04470_ sky130_fd_sc_hd__a221o_1
XFILLER_57_459 VGND VGND VPWR VPWR sky130_fd_sc_hd__decap_8
X_07735_ count_instr\[30\] net394 _03631_ VGND VGND VPWR VPWR _00611_ sky130_fd_sc_hd__o21a_1
X_04947_ _00015_ VGND VGND VPWR VPWR _01580_ sky130_fd_sc_hd__inv_16
XFILLER_26_813 VPWR VGND VPWR VGND sky130_ef_sc_hd__decap_12
XFILLER_38_673 VGND VGND VPWR VPWR sky130_fd_sc_hd__fill_1
XFILLER_25_323 VGND VGND VPWR VPWR sky130_fd_sc_hd__fill_2
XFILLER_25_334 VGND VGND VPWR VPWR sky130_fd_sc_hd__fill_2
XTAP_TAPCELL_ROW_140_2575 VGND VPWR sky130_fd_sc_hd__tapvpwrvgnd_1
XTAP_TAPCELL_ROW_140_2564 VGND VPWR sky130_fd_sc_hd__tapvpwrvgnd_1
X_07666_ count_instr\[5\] net399 _03587_ VGND VGND VPWR VPWR _00586_ sky130_fd_sc_hd__o21a_1
XFILLER_52_153 VPWR VGND VPWR VGND sky130_ef_sc_hd__decap_12
XFILLER_25_345 VGND VGND VPWR VPWR sky130_fd_sc_hd__decap_3
X_09405_ _02621_ cpuregs\[18\]\[9\] _04862_ VGND VGND VPWR VPWR _01039_ sky130_fd_sc_hd__mux2_1
XFILLER_111_57 VGND VGND VPWR VPWR sky130_fd_sc_hd__decap_4
X_07597_ cpuregs\[20\]\[14\] _02641_ net245 VGND VGND VPWR VPWR _00530_ sky130_fd_sc_hd__mux2_1
X_06617_ cpuregs\[24\]\[11\] cpuregs\[25\]\[11\] cpuregs\[26\]\[11\] cpuregs\[27\]\[11\]
+ net268 net259 VGND VGND VPWR VPWR _03044_ sky130_fd_sc_hd__mux4_1
XFILLER_41_827 VGND VGND VPWR VPWR sky130_fd_sc_hd__fill_1
X_09336_ mem_rdata_q\[27\] _01589_ VGND VGND VPWR VPWR _04830_ sky130_fd_sc_hd__and2_1
X_06548_ net236 _02962_ _02977_ _02949_ VGND VGND VPWR VPWR _00077_ sky130_fd_sc_hd__a31o_1
XFILLER_52_197 VGND VGND VPWR VPWR sky130_fd_sc_hd__decap_6
XTAP_TAPCELL_ROW_47_1090 VGND VPWR sky130_fd_sc_hd__tapvpwrvgnd_1
X_09267_ mem_state\[0\] _04806_ _04808_ _04809_ VGND VGND VPWR VPWR _00954_ sky130_fd_sc_hd__a22o_1
X_08218_ _04021_ _04022_ VGND VGND VPWR VPWR _04023_ sky130_fd_sc_hd__or2_1
Xclkbuf_leaf_141_clk clknet_4_2_0_clk VGND VGND VPWR VPWR clknet_leaf_141_clk sky130_fd_sc_hd__clkbuf_8
X_06479_ cpuregs\[24\]\[6\] cpuregs\[25\]\[6\] cpuregs\[26\]\[6\] cpuregs\[27\]\[6\]
+ net263 net259 VGND VGND VPWR VPWR _02911_ sky130_fd_sc_hd__mux4_1
XTAP_TAPCELL_ROW_60_1290 VGND VPWR sky130_fd_sc_hd__tapvpwrvgnd_1
XFILLER_5_706 VPWR VGND VPWR VGND sky130_ef_sc_hd__decap_12
X_09198_ decoded_rd\[1\] _01102_ _02513_ VGND VGND VPWR VPWR _00899_ sky130_fd_sc_hd__mux2_1
X_08149_ _03708_ _03933_ _03709_ VGND VGND VPWR VPWR _03960_ sky130_fd_sc_hd__a21oi_1
XFILLER_107_645 VPWR VGND VPWR VGND sky130_ef_sc_hd__decap_12
XFILLER_107_667 VGND VGND VPWR VPWR sky130_fd_sc_hd__decap_4
X_11160_ clknet_leaf_22_clk _01207_ VGND VGND VPWR VPWR cpuregs\[23\]\[17\] sky130_fd_sc_hd__dfxtp_1
XFILLER_20_65 VPWR VGND VPWR VGND sky130_ef_sc_hd__decap_12
XFILLER_136_65 VPWR VGND VPWR VGND sky130_ef_sc_hd__decap_12
X_11091_ clknet_leaf_49_clk _01148_ VGND VGND VPWR VPWR cpuregs\[24\]\[22\] sky130_fd_sc_hd__dfxtp_1
XFILLER_121_125 VPWR VGND VPWR VGND sky130_ef_sc_hd__decap_12
X_10111_ clknet_leaf_11_clk _00241_ VGND VGND VPWR VPWR cpuregs\[28\]\[13\] sky130_fd_sc_hd__dfxtp_1
X_10042_ clknet_leaf_13_clk _00172_ VGND VGND VPWR VPWR cpuregs\[13\]\[8\] sky130_fd_sc_hd__dfxtp_1
XFILLER_76_713 VPWR VGND VPWR VGND sky130_ef_sc_hd__decap_12
XFILLER_0_477 VGND VGND VPWR VPWR sky130_fd_sc_hd__fill_1
XFILLER_152_53 VPWR VGND VPWR VGND sky130_ef_sc_hd__decap_12
XFILLER_130_692 VGND VGND VPWR VPWR sky130_fd_sc_hd__decap_8
XFILLER_75_234 VGND VGND VPWR VPWR sky130_fd_sc_hd__decap_4
XFILLER_75_223 VGND VGND VPWR VPWR sky130_fd_sc_hd__fill_1
XFILLER_152_97 VPWR VGND VPWR VGND sky130_ef_sc_hd__decap_12
XFILLER_91_727 VGND VGND VPWR VPWR sky130_fd_sc_hd__fill_1
XTAP_TAPCELL_ROW_67_1400 VGND VPWR sky130_fd_sc_hd__tapvpwrvgnd_1
XFILLER_29_673 VGND VGND VPWR VPWR sky130_fd_sc_hd__decap_4
XTAP_TAPCELL_ROW_67_1411 VGND VPWR sky130_fd_sc_hd__tapvpwrvgnd_1
X_10944_ clknet_leaf_94_clk _01006_ VGND VGND VPWR VPWR decoded_imm\[24\] sky130_fd_sc_hd__dfxtp_2
XFILLER_71_440 VGND VGND VPWR VPWR sky130_fd_sc_hd__fill_2
X_10875_ clknet_leaf_71_clk _00937_ VGND VGND VPWR VPWR cpuregs\[1\]\[19\] sky130_fd_sc_hd__dfxtp_1
XTAP_TAPCELL_ROW_80_1611 VGND VPWR sky130_fd_sc_hd__tapvpwrvgnd_1
XFILLER_32_849 VPWR VGND VPWR VGND sky130_ef_sc_hd__decap_12
XFILLER_129_225 VGND VGND VPWR VPWR sky130_fd_sc_hd__decap_8
XTAP_TAPCELL_ROW_14_557 VGND VPWR sky130_fd_sc_hd__tapvpwrvgnd_1
Xclkbuf_leaf_132_clk clknet_4_9_0_clk VGND VGND VPWR VPWR clknet_leaf_132_clk sky130_fd_sc_hd__clkbuf_8
XFILLER_40_893 VPWR VGND VPWR VGND sky130_ef_sc_hd__decap_12
XFILLER_145_729 VPWR VGND VPWR VGND sky130_ef_sc_hd__decap_12
X_11427_ clknet_leaf_67_clk _01471_ VGND VGND VPWR VPWR cpuregs\[8\]\[25\] sky130_fd_sc_hd__dfxtp_1
XANTENNA_5 _02498_ VGND VGND VPWR VPWR sky130_fd_sc_hd__diode_2
XTAP_TAPCELL_ROW_78_1573 VGND VPWR sky130_fd_sc_hd__tapvpwrvgnd_1
X_11358_ clknet_leaf_76_clk _01402_ VGND VGND VPWR VPWR cpuregs\[6\]\[20\] sky130_fd_sc_hd__dfxtp_1
XTAP_TAPCELL_ROW_111_2110 VGND VPWR sky130_fd_sc_hd__tapvpwrvgnd_1
XFILLER_99_805 VGND VGND VPWR VPWR sky130_fd_sc_hd__fill_2
XTAP_TAPCELL_ROW_78_1584 VGND VPWR sky130_fd_sc_hd__tapvpwrvgnd_1
X_10309_ clknet_leaf_64_clk _00439_ VGND VGND VPWR VPWR cpuregs\[26\]\[19\] sky130_fd_sc_hd__dfxtp_1
XFILLER_125_486 VGND VGND VPWR VPWR sky130_fd_sc_hd__fill_2
X_11289_ clknet_leaf_42_clk _01336_ VGND VGND VPWR VPWR cpuregs\[4\]\[18\] sky130_fd_sc_hd__dfxtp_1
XTAP_TAPCELL_ROW_91_1784 VGND VPWR sky130_fd_sc_hd__tapvpwrvgnd_1
XFILLER_3_293 VPWR VGND VPWR VGND sky130_ef_sc_hd__decap_12
XFILLER_100_309 VPWR VGND VPWR VGND sky130_ef_sc_hd__decap_12
XTAP_TAPCELL_ROW_91_1795 VGND VPWR sky130_fd_sc_hd__tapvpwrvgnd_1
XFILLER_79_595 VGND VGND VPWR VPWR sky130_fd_sc_hd__decap_6
XFILLER_120_191 VGND VGND VPWR VPWR sky130_fd_sc_hd__decap_4
X_05850_ _02085_ _02408_ VGND VGND VPWR VPWR _02410_ sky130_fd_sc_hd__or2_1
XFILLER_13_3 VPWR VGND VPWR VGND sky130_ef_sc_hd__decap_12
XTAP_TAPCELL_ROW_109_2083 VGND VPWR sky130_fd_sc_hd__tapvpwrvgnd_1
XTAP_TAPCELL_ROW_109_2072 VGND VPWR sky130_fd_sc_hd__tapvpwrvgnd_1
Xrebuffer17 net402 VGND VGND VPWR VPWR net403 sky130_fd_sc_hd__dlymetal6s2s_1
Xrebuffer28 _03600_ VGND VGND VPWR VPWR net414 sky130_fd_sc_hd__dlygate4sd1_1
X_05781_ _02146_ _02149_ _02333_ _02347_ _02147_ VGND VGND VPWR VPWR _02348_ sky130_fd_sc_hd__a311o_1
Xrebuffer39 net426 VGND VGND VPWR VPWR net425 sky130_fd_sc_hd__dlygate4sd1_1
X_07520_ _02598_ cpuregs\[16\]\[4\] _03570_ VGND VGND VPWR VPWR _00456_ sky130_fd_sc_hd__mux2_1
XTAP_TAPCELL_ROW_122_2283 VGND VPWR sky130_fd_sc_hd__tapvpwrvgnd_1
X_07451_ cpuregs\[15\]\[2\] _02590_ _03567_ VGND VGND VPWR VPWR _00390_ sky130_fd_sc_hd__mux2_1
X_07382_ cpuregs\[14\]\[0\] _02586_ net247 VGND VGND VPWR VPWR _00324_ sky130_fd_sc_hd__mux2_1
XFILLER_34_197 VGND VGND VPWR VPWR sky130_fd_sc_hd__decap_6
XTAP_TAPCELL_ROW_33_855 VGND VPWR sky130_fd_sc_hd__tapvpwrvgnd_1
X_06402_ _02725_ _02836_ VGND VGND VPWR VPWR _02837_ sky130_fd_sc_hd__nor2_1
XFILLER_148_523 VGND VGND VPWR VPWR sky130_fd_sc_hd__decap_8
XTAP_TAPCELL_ROW_98_1905 VGND VPWR sky130_fd_sc_hd__tapvpwrvgnd_1
X_09121_ instr_lw _04747_ _04763_ is_lb_lh_lw_lbu_lhu VGND VGND VPWR VPWR _00856_
+ sky130_fd_sc_hd__a22o_1
XTAP_TAPCELL_ROW_33_866 VGND VPWR sky130_fd_sc_hd__tapvpwrvgnd_1
X_06333_ _02714_ _02763_ _02769_ _01622_ _02766_ VGND VGND VPWR VPWR _02770_ sky130_fd_sc_hd__a221o_1
Xclkbuf_leaf_123_clk clknet_4_8_0_clk VGND VGND VPWR VPWR clknet_leaf_123_clk sky130_fd_sc_hd__clkbuf_8
XFILLER_30_381 VPWR VGND VPWR VGND sky130_ef_sc_hd__decap_12
XFILLER_148_589 VPWR VGND VPWR VGND sky130_ef_sc_hd__decap_12
XFILLER_135_217 VGND VGND VPWR VPWR sky130_fd_sc_hd__decap_6
X_06264_ _02704_ cpuregs\[11\]\[29\] _02582_ VGND VGND VPWR VPWR _00066_ sky130_fd_sc_hd__mux2_1
X_09052_ _01558_ _04713_ net269 VGND VGND VPWR VPWR _04723_ sky130_fd_sc_hd__o21a_1
XFILLER_135_239 VGND VGND VPWR VPWR sky130_fd_sc_hd__fill_1
X_06195_ _02647_ _02648_ _02584_ VGND VGND VPWR VPWR _02649_ sky130_fd_sc_hd__mux2_8
X_08003_ _03697_ _03698_ _03796_ VGND VGND VPWR VPWR _03825_ sky130_fd_sc_hd__nand3_1
X_05215_ _01768_ _01781_ _01817_ VGND VGND VPWR VPWR _01818_ sky130_fd_sc_hd__or3_1
XFILLER_150_209 VPWR VGND VPWR VGND sky130_ef_sc_hd__decap_12
XFILLER_116_464 VPWR VGND VPWR VGND sky130_ef_sc_hd__decap_12
X_05146_ reg_pc\[7\] decoded_imm\[7\] VGND VGND VPWR VPWR _01754_ sky130_fd_sc_hd__and2_1
Xmax_cap252 _03556_ VGND VGND VPWR VPWR net252 sky130_fd_sc_hd__buf_12
Xmax_cap263 net264 VGND VGND VPWR VPWR net263 sky130_fd_sc_hd__buf_12
Xmax_cap274 _00008_ VGND VGND VPWR VPWR net274 sky130_fd_sc_hd__buf_12
XFILLER_131_434 VGND VGND VPWR VPWR sky130_fd_sc_hd__decap_4
X_09954_ clknet_leaf_58_clk _00084_ VGND VGND VPWR VPWR net177 sky130_fd_sc_hd__dfxtp_4
X_05077_ net2 net19 net606 VGND VGND VPWR VPWR _01690_ sky130_fd_sc_hd__mux2_1
X_08905_ cpuregs\[8\]\[23\] cpuregs\[9\]\[23\] cpuregs\[10\]\[23\] cpuregs\[11\]\[23\]
+ net276 net272 VGND VGND VPWR VPWR _04584_ sky130_fd_sc_hd__mux4_1
X_09885_ cpuregs\[0\]\[15\] VGND VGND VPWR VPWR _01493_ sky130_fd_sc_hd__clkbuf_1
X_08836_ _04514_ _04515_ net270 VGND VGND VPWR VPWR _04519_ sky130_fd_sc_hd__mux2_1
XFILLER_100_854 VGND VGND VPWR VPWR sky130_fd_sc_hd__fill_2
XFILLER_85_521 VPWR VGND VPWR VGND sky130_ef_sc_hd__decap_12
XTAP_TAPCELL_ROW_142_2604 VGND VPWR sky130_fd_sc_hd__tapvpwrvgnd_1
XFILLER_73_727 VGND VGND VPWR VPWR sky130_fd_sc_hd__fill_1
XFILLER_122_45 VGND VGND VPWR VPWR sky130_fd_sc_hd__decap_3
X_05979_ reg_out\[12\] reg_next_pc\[12\] net596 VGND VGND VPWR VPWR _02493_ sky130_fd_sc_hd__mux2_1
X_08767_ _04440_ _04441_ net270 VGND VGND VPWR VPWR _04454_ sky130_fd_sc_hd__mux2_1
XFILLER_72_215 VPWR VGND VPWR VGND sky130_ef_sc_hd__decap_12
XFILLER_38_470 VGND VGND VPWR VPWR sky130_fd_sc_hd__fill_1
X_07718_ count_instr\[24\] _03618_ net34 VGND VGND VPWR VPWR _03621_ sky130_fd_sc_hd__o21ai_1
XFILLER_82_27 VGND VGND VPWR VPWR sky130_fd_sc_hd__fill_1
XFILLER_72_248 VGND VGND VPWR VPWR sky130_fd_sc_hd__decap_4
X_08698_ net270 _04387_ VGND VGND VPWR VPWR _04388_ sky130_fd_sc_hd__or2_1
XFILLER_53_440 VGND VGND VPWR VPWR sky130_fd_sc_hd__decap_8
XFILLER_82_49 VGND VGND VPWR VPWR sky130_fd_sc_hd__decap_3
XFILLER_14_849 VPWR VGND VPWR VGND sky130_ef_sc_hd__decap_12
XFILLER_40_101 VPWR VGND VPWR VGND sky130_ef_sc_hd__decap_12
X_07649_ net388 net408 VGND VGND VPWR VPWR _03576_ sky130_fd_sc_hd__nand2_8
X_10660_ clknet_leaf_89_clk _04887_ VGND VGND VPWR VPWR reg_out\[18\] sky130_fd_sc_hd__dfxtp_1
XTAP_TAPCELL_ROW_62_1330 VGND VPWR sky130_fd_sc_hd__tapvpwrvgnd_1
XFILLER_13_337 VGND VGND VPWR VPWR sky130_fd_sc_hd__decap_8
XTAP_TAPCELL_ROW_45_1049 VGND VPWR sky130_fd_sc_hd__tapvpwrvgnd_1
XTAP_TAPCELL_ROW_11_505 VGND VPWR sky130_fd_sc_hd__tapvpwrvgnd_1
X_09319_ reg_sh\[0\] _02744_ _04818_ _01554_ _04817_ VGND VGND VPWR VPWR _00997_ sky130_fd_sc_hd__a221o_1
X_10591_ clknet_leaf_87_clk _00721_ VGND VGND VPWR VPWR count_cycle\[14\] sky130_fd_sc_hd__dfxtp_1
XFILLER_21_370 VGND VGND VPWR VPWR sky130_fd_sc_hd__fill_1
XFILLER_22_893 VGND VGND VPWR VPWR sky130_fd_sc_hd__decap_8
XFILLER_5_503 VGND VGND VPWR VPWR sky130_fd_sc_hd__fill_1
XTAP_TAPCELL_ROW_153_2799 VGND VPWR sky130_fd_sc_hd__tapvpwrvgnd_1
XTAP_TAPCELL_ROW_153_2788 VGND VPWR sky130_fd_sc_hd__tapvpwrvgnd_1
XTAP_TAPCELL_ROW_153_2777 VGND VPWR sky130_fd_sc_hd__tapvpwrvgnd_1
X_11212_ clknet_leaf_143_clk _01259_ VGND VGND VPWR VPWR cpuregs\[3\]\[5\] sky130_fd_sc_hd__dfxtp_1
XFILLER_107_497 VGND VGND VPWR VPWR sky130_fd_sc_hd__decap_6
Xoutput42 net42 VGND VGND VPWR VPWR mem_addr[17] sky130_fd_sc_hd__buf_2
Xoutput53 net53 VGND VGND VPWR VPWR mem_addr[28] sky130_fd_sc_hd__buf_2
XFILLER_122_456 VPWR VGND VPWR VGND sky130_ef_sc_hd__decap_12
Xoutput75 net75 VGND VGND VPWR VPWR mem_la_addr[19] sky130_fd_sc_hd__buf_2
Xoutput64 net64 VGND VGND VPWR VPWR mem_addr[9] sky130_fd_sc_hd__buf_2
XFILLER_1_753 VPWR VGND VPWR VGND sky130_ef_sc_hd__decap_12
X_11143_ clknet_leaf_119_clk _01190_ VGND VGND VPWR VPWR cpuregs\[23\]\[0\] sky130_fd_sc_hd__dfxtp_1
XFILLER_95_329 VGND VGND VPWR VPWR sky130_fd_sc_hd__decap_6
XTAP_TAPCELL_ROW_73_1492 VGND VPWR sky130_fd_sc_hd__tapvpwrvgnd_1
Xoutput97 net97 VGND VGND VPWR VPWR mem_la_wdata[0] sky130_fd_sc_hd__buf_2
Xoutput86 net86 VGND VGND VPWR VPWR mem_la_addr[2] sky130_fd_sc_hd__buf_2
X_11074_ clknet_leaf_141_clk _01131_ VGND VGND VPWR VPWR cpuregs\[24\]\[5\] sky130_fd_sc_hd__dfxtp_1
X_10025_ clknet_leaf_52_clk _00155_ VGND VGND VPWR VPWR cpuregs\[30\]\[23\] sky130_fd_sc_hd__dfxtp_1
XFILLER_1_797 VPWR VGND VPWR VGND sky130_ef_sc_hd__decap_12
XFILLER_76_598 VGND VGND VPWR VPWR sky130_fd_sc_hd__decap_3
XFILLER_63_237 VPWR VGND VPWR VGND sky130_ef_sc_hd__decap_12
XFILLER_56_83 VGND VGND VPWR VPWR sky130_fd_sc_hd__fill_1
XTAP_TAPCELL_ROW_19_638 VGND VPWR sky130_fd_sc_hd__tapvpwrvgnd_1
XFILLER_29_481 VGND VGND VPWR VPWR sky130_fd_sc_hd__fill_2
XFILLER_91_568 VPWR VGND VPWR VGND sky130_ef_sc_hd__decap_12
XFILLER_16_120 VPWR VGND VPWR VGND sky130_ef_sc_hd__decap_12
X_10927_ clknet_leaf_106_clk _00989_ VGND VGND VPWR VPWR net168 sky130_fd_sc_hd__dfxtp_1
XFILLER_32_613 VGND VGND VPWR VPWR sky130_fd_sc_hd__fill_1
XFILLER_149_309 VPWR VGND VPWR VGND sky130_ef_sc_hd__decap_12
XFILLER_71_281 VPWR VGND VPWR VGND sky130_ef_sc_hd__decap_12
XFILLER_16_197 VGND VGND VPWR VPWR sky130_fd_sc_hd__decap_4
X_10858_ clknet_leaf_120_clk _00920_ VGND VGND VPWR VPWR cpuregs\[1\]\[2\] sky130_fd_sc_hd__dfxtp_1
XTAP_TAPCELL_ROW_30_814 VGND VPWR sky130_fd_sc_hd__tapvpwrvgnd_1
XFILLER_31_167 VGND VGND VPWR VPWR sky130_fd_sc_hd__fill_1
Xclkbuf_leaf_105_clk clknet_4_11_0_clk VGND VGND VPWR VPWR clknet_leaf_105_clk sky130_fd_sc_hd__clkbuf_8
X_10789_ clknet_leaf_103_clk _00854_ VGND VGND VPWR VPWR instr_lb sky130_fd_sc_hd__dfxtp_1
XFILLER_9_853 VPWR VGND VPWR VGND sky130_ef_sc_hd__decap_12
XFILLER_31_189 VPWR VGND VPWR VGND sky130_ef_sc_hd__decap_12
XFILLER_9_897 VPWR VGND VPWR VGND sky130_ef_sc_hd__decap_12
XFILLER_8_363 VGND VGND VPWR VPWR sky130_fd_sc_hd__fill_1
X_05000_ _01547_ _01549_ VGND VGND VPWR VPWR _01628_ sky130_fd_sc_hd__nor2_8
XTAP_TAPCELL_ROW_93_1824 VGND VPWR sky130_fd_sc_hd__tapvpwrvgnd_1
XTAP_TAPCELL_ROW_93_1813 VGND VPWR sky130_fd_sc_hd__tapvpwrvgnd_1
XFILLER_113_423 VGND VGND VPWR VPWR sky130_fd_sc_hd__decap_3
XFILLER_113_445 VGND VGND VPWR VPWR sky130_fd_sc_hd__decap_3
XFILLER_140_275 VGND VGND VPWR VPWR sky130_fd_sc_hd__decap_8
XFILLER_140_253 VGND VGND VPWR VPWR sky130_fd_sc_hd__decap_4
X_06951_ _03361_ _03364_ _03365_ _00016_ _01580_ VGND VGND VPWR VPWR _03366_ sky130_fd_sc_hd__a221o_1
XFILLER_101_629 VGND VGND VPWR VPWR sky130_fd_sc_hd__decap_4
XFILLER_100_106 VGND VGND VPWR VPWR sky130_fd_sc_hd__fill_1
XFILLER_98_178 VGND VGND VPWR VPWR sky130_fd_sc_hd__decap_6
XFILLER_67_510 VPWR VGND VPWR VGND sky130_ef_sc_hd__decap_12
X_05902_ _02075_ _02455_ VGND VGND VPWR VPWR _02456_ sky130_fd_sc_hd__xnor2_1
XFILLER_95_841 VGND VGND VPWR VPWR sky130_fd_sc_hd__decap_8
X_09670_ cpuregs\[4\]\[9\] _02621_ net238 VGND VGND VPWR VPWR _01327_ sky130_fd_sc_hd__mux2_1
XFILLER_39_234 VGND VGND VPWR VPWR sky130_fd_sc_hd__decap_4
XTAP_TAPCELL_ROW_124_2312 VGND VPWR sky130_fd_sc_hd__tapvpwrvgnd_1
X_06882_ _03274_ _03297_ VGND VGND VPWR VPWR _03299_ sky130_fd_sc_hd__nor2_1
X_08621_ decoded_imm\[7\] _01654_ _01586_ VGND VGND VPWR VPWR _04316_ sky130_fd_sc_hd__a21o_1
XTAP_TAPCELL_ROW_124_2323 VGND VPWR sky130_fd_sc_hd__tapvpwrvgnd_1
X_05833_ _02096_ _02240_ _02394_ VGND VGND VPWR VPWR _02395_ sky130_fd_sc_hd__a21o_1
XFILLER_55_727 VGND VGND VPWR VPWR sky130_fd_sc_hd__fill_1
XTAP_TAPCELL_ROW_38_936 VGND VPWR sky130_fd_sc_hd__tapvpwrvgnd_1
XTAP_TAPCELL_ROW_38_947 VGND VPWR sky130_fd_sc_hd__tapvpwrvgnd_1
XFILLER_82_568 VGND VGND VPWR VPWR sky130_fd_sc_hd__decap_8
X_05764_ _02152_ _02156_ _02317_ VGND VGND VPWR VPWR _02333_ sky130_fd_sc_hd__and3_1
XFILLER_70_708 VGND VGND VPWR VPWR sky130_fd_sc_hd__decap_8
X_08552_ _01559_ _04248_ _01560_ VGND VGND VPWR VPWR _04253_ sky130_fd_sc_hd__a21oi_1
X_07503_ cpuregs\[26\]\[21\] _02670_ _03568_ VGND VGND VPWR VPWR _00441_ sky130_fd_sc_hd__mux2_1
X_08483_ net67 net36 _04208_ VGND VGND VPWR VPWR _00781_ sky130_fd_sc_hd__mux2_1
X_07434_ cpuregs\[27\]\[18\] _02657_ _03566_ VGND VGND VPWR VPWR _00374_ sky130_fd_sc_hd__mux2_1
XFILLER_50_421 VPWR VGND VPWR VGND sky130_ef_sc_hd__decap_12
XFILLER_22_134 VGND VGND VPWR VPWR sky130_fd_sc_hd__decap_6
X_05695_ _02168_ _02239_ _02237_ VGND VGND VPWR VPWR _02273_ sky130_fd_sc_hd__o21ba_1
XFILLER_149_821 VPWR VGND VPWR VGND sky130_ef_sc_hd__decap_12
XTAP_TAPCELL_ROW_102_1964 VGND VPWR sky130_fd_sc_hd__tapvpwrvgnd_1
XFILLER_10_307 VGND VGND VPWR VPWR sky130_fd_sc_hd__fill_1
XFILLER_149_865 VPWR VGND VPWR VGND sky130_ef_sc_hd__decap_12
X_07365_ _02649_ cpuregs\[9\]\[16\] _03563_ VGND VGND VPWR VPWR _00308_ sky130_fd_sc_hd__mux2_1
XFILLER_108_206 VPWR VGND VPWR VGND sky130_ef_sc_hd__decap_12
X_07296_ cpuregs\[28\]\[14\] _02641_ net249 VGND VGND VPWR VPWR _00242_ sky130_fd_sc_hd__mux2_1
X_09104_ instr_bge _04748_ _04750_ _04755_ VGND VGND VPWR VPWR _00850_ sky130_fd_sc_hd__a22o_1
X_06316_ cpuregs\[0\]\[1\] cpuregs\[1\]\[1\] cpuregs\[2\]\[1\] cpuregs\[3\]\[1\] net268
+ net262 VGND VGND VPWR VPWR _02753_ sky130_fd_sc_hd__mux4_1
X_06247_ _02689_ _02690_ _02584_ VGND VGND VPWR VPWR _02691_ sky130_fd_sc_hd__mux2_8
X_09035_ _04698_ _04699_ _04705_ _04706_ _01558_ _01559_ VGND VGND VPWR VPWR _04707_
+ sky130_fd_sc_hd__mux4_1
XTAP_TAPCELL_ROW_135_2496 VGND VPWR sky130_fd_sc_hd__tapvpwrvgnd_1
XTAP_TAPCELL_ROW_135_2485 VGND VPWR sky130_fd_sc_hd__tapvpwrvgnd_1
XFILLER_132_710 VGND VGND VPWR VPWR sky130_fd_sc_hd__decap_8
X_06178_ reg_pc\[12\] _02627_ reg_pc\[13\] VGND VGND VPWR VPWR _02635_ sky130_fd_sc_hd__a21oi_1
XFILLER_2_528 VGND VGND VPWR VPWR sky130_fd_sc_hd__decap_4
XFILLER_120_905 VGND VGND VPWR VPWR sky130_fd_sc_hd__decap_4
XFILLER_104_445 VGND VGND VPWR VPWR sky130_fd_sc_hd__fill_2
XFILLER_78_808 VGND VGND VPWR VPWR sky130_fd_sc_hd__decap_4
X_05129_ _01737_ _01738_ VGND VGND VPWR VPWR _01739_ sky130_fd_sc_hd__nand2_1
XFILLER_104_489 VPWR VGND VPWR VGND sky130_ef_sc_hd__decap_12
X_09937_ clknet_leaf_111_clk _00030_ VGND VGND VPWR VPWR _00010_ sky130_fd_sc_hd__dfxtp_4
XFILLER_86_841 VPWR VGND VPWR VGND sky130_ef_sc_hd__decap_12
XFILLER_133_55 VGND VGND VPWR VPWR sky130_fd_sc_hd__fill_1
XFILLER_100_662 VGND VGND VPWR VPWR sky130_fd_sc_hd__decap_4
XFILLER_85_362 VGND VGND VPWR VPWR sky130_fd_sc_hd__decap_8
X_09868_ decoded_imm_j\[2\] _01116_ _02513_ VGND VGND VPWR VPWR _00909_ sky130_fd_sc_hd__mux2_1
XFILLER_133_77 VGND VGND VPWR VPWR sky130_fd_sc_hd__fill_1
X_08819_ _04492_ _04501_ _04502_ _01560_ _00010_ VGND VGND VPWR VPWR _04503_ sky130_fd_sc_hd__a221o_1
XFILLER_93_48 VGND VGND VPWR VPWR sky130_fd_sc_hd__decap_8
XFILLER_73_513 VGND VGND VPWR VPWR sky130_fd_sc_hd__decap_3
XFILLER_58_587 VGND VGND VPWR VPWR sky130_fd_sc_hd__fill_1
X_09799_ _02607_ cpuregs\[8\]\[6\] _04875_ VGND VGND VPWR VPWR _01452_ sky130_fd_sc_hd__mux2_1
XFILLER_45_204 VPWR VGND VPWR VGND sky130_ef_sc_hd__decap_12
XFILLER_73_568 VGND VGND VPWR VPWR sky130_fd_sc_hd__decap_6
XFILLER_45_237 VPWR VGND VPWR VGND sky130_ef_sc_hd__decap_12
XFILLER_26_53 VPWR VGND VPWR VGND sky130_ef_sc_hd__decap_12
XFILLER_26_75 VGND VGND VPWR VPWR sky130_fd_sc_hd__decap_8
XFILLER_53_281 VGND VGND VPWR VPWR sky130_fd_sc_hd__decap_6
X_10712_ clknet_leaf_126_clk _00809_ VGND VGND VPWR VPWR net122 sky130_fd_sc_hd__dfxtp_4
XFILLER_9_105 VGND VGND VPWR VPWR sky130_fd_sc_hd__decap_6
XFILLER_42_41 VGND VGND VPWR VPWR sky130_fd_sc_hd__fill_2
X_10643_ clknet_leaf_128_clk _04889_ VGND VGND VPWR VPWR reg_out\[1\] sky130_fd_sc_hd__dfxtp_1
X_10574_ clknet_leaf_65_clk _00704_ VGND VGND VPWR VPWR reg_next_pc\[29\] sky130_fd_sc_hd__dfxtp_1
XFILLER_42_74 VGND VGND VPWR VPWR sky130_fd_sc_hd__fill_1
XFILLER_42_85 VGND VGND VPWR VPWR sky130_fd_sc_hd__decap_6
Xrebuffer8 _03629_ VGND VGND VPWR VPWR net394 sky130_fd_sc_hd__dlygate4sd1_1
XFILLER_6_867 VGND VGND VPWR VPWR sky130_fd_sc_hd__fill_1
XFILLER_107_250 VPWR VGND VPWR VGND sky130_ef_sc_hd__decap_12
XTAP_TAPCELL_ROW_75_1532 VGND VPWR sky130_fd_sc_hd__tapvpwrvgnd_1
X_11126_ clknet_leaf_15_clk _01173_ VGND VGND VPWR VPWR cpuregs\[31\]\[15\] sky130_fd_sc_hd__dfxtp_1
XFILLER_1_561 VGND VGND VPWR VPWR sky130_fd_sc_hd__decap_4
XFILLER_122_286 VGND VGND VPWR VPWR sky130_fd_sc_hd__fill_1
XFILLER_95_137 VPWR VGND VPWR VGND sky130_ef_sc_hd__decap_12
XFILLER_89_690 VPWR VGND VPWR VGND sky130_ef_sc_hd__decap_12
XFILLER_77_841 VGND VGND VPWR VPWR sky130_fd_sc_hd__decap_6
XFILLER_49_521 VGND VGND VPWR VPWR sky130_fd_sc_hd__decap_6
XFILLER_3_57 VPWR VGND VPWR VGND sky130_ef_sc_hd__decap_12
XFILLER_92_811 VGND VGND VPWR VPWR sky130_fd_sc_hd__fill_1
X_11057_ clknet_leaf_110_clk _01114_ VGND VGND VPWR VPWR mem_rdata_q\[20\] sky130_fd_sc_hd__dfxtp_1
XTAP_TAPCELL_ROW_106_2031 VGND VPWR sky130_fd_sc_hd__tapvpwrvgnd_1
XTAP_TAPCELL_ROW_106_2020 VGND VPWR sky130_fd_sc_hd__tapvpwrvgnd_1
X_10008_ clknet_leaf_2_clk _00138_ VGND VGND VPWR VPWR cpuregs\[30\]\[6\] sky130_fd_sc_hd__dfxtp_1
XFILLER_64_568 VGND VGND VPWR VPWR sky130_fd_sc_hd__decap_6
XFILLER_51_218 VGND VGND VPWR VPWR sky130_fd_sc_hd__decap_6
XFILLER_32_432 VGND VGND VPWR VPWR sky130_fd_sc_hd__fill_1
X_05480_ net190 net222 VGND VGND VPWR VPWR _02063_ sky130_fd_sc_hd__nand2_1
XFILLER_146_813 VPWR VGND VPWR VGND sky130_ef_sc_hd__decap_12
X_07150_ cpuregs\[12\]\[4\] _02598_ net253 VGND VGND VPWR VPWR _00104_ sky130_fd_sc_hd__mux2_1
X_07081_ cpuregs\[4\]\[28\] cpuregs\[5\]\[28\] cpuregs\[6\]\[28\] cpuregs\[7\]\[28\]
+ net266 net261 VGND VGND VPWR VPWR _03491_ sky130_fd_sc_hd__mux4_1
XFILLER_8_160 VPWR VGND VPWR VGND sky130_ef_sc_hd__decap_12
X_06101_ cpuregs\[28\]\[4\] cpuregs\[29\]\[4\] cpuregs\[30\]\[4\] cpuregs\[31\]\[4\]
+ net278 net273 VGND VGND VPWR VPWR _02572_ sky130_fd_sc_hd__mux4_1
XFILLER_114_710 VGND VGND VPWR VPWR sky130_fd_sc_hd__decap_6
X_06032_ decoded_imm_j\[15\] _01109_ _02513_ VGND VGND VPWR VPWR _00032_ sky130_fd_sc_hd__mux2_1
XFILLER_114_754 VGND VGND VPWR VPWR sky130_fd_sc_hd__fill_2
XFILLER_99_443 VGND VGND VPWR VPWR sky130_fd_sc_hd__decap_4
XFILLER_101_415 VGND VGND VPWR VPWR sky130_fd_sc_hd__fill_1
X_09722_ _02699_ cpuregs\[5\]\[28\] _04872_ VGND VGND VPWR VPWR _01378_ sky130_fd_sc_hd__mux2_1
X_07983_ decoded_imm_j\[10\] _03697_ VGND VGND VPWR VPWR _03806_ sky130_fd_sc_hd__nand2_1
X_06934_ _03319_ _03323_ _03346_ _03347_ VGND VGND VPWR VPWR _03349_ sky130_fd_sc_hd__a211o_1
X_09653_ _02691_ cpuregs\[22\]\[26\] _04869_ VGND VGND VPWR VPWR _01312_ sky130_fd_sc_hd__mux2_1
X_06865_ _01579_ _03282_ VGND VGND VPWR VPWR _03283_ sky130_fd_sc_hd__or2_1
X_09584_ cpuregs\[29\]\[23\] _02678_ _04867_ VGND VGND VPWR VPWR _01245_ sky130_fd_sc_hd__mux2_1
X_05816_ _02099_ _02104_ _02101_ VGND VGND VPWR VPWR _02379_ sky130_fd_sc_hd__a21o_1
XFILLER_94_192 VGND VGND VPWR VPWR sky130_fd_sc_hd__decap_4
XFILLER_82_343 VGND VGND VPWR VPWR sky130_fd_sc_hd__decap_8
XFILLER_82_321 VGND VGND VPWR VPWR sky130_fd_sc_hd__decap_6
X_08604_ cpuregs\[20\]\[7\] cpuregs\[21\]\[7\] cpuregs\[22\]\[7\] cpuregs\[23\]\[7\]
+ net279 _00008_ VGND VGND VPWR VPWR _04299_ sky130_fd_sc_hd__mux4_1
XTAP_TAPCELL_ROW_2_369 VGND VPWR sky130_fd_sc_hd__tapvpwrvgnd_1
XTAP_TAPCELL_ROW_2_358 VGND VPWR sky130_fd_sc_hd__tapvpwrvgnd_1
XPHY_EDGE_ROW_118_Right_118 VGND VGND VPWR VPWR sky130_fd_sc_hd__decap_3
XFILLER_103_69 VPWR VGND VPWR VGND sky130_ef_sc_hd__decap_12
X_06796_ _01621_ _03215_ VGND VGND VPWR VPWR _03216_ sky130_fd_sc_hd__nor2_1
XFILLER_82_365 VGND VGND VPWR VPWR sky130_fd_sc_hd__decap_8
X_08535_ decoded_imm\[0\] _04236_ _01653_ VGND VGND VPWR VPWR _04237_ sky130_fd_sc_hd__mux2_1
X_05747_ _02317_ _02312_ instr_sub VGND VGND VPWR VPWR _02318_ sky130_fd_sc_hd__mux2_1
XFILLER_35_281 VGND VGND VPWR VPWR sky130_fd_sc_hd__decap_8
XFILLER_36_793 VPWR VGND VPWR VGND sky130_ef_sc_hd__decap_12
X_08466_ _00016_ _04188_ _02735_ VGND VGND VPWR VPWR _04203_ sky130_fd_sc_hd__o21a_1
XTAP_TAPCELL_ROW_42_1008 VGND VPWR sky130_fd_sc_hd__tapvpwrvgnd_1
X_05678_ _02237_ _02257_ _02126_ VGND VGND VPWR VPWR _02258_ sky130_fd_sc_hd__o21a_1
XTAP_TAPCELL_ROW_137_2525 VGND VPWR sky130_fd_sc_hd__tapvpwrvgnd_1
X_08397_ count_cycle\[50\] _04144_ count_cycle\[51\] VGND VGND VPWR VPWR _04147_ sky130_fd_sc_hd__a21o_1
XFILLER_51_785 VGND VGND VPWR VPWR sky130_fd_sc_hd__decap_6
X_07417_ cpuregs\[27\]\[1\] _02588_ _03566_ VGND VGND VPWR VPWR _00357_ sky130_fd_sc_hd__mux2_1
XFILLER_10_159 VGND VGND VPWR VPWR sky130_fd_sc_hd__decap_6
X_07348_ _02579_ _03557_ VGND VGND VPWR VPWR _03563_ sky130_fd_sc_hd__or2_4
XFILLER_109_548 VGND VGND VPWR VPWR sky130_fd_sc_hd__fill_2
XTAP_TAPCELL_ROW_21_666 VGND VPWR sky130_fd_sc_hd__tapvpwrvgnd_1
XFILLER_152_805 VGND VGND VPWR VPWR sky130_fd_sc_hd__decap_6
XTAP_TAPCELL_ROW_150_2736 VGND VPWR sky130_fd_sc_hd__tapvpwrvgnd_1
XTAP_TAPCELL_ROW_150_2725 VGND VPWR sky130_fd_sc_hd__tapvpwrvgnd_1
X_07279_ cpuregs\[2\]\[30\] _02709_ net250 VGND VGND VPWR VPWR _00226_ sky130_fd_sc_hd__mux2_1
XFILLER_12_77 VGND VGND VPWR VPWR sky130_fd_sc_hd__decap_6
XFILLER_152_849 VPWR VGND VPWR VGND sky130_ef_sc_hd__decap_12
XFILLER_151_304 VPWR VGND VPWR VGND sky130_ef_sc_hd__decap_12
XFILLER_128_77 VGND VGND VPWR VPWR sky130_fd_sc_hd__decap_6
X_09018_ _04685_ _04686_ _01558_ VGND VGND VPWR VPWR _04691_ sky130_fd_sc_hd__mux2_1
XFILLER_88_15 VPWR VGND VPWR VGND sky130_ef_sc_hd__decap_12
X_10290_ clknet_leaf_118_clk _00420_ VGND VGND VPWR VPWR cpuregs\[26\]\[0\] sky130_fd_sc_hd__dfxtp_1
XTAP_TAPCELL_ROW_57_1251 VGND VPWR sky130_fd_sc_hd__tapvpwrvgnd_1
XTAP_TAPCELL_ROW_57_1240 VGND VPWR sky130_fd_sc_hd__tapvpwrvgnd_1
XFILLER_120_713 VPWR VGND VPWR VGND sky130_ef_sc_hd__decap_12
XFILLER_144_65 VPWR VGND VPWR VGND sky130_ef_sc_hd__decap_12
XFILLER_77_137 VPWR VGND VPWR VGND sky130_ef_sc_hd__decap_12
XTAP_TAPCELL_ROW_70_1451 VGND VPWR sky130_fd_sc_hd__tapvpwrvgnd_1
XTAP_TAPCELL_ROW_148_2698 VGND VPWR sky130_fd_sc_hd__tapvpwrvgnd_1
XFILLER_74_811 VGND VGND VPWR VPWR sky130_fd_sc_hd__fill_1
XTAP_TAPCELL_ROW_29_788 VGND VPWR sky130_fd_sc_hd__tapvpwrvgnd_1
XFILLER_14_421 VPWR VGND VPWR VGND sky130_ef_sc_hd__decap_12
XTAP_TAPCELL_ROW_29_799 VGND VPWR sky130_fd_sc_hd__tapvpwrvgnd_1
XFILLER_146_109 VGND VGND VPWR VPWR sky130_fd_sc_hd__fill_2
XFILLER_128_813 VPWR VGND VPWR VGND sky130_ef_sc_hd__decap_12
XFILLER_128_802 VGND VGND VPWR VPWR sky130_fd_sc_hd__decap_8
X_10626_ clknet_leaf_85_clk _00756_ VGND VGND VPWR VPWR count_cycle\[49\] sky130_fd_sc_hd__dfxtp_1
XTAP_TAPCELL_ROW_40_964 VGND VPWR sky130_fd_sc_hd__tapvpwrvgnd_1
XTAP_TAPCELL_ROW_40_975 VGND VPWR sky130_fd_sc_hd__tapvpwrvgnd_1
Xpicorv32_307 VGND VGND VPWR VPWR picorv32_307/HI eoi[26] sky130_fd_sc_hd__conb_1
XFILLER_139_194 VGND VGND VPWR VPWR sky130_fd_sc_hd__decap_8
Xpicorv32_318 VGND VGND VPWR VPWR picorv32_318/HI pcpi_insn[1] sky130_fd_sc_hd__conb_1
X_10557_ clknet_leaf_96_clk _00687_ VGND VGND VPWR VPWR reg_next_pc\[12\] sky130_fd_sc_hd__dfxtp_1
XFILLER_10_682 VGND VGND VPWR VPWR sky130_fd_sc_hd__fill_2
Xpicorv32_329 VGND VGND VPWR VPWR picorv32_329/HI pcpi_insn[12] sky130_fd_sc_hd__conb_1
XFILLER_142_304 VGND VGND VPWR VPWR sky130_fd_sc_hd__decap_4
X_10488_ clknet_leaf_107_clk _00618_ VGND VGND VPWR VPWR count_instr\[37\] sky130_fd_sc_hd__dfxtp_1
XFILLER_142_359 VGND VGND VPWR VPWR sky130_fd_sc_hd__decap_4
XFILLER_108_581 VGND VGND VPWR VPWR sky130_fd_sc_hd__decap_6
XFILLER_96_402 VGND VGND VPWR VPWR sky130_fd_sc_hd__fill_2
XTAP_TAPCELL_ROW_9_480 VGND VPWR sky130_fd_sc_hd__tapvpwrvgnd_1
XFILLER_2_881 VPWR VGND VPWR VGND sky130_ef_sc_hd__decap_12
X_11109_ clknet_leaf_99_clk _00022_ VGND VGND VPWR VPWR cpu_state\[5\] sky130_fd_sc_hd__dfxtp_2
XFILLER_1_391 VGND VGND VPWR VPWR sky130_fd_sc_hd__fill_1
X_04980_ mem_state\[0\] mem_state\[1\] VGND VGND VPWR VPWR _01608_ sky130_fd_sc_hd__and2_1
XTAP_TAPCELL_ROW_88_1734 VGND VPWR sky130_fd_sc_hd__tapvpwrvgnd_1
XFILLER_77_671 VGND VGND VPWR VPWR sky130_fd_sc_hd__fill_1
XTAP_TAPCELL_ROW_88_1745 VGND VPWR sky130_fd_sc_hd__tapvpwrvgnd_1
X_06650_ net258 _03074_ _00016_ VGND VGND VPWR VPWR _03076_ sky130_fd_sc_hd__o21a_1
XFILLER_92_663 VPWR VGND VPWR VGND sky130_ef_sc_hd__decap_12
XFILLER_64_376 VPWR VGND VPWR VGND sky130_ef_sc_hd__decap_12
X_05601_ _02178_ _02183_ _02179_ VGND VGND VPWR VPWR _02184_ sky130_fd_sc_hd__a21oi_1
X_06581_ _02979_ _03008_ _03007_ VGND VGND VPWR VPWR _03009_ sky130_fd_sc_hd__a21oi_2
XFILLER_18_793 VPWR VGND VPWR VGND sky130_ef_sc_hd__decap_12
X_05532_ _02081_ _02098_ _02114_ VGND VGND VPWR VPWR _02115_ sky130_fd_sc_hd__or3_1
X_08320_ count_cycle\[22\] _04096_ net34 VGND VGND VPWR VPWR _04099_ sky130_fd_sc_hd__o21ai_1
X_08251_ _03720_ _04041_ instr_jal VGND VGND VPWR VPWR _04053_ sky130_fd_sc_hd__a21oi_1
X_05463_ _02039_ _02040_ _02046_ VGND VGND VPWR VPWR _04902_ sky130_fd_sc_hd__o21bai_1
XFILLER_20_413 VGND VGND VPWR VPWR sky130_fd_sc_hd__decap_6
XFILLER_137_109 VGND VGND VPWR VPWR sky130_fd_sc_hd__decap_3
X_07202_ cpuregs\[30\]\[20\] _02665_ _03556_ VGND VGND VPWR VPWR _00152_ sky130_fd_sc_hd__mux2_1
XTAP_TAPCELL_ROW_119_2233 VGND VPWR sky130_fd_sc_hd__tapvpwrvgnd_1
XFILLER_146_610 VPWR VGND VPWR VGND sky130_ef_sc_hd__decap_12
X_08182_ _03985_ _03988_ instr_jal VGND VGND VPWR VPWR _03990_ sky130_fd_sc_hd__o21ai_1
X_05394_ _01970_ _01973_ _01982_ VGND VGND VPWR VPWR _01983_ sky130_fd_sc_hd__nand3_1
XFILLER_134_805 VGND VGND VPWR VPWR sky130_fd_sc_hd__decap_6
X_07133_ cpuregs\[8\]\[30\] cpuregs\[9\]\[30\] cpuregs\[10\]\[30\] cpuregs\[11\]\[30\]
+ net265 net260 VGND VGND VPWR VPWR _03541_ sky130_fd_sc_hd__mux4_1
Xoutput210 net210 VGND VGND VPWR VPWR pcpi_rs2[16] sky130_fd_sc_hd__buf_2
XFILLER_134_849 VPWR VGND VPWR VGND sky130_ef_sc_hd__decap_12
XTAP_TAPCELL_ROW_132_2444 VGND VPWR sky130_fd_sc_hd__tapvpwrvgnd_1
X_07064_ _01567_ net237 VGND VGND VPWR VPWR _03474_ sky130_fd_sc_hd__nor2_1
XPHY_EDGE_ROW_12_Right_12 VGND VGND VPWR VPWR sky130_fd_sc_hd__decap_3
Xoutput221 net221 VGND VGND VPWR VPWR pcpi_rs2[26] sky130_fd_sc_hd__buf_2
X_06015_ reg_out\[30\] reg_next_pc\[30\] net597 VGND VGND VPWR VPWR _02511_ sky130_fd_sc_hd__mux2_1
Xoutput232 net232 VGND VGND VPWR VPWR pcpi_rs2[7] sky130_fd_sc_hd__buf_2
XFILLER_58_29 VPWR VGND VPWR VGND sky130_ef_sc_hd__decap_12
XTAP_TAPCELL_ROW_7_439 VGND VPWR sky130_fd_sc_hd__tapvpwrvgnd_1
XFILLER_0_818 VGND VGND VPWR VPWR sky130_fd_sc_hd__decap_4
XFILLER_142_893 VPWR VGND VPWR VGND sky130_ef_sc_hd__decap_12
XFILLER_101_223 VGND VGND VPWR VPWR sky130_fd_sc_hd__fill_1
X_07966_ _03787_ _03789_ _03775_ _03779_ VGND VGND VPWR VPWR _03791_ sky130_fd_sc_hd__a211o_1
X_06917_ cpuregs\[16\]\[22\] cpuregs\[17\]\[22\] cpuregs\[18\]\[22\] cpuregs\[19\]\[22\]
+ net267 net261 VGND VGND VPWR VPWR _03333_ sky130_fd_sc_hd__mux4_1
XFILLER_68_693 VGND VGND VPWR VPWR sky130_fd_sc_hd__fill_1
XTAP_TAPCELL_ROW_52_1170 VGND VPWR sky130_fd_sc_hd__tapvpwrvgnd_1
X_09705_ _02630_ cpuregs\[5\]\[11\] _04872_ VGND VGND VPWR VPWR _01361_ sky130_fd_sc_hd__mux2_1
Xclkbuf_leaf_94_clk clknet_4_12_0_clk VGND VGND VPWR VPWR clknet_leaf_94_clk sky130_fd_sc_hd__clkbuf_8
XFILLER_83_652 VGND VGND VPWR VPWR sky130_fd_sc_hd__fill_2
XFILLER_83_641 VGND VGND VPWR VPWR sky130_fd_sc_hd__decap_4
X_09636_ _02621_ cpuregs\[22\]\[9\] _04869_ VGND VGND VPWR VPWR _01295_ sky130_fd_sc_hd__mux2_1
X_07897_ _03721_ _03727_ VGND VGND VPWR VPWR _03728_ sky130_fd_sc_hd__or2_1
X_06848_ decoded_imm\[19\] net181 _03214_ _03264_ _03265_ VGND VGND VPWR VPWR _03266_
+ sky130_fd_sc_hd__a221o_1
XPHY_EDGE_ROW_21_Right_21 VGND VGND VPWR VPWR sky130_fd_sc_hd__decap_3
X_06779_ cpuregs\[16\]\[17\] cpuregs\[17\]\[17\] cpuregs\[18\]\[17\] cpuregs\[19\]\[17\]
+ net265 net260 VGND VGND VPWR VPWR _03200_ sky130_fd_sc_hd__mux4_1
XTAP_TAPCELL_ROW_26_747 VGND VPWR sky130_fd_sc_hd__tapvpwrvgnd_1
X_09567_ cpuregs\[29\]\[6\] _02607_ net239 VGND VGND VPWR VPWR _01228_ sky130_fd_sc_hd__mux2_1
XFILLER_90_27 VGND VGND VPWR VPWR sky130_fd_sc_hd__fill_1
X_09498_ cpuregs\[31\]\[3\] _02593_ net240 VGND VGND VPWR VPWR _01161_ sky130_fd_sc_hd__mux2_1
X_08518_ cpuregs\[4\]\[0\] cpuregs\[5\]\[0\] cpuregs\[6\]\[0\] cpuregs\[7\]\[0\] net279
+ _00008_ VGND VGND VPWR VPWR _04220_ sky130_fd_sc_hd__mux4_1
X_08449_ cpuregs\[0\]\[31\] cpuregs\[1\]\[31\] cpuregs\[2\]\[31\] cpuregs\[3\]\[31\]
+ net264 net259 VGND VGND VPWR VPWR _04186_ sky130_fd_sc_hd__mux4_1
XFILLER_11_402 VPWR VGND VPWR VGND sky130_ef_sc_hd__decap_12
X_11460_ clknet_leaf_45_clk _01504_ VGND VGND VPWR VPWR cpuregs\[0\]\[26\] sky130_fd_sc_hd__dfxtp_1
XFILLER_128_3 VPWR VGND VPWR VGND sky130_ef_sc_hd__decap_12
XFILLER_11_479 VGND VGND VPWR VPWR sky130_fd_sc_hd__decap_6
X_10411_ clknet_leaf_68_clk _00541_ VGND VGND VPWR VPWR cpuregs\[20\]\[25\] sky130_fd_sc_hd__dfxtp_1
X_11391_ clknet_leaf_74_clk _01435_ VGND VGND VPWR VPWR cpuregs\[7\]\[21\] sky130_fd_sc_hd__dfxtp_1
XPHY_EDGE_ROW_30_Right_30 VGND VGND VPWR VPWR sky130_fd_sc_hd__decap_3
X_10342_ clknet_leaf_76_clk _00472_ VGND VGND VPWR VPWR cpuregs\[16\]\[20\] sky130_fd_sc_hd__dfxtp_1
XFILLER_99_69 VPWR VGND VPWR VGND sky130_ef_sc_hd__decap_12
XFILLER_151_167 VGND VGND VPWR VPWR sky130_fd_sc_hd__fill_1
X_10273_ clknet_leaf_11_clk _00403_ VGND VGND VPWR VPWR cpuregs\[15\]\[15\] sky130_fd_sc_hd__dfxtp_1
XFILLER_2_133 VGND VGND VPWR VPWR sky130_fd_sc_hd__decap_6
XFILLER_2_177 VPWR VGND VPWR VGND sky130_ef_sc_hd__decap_12
XFILLER_66_619 VGND VGND VPWR VPWR sky130_fd_sc_hd__decap_3
XFILLER_59_682 VGND VGND VPWR VPWR sky130_fd_sc_hd__decap_6
Xclkbuf_leaf_85_clk clknet_4_14_0_clk VGND VGND VPWR VPWR clknet_leaf_85_clk sky130_fd_sc_hd__clkbuf_8
XFILLER_46_321 VGND VGND VPWR VPWR sky130_fd_sc_hd__fill_1
XFILLER_47_877 VPWR VGND VPWR VGND sky130_ef_sc_hd__decap_12
XFILLER_0_69 VPWR VGND VPWR VGND sky130_ef_sc_hd__decap_12
XFILLER_64_61 VGND VGND VPWR VPWR sky130_fd_sc_hd__fill_1
XTAP_TAPCELL_ROW_83_1664 VGND VPWR sky130_fd_sc_hd__tapvpwrvgnd_1
XTAP_TAPCELL_ROW_83_1653 VGND VPWR sky130_fd_sc_hd__tapvpwrvgnd_1
XFILLER_14_251 VGND VGND VPWR VPWR sky130_fd_sc_hd__fill_1
XFILLER_15_785 VPWR VGND VPWR VGND sky130_ef_sc_hd__decap_12
XFILLER_119_109 VGND VGND VPWR VPWR sky130_fd_sc_hd__decap_3
XFILLER_128_621 VGND VGND VPWR VPWR sky130_fd_sc_hd__decap_6
X_10609_ clknet_leaf_110_clk _00739_ VGND VGND VPWR VPWR count_cycle\[32\] sky130_fd_sc_hd__dfxtp_1
XFILLER_116_827 VGND VGND VPWR VPWR sky130_fd_sc_hd__decap_8
XFILLER_127_186 VGND VGND VPWR VPWR sky130_fd_sc_hd__decap_3
XFILLER_115_326 VGND VGND VPWR VPWR sky130_fd_sc_hd__fill_1
XTAP_TAPCELL_ROW_114_2163 VGND VPWR sky130_fd_sc_hd__tapvpwrvgnd_1
XTAP_TAPCELL_ROW_114_2152 VGND VPWR sky130_fd_sc_hd__tapvpwrvgnd_1
XFILLER_130_307 VGND VGND VPWR VPWR sky130_fd_sc_hd__fill_1
XFILLER_97_711 VPWR VGND VPWR VGND sky130_ef_sc_hd__decap_12
XFILLER_124_893 VPWR VGND VPWR VGND sky130_ef_sc_hd__decap_12
X_07820_ count_instr\[62\] _03683_ net34 VGND VGND VPWR VPWR _03685_ sky130_fd_sc_hd__o21ai_1
XFILLER_111_554 VGND VGND VPWR VPWR sky130_fd_sc_hd__decap_6
XFILLER_97_766 VGND VGND VPWR VPWR sky130_fd_sc_hd__fill_1
XFILLER_69_446 VGND VGND VPWR VPWR sky130_fd_sc_hd__fill_2
XFILLER_84_416 VGND VGND VPWR VPWR sky130_fd_sc_hd__decap_4
X_07751_ count_instr\[36\] _03639_ _03641_ VGND VGND VPWR VPWR _00617_ sky130_fd_sc_hd__o21a_1
Xclkbuf_leaf_76_clk clknet_4_15_0_clk VGND VGND VPWR VPWR clknet_leaf_76_clk sky130_fd_sc_hd__clkbuf_8
X_06702_ _03117_ _03118_ _01579_ VGND VGND VPWR VPWR _03126_ sky130_fd_sc_hd__mux2_1
X_04963_ instr_sltu instr_slt instr_sltiu instr_slti VGND VGND VPWR VPWR _01593_ sky130_fd_sc_hd__or4_1
XFILLER_38_866 VGND VGND VPWR VPWR sky130_fd_sc_hd__fill_2
XFILLER_80_600 VGND VGND VPWR VPWR sky130_fd_sc_hd__decap_6
X_07682_ count_instr\[11\] net391 _03597_ VGND VGND VPWR VPWR _00592_ sky130_fd_sc_hd__o21a_1
XFILLER_65_663 VGND VGND VPWR VPWR sky130_fd_sc_hd__decap_8
XFILLER_25_505 VGND VGND VPWR VPWR sky130_fd_sc_hd__decap_8
X_09421_ _02688_ cpuregs\[18\]\[25\] _04862_ VGND VGND VPWR VPWR _01055_ sky130_fd_sc_hd__mux2_1
X_06633_ _03006_ _03009_ _03034_ VGND VGND VPWR VPWR _03059_ sky130_fd_sc_hd__o21ba_4
X_09352_ instr_jal decoded_imm_j\[19\] _01589_ mem_rdata_q\[19\] VGND VGND VPWR VPWR
+ _04838_ sky130_fd_sc_hd__a22o_1
X_06564_ cpuregs\[8\]\[9\] cpuregs\[9\]\[9\] cpuregs\[10\]\[9\] cpuregs\[11\]\[9\]
+ net263 net259 VGND VGND VPWR VPWR _02993_ sky130_fd_sc_hd__mux4_1
XFILLER_40_508 VPWR VGND VPWR VGND sky130_ef_sc_hd__decap_12
X_05515_ _02085_ _02088_ _02092_ _02096_ VGND VGND VPWR VPWR _02098_ sky130_fd_sc_hd__or4_2
XFILLER_100_37 VPWR VGND VPWR VGND sky130_ef_sc_hd__decap_12
X_08303_ count_cycle\[16\] count_cycle\[17\] VGND VGND VPWR VPWR _04087_ sky130_fd_sc_hd__and2_1
XTAP_TAPCELL_ROW_23_706 VGND VPWR sky130_fd_sc_hd__tapvpwrvgnd_1
X_09283_ net139 net101 _04206_ VGND VGND VPWR VPWR _00969_ sky130_fd_sc_hd__mux2_1
XFILLER_60_19 VGND VGND VPWR VPWR sky130_fd_sc_hd__decap_8
XFILLER_20_232 VGND VGND VPWR VPWR sky130_fd_sc_hd__fill_1
X_06495_ decoded_imm\[7\] net200 VGND VGND VPWR VPWR _02926_ sky130_fd_sc_hd__nand2_1
X_08234_ _01551_ _04029_ _04030_ _04036_ _04037_ VGND VGND VPWR VPWR _04038_ sky130_fd_sc_hd__a32o_1
X_05446_ _02027_ _02028_ _02029_ _02016_ VGND VGND VPWR VPWR _02031_ sky130_fd_sc_hd__a211o_1
X_08165_ decoded_imm_j\[20\] _03711_ VGND VGND VPWR VPWR _03974_ sky130_fd_sc_hd__xor2_1
X_05377_ cpu_state\[6\] _01860_ _01963_ _01967_ VGND VGND VPWR VPWR _01968_ sky130_fd_sc_hd__a31o_1
XFILLER_118_153 VGND VGND VPWR VPWR sky130_fd_sc_hd__decap_8
X_07116_ net192 _03524_ net236 VGND VGND VPWR VPWR _00098_ sky130_fd_sc_hd__mux2_1
Xclkload80 clknet_leaf_52_clk VGND VGND VPWR VPWR clkload80/Y sky130_fd_sc_hd__inv_8
XFILLER_109_57 VGND VGND VPWR VPWR sky130_fd_sc_hd__decap_8
X_08096_ _03909_ _03910_ VGND VGND VPWR VPWR _03911_ sky130_fd_sc_hd__xnor2_1
XFILLER_69_39 VGND VGND VPWR VPWR sky130_fd_sc_hd__fill_1
X_07047_ _01622_ _03452_ _03453_ _03457_ VGND VGND VPWR VPWR _03458_ sky130_fd_sc_hd__a31o_1
Xclkload91 clknet_leaf_99_clk VGND VGND VPWR VPWR clkload91/X sky130_fd_sc_hd__clkbuf_4
XFILLER_0_637 VGND VGND VPWR VPWR sky130_fd_sc_hd__decap_3
XFILLER_88_766 VGND VGND VPWR VPWR sky130_fd_sc_hd__decap_4
XTAP_TAPCELL_ROW_145_2646 VGND VPWR sky130_fd_sc_hd__tapvpwrvgnd_1
X_08998_ cpuregs\[16\]\[28\] cpuregs\[17\]\[28\] cpuregs\[18\]\[28\] cpuregs\[19\]\[28\]
+ net280 net274 VGND VGND VPWR VPWR _04672_ sky130_fd_sc_hd__mux4_1
XFILLER_102_587 VGND VGND VPWR VPWR sky130_fd_sc_hd__fill_1
XTAP_TAPCELL_ROW_50_1129 VGND VPWR sky130_fd_sc_hd__tapvpwrvgnd_1
XFILLER_48_619 VGND VGND VPWR VPWR sky130_fd_sc_hd__fill_1
XFILLER_47_107 VGND VGND VPWR VPWR sky130_fd_sc_hd__decap_4
XTAP_TAPCELL_ROW_145_2657 VGND VPWR sky130_fd_sc_hd__tapvpwrvgnd_1
Xclkbuf_leaf_67_clk clknet_4_13_0_clk VGND VGND VPWR VPWR clknet_leaf_67_clk sky130_fd_sc_hd__clkbuf_8
XFILLER_75_438 VGND VGND VPWR VPWR sky130_fd_sc_hd__decap_4
X_07949_ _03774_ VGND VGND VPWR VPWR _03775_ sky130_fd_sc_hd__inv_2
XFILLER_47_129 VGND VGND VPWR VPWR sky130_fd_sc_hd__fill_2
XFILLER_141_55 VGND VGND VPWR VPWR sky130_fd_sc_hd__fill_1
XFILLER_90_419 VGND VGND VPWR VPWR sky130_fd_sc_hd__fill_1
X_10960_ clknet_leaf_100_clk _01022_ VGND VGND VPWR VPWR decoded_imm\[8\] sky130_fd_sc_hd__dfxtp_1
XFILLER_18_65 VPWR VGND VPWR VGND sky130_ef_sc_hd__decap_12
XFILLER_29_877 VPWR VGND VPWR VGND sky130_ef_sc_hd__decap_12
XFILLER_44_825 VGND VGND VPWR VPWR sky130_fd_sc_hd__fill_2
X_09619_ _02688_ cpuregs\[3\]\[25\] _04868_ VGND VGND VPWR VPWR _01279_ sky130_fd_sc_hd__mux2_1
XFILLER_56_685 VGND VGND VPWR VPWR sky130_fd_sc_hd__fill_1
X_10891_ clknet_4_10_0_clk _00953_ VGND VGND VPWR VPWR net65 sky130_fd_sc_hd__dfxtp_1
XFILLER_28_398 VGND VGND VPWR VPWR sky130_fd_sc_hd__fill_1
XFILLER_71_666 VGND VGND VPWR VPWR sky130_fd_sc_hd__decap_6
XFILLER_43_346 VGND VGND VPWR VPWR sky130_fd_sc_hd__fill_1
XFILLER_44_869 VPWR VGND VPWR VGND sky130_ef_sc_hd__decap_12
XFILLER_70_176 VGND VGND VPWR VPWR sky130_fd_sc_hd__decap_6
XTAP_TAPCELL_ROW_65_1372 VGND VPWR sky130_fd_sc_hd__tapvpwrvgnd_1
XFILLER_52_891 VGND VGND VPWR VPWR sky130_fd_sc_hd__fill_2
XFILLER_24_582 VGND VGND VPWR VPWR sky130_fd_sc_hd__decap_6
XFILLER_34_53 VGND VGND VPWR VPWR sky130_fd_sc_hd__decap_3
XFILLER_11_221 VGND VGND VPWR VPWR sky130_fd_sc_hd__decap_3
XFILLER_11_210 VGND VGND VPWR VPWR sky130_fd_sc_hd__fill_2
XFILLER_50_41 VPWR VGND VPWR VGND sky130_ef_sc_hd__decap_12
XFILLER_7_225 VGND VGND VPWR VPWR sky130_fd_sc_hd__fill_1
X_11443_ clknet_leaf_0_clk _01487_ VGND VGND VPWR VPWR cpuregs\[0\]\[9\] sky130_fd_sc_hd__dfxtp_1
XFILLER_50_85 VPWR VGND VPWR VGND sky130_ef_sc_hd__decap_12
XFILLER_125_657 VGND VGND VPWR VPWR sky130_fd_sc_hd__decap_6
XFILLER_109_175 VGND VGND VPWR VPWR sky130_fd_sc_hd__fill_1
X_11374_ clknet_leaf_137_clk _01418_ VGND VGND VPWR VPWR cpuregs\[7\]\[4\] sky130_fd_sc_hd__dfxtp_1
XFILLER_113_808 VPWR VGND VPWR VGND sky130_ef_sc_hd__decap_12
X_10325_ clknet_leaf_124_clk _00455_ VGND VGND VPWR VPWR cpuregs\[16\]\[3\] sky130_fd_sc_hd__dfxtp_1
XFILLER_105_370 VGND VGND VPWR VPWR sky130_fd_sc_hd__decap_6
X_10256_ clknet_leaf_24_clk _00386_ VGND VGND VPWR VPWR cpuregs\[27\]\[30\] sky130_fd_sc_hd__dfxtp_1
XFILLER_59_61 VGND VGND VPWR VPWR sky130_fd_sc_hd__fill_1
XFILLER_121_841 VPWR VGND VPWR VGND sky130_ef_sc_hd__decap_12
XFILLER_78_243 VGND VGND VPWR VPWR sky130_fd_sc_hd__decap_8
XFILLER_39_608 VGND VGND VPWR VPWR sky130_fd_sc_hd__decap_8
X_10187_ clknet_leaf_67_clk _00317_ VGND VGND VPWR VPWR cpuregs\[9\]\[25\] sky130_fd_sc_hd__dfxtp_1
XFILLER_38_118 VGND VGND VPWR VPWR sky130_fd_sc_hd__decap_6
Xclkbuf_leaf_58_clk clknet_4_6_0_clk VGND VGND VPWR VPWR clknet_leaf_58_clk sky130_fd_sc_hd__clkbuf_8
XFILLER_82_909 VGND VGND VPWR VPWR sky130_fd_sc_hd__decap_3
XFILLER_19_321 VGND VGND VPWR VPWR sky130_fd_sc_hd__decap_6
XFILLER_93_279 VGND VGND VPWR VPWR sky130_fd_sc_hd__fill_1
XFILLER_81_419 VPWR VGND VPWR VGND sky130_ef_sc_hd__decap_12
Xclkbuf_4_11_0_clk clknet_0_clk VGND VGND VPWR VPWR clknet_4_11_0_clk sky130_fd_sc_hd__clkbuf_8
XFILLER_74_482 VPWR VGND VPWR VGND sky130_ef_sc_hd__decap_12
XFILLER_62_666 VGND VGND VPWR VPWR sky130_fd_sc_hd__decap_8
XFILLER_46_195 VGND VGND VPWR VPWR sky130_fd_sc_hd__fill_1
XTAP_TAPCELL_ROW_17_599 VGND VPWR sky130_fd_sc_hd__tapvpwrvgnd_1
X_05300_ cpu_state\[3\] _01890_ _01896_ VGND VGND VPWR VPWR _04887_ sky130_fd_sc_hd__a21o_1
X_06280_ mem_do_wdata cpu_state\[5\] _01549_ VGND VGND VPWR VPWR _02718_ sky130_fd_sc_hd__a21oi_1
X_05231_ _01812_ _01821_ _01830_ VGND VGND VPWR VPWR _01833_ sky130_fd_sc_hd__or3_1
XFILLER_128_473 VGND VGND VPWR VPWR sky130_fd_sc_hd__decap_3
XTAP_TAPCELL_ROW_96_1866 VGND VPWR sky130_fd_sc_hd__tapvpwrvgnd_1
X_05162_ _01765_ _01768_ VGND VGND VPWR VPWR _01769_ sky130_fd_sc_hd__nand2_1
XFILLER_115_167 VGND VGND VPWR VPWR sky130_fd_sc_hd__fill_1
X_09970_ clknet_leaf_126_clk _00100_ VGND VGND VPWR VPWR cpuregs\[12\]\[0\] sky130_fd_sc_hd__dfxtp_1
X_05093_ reg_pc\[3\] decoded_imm\[3\] VGND VGND VPWR VPWR _01705_ sky130_fd_sc_hd__or2_1
X_08921_ cpuregs\[12\]\[24\] cpuregs\[13\]\[24\] cpuregs\[14\]\[24\] cpuregs\[15\]\[24\]
+ net280 net274 VGND VGND VPWR VPWR _04599_ sky130_fd_sc_hd__mux4_1
XFILLER_130_115 VPWR VGND VPWR VGND sky130_ef_sc_hd__decap_12
XFILLER_115_178 VGND VGND VPWR VPWR sky130_fd_sc_hd__decap_4
X_08852_ _01558_ _04524_ net269 VGND VGND VPWR VPWR _04534_ sky130_fd_sc_hd__o21a_1
X_07803_ _03669_ count_instr\[55\] count_instr\[54\] count_instr\[56\] VGND VGND VPWR
+ VPWR _03674_ sky130_fd_sc_hd__and4_1
Xclkbuf_leaf_49_clk clknet_4_7_0_clk VGND VGND VPWR VPWR clknet_leaf_49_clk sky130_fd_sc_hd__clkbuf_8
XTAP_TAPCELL_ROW_127_2365 VGND VPWR sky130_fd_sc_hd__tapvpwrvgnd_1
X_05995_ reg_out\[20\] reg_next_pc\[20\] net596 VGND VGND VPWR VPWR _02501_ sky130_fd_sc_hd__mux2_1
X_08783_ _04458_ _04459_ _01558_ VGND VGND VPWR VPWR _04469_ sky130_fd_sc_hd__mux2_1
XFILLER_84_235 VGND VGND VPWR VPWR sky130_fd_sc_hd__decap_3
XFILLER_73_909 VGND VGND VPWR VPWR sky130_fd_sc_hd__decap_3
X_07734_ count_instr\[30\] _03629_ _01549_ VGND VGND VPWR VPWR _03631_ sky130_fd_sc_hd__a21oi_1
X_04946_ net258 VGND VGND VPWR VPWR _01579_ sky130_fd_sc_hd__clkinv_16
XFILLER_72_419 VGND VGND VPWR VPWR sky130_fd_sc_hd__fill_1
X_07665_ count_instr\[5\] net418 _01549_ VGND VGND VPWR VPWR _03587_ sky130_fd_sc_hd__a21oi_1
XFILLER_26_825 VPWR VGND VPWR VGND sky130_ef_sc_hd__decap_12
XTAP_TAPCELL_ROW_140_2576 VGND VPWR sky130_fd_sc_hd__tapvpwrvgnd_1
XTAP_TAPCELL_ROW_140_2565 VGND VPWR sky130_fd_sc_hd__tapvpwrvgnd_1
X_06616_ cpuregs\[28\]\[11\] cpuregs\[29\]\[11\] cpuregs\[30\]\[11\] cpuregs\[31\]\[11\]
+ net268 net259 VGND VGND VPWR VPWR _03043_ sky130_fd_sc_hd__mux4_1
XFILLER_26_869 VPWR VGND VPWR VGND sky130_ef_sc_hd__decap_12
X_09404_ _02616_ cpuregs\[18\]\[8\] _04862_ VGND VGND VPWR VPWR _01038_ sky130_fd_sc_hd__mux2_1
X_07596_ cpuregs\[20\]\[13\] _02638_ net245 VGND VGND VPWR VPWR _00529_ sky130_fd_sc_hd__mux2_1
XFILLER_52_165 VPWR VGND VPWR VGND sky130_ef_sc_hd__decap_12
XFILLER_34_880 VPWR VGND VPWR VGND sky130_ef_sc_hd__decap_12
XFILLER_41_839 VGND VGND VPWR VPWR sky130_fd_sc_hd__fill_1
X_09335_ decoded_imm\[28\] _04746_ _04825_ _04829_ VGND VGND VPWR VPWR _01002_ sky130_fd_sc_hd__o22a_1
XFILLER_80_496 VGND VGND VPWR VPWR sky130_fd_sc_hd__decap_8
X_06547_ reg_pc\[8\] _02751_ _02976_ _02715_ VGND VGND VPWR VPWR _02977_ sky130_fd_sc_hd__a211o_1
XTAP_TAPCELL_ROW_47_1091 VGND VPWR sky130_fd_sc_hd__tapvpwrvgnd_1
XFILLER_40_327 VGND VGND VPWR VPWR sky130_fd_sc_hd__decap_6
XTAP_TAPCELL_ROW_47_1080 VGND VPWR sky130_fd_sc_hd__tapvpwrvgnd_1
X_06478_ cpuregs\[28\]\[6\] cpuregs\[29\]\[6\] cpuregs\[30\]\[6\] cpuregs\[31\]\[6\]
+ net263 net259 VGND VGND VPWR VPWR _02910_ sky130_fd_sc_hd__mux4_1
X_09266_ _01549_ _04805_ VGND VGND VPWR VPWR _04809_ sky130_fd_sc_hd__nor2_1
X_08217_ _04010_ _04014_ _04019_ _01551_ VGND VGND VPWR VPWR _04022_ sky130_fd_sc_hd__a31o_1
X_05429_ reg_pc\[29\] decoded_imm\[29\] VGND VGND VPWR VPWR _02015_ sky130_fd_sc_hd__nor2_1
XFILLER_107_613 VGND VGND VPWR VPWR sky130_fd_sc_hd__decap_3
XTAP_TAPCELL_ROW_60_1291 VGND VPWR sky130_fd_sc_hd__tapvpwrvgnd_1
XFILLER_5_729 VGND VGND VPWR VPWR sky130_fd_sc_hd__decap_3
XFILLER_5_718 VGND VGND VPWR VPWR sky130_fd_sc_hd__decap_8
X_09197_ mem_rdata_q\[8\] net31 _01609_ VGND VGND VPWR VPWR _01102_ sky130_fd_sc_hd__mux2_1
XFILLER_134_421 VGND VGND VPWR VPWR sky130_fd_sc_hd__fill_1
X_08148_ _03933_ _03709_ _03708_ VGND VGND VPWR VPWR _03959_ sky130_fd_sc_hd__and3_1
XFILLER_122_605 VGND VGND VPWR VPWR sky130_fd_sc_hd__decap_6
XFILLER_107_657 VGND VGND VPWR VPWR sky130_fd_sc_hd__decap_3
X_08079_ _03857_ _03870_ VGND VGND VPWR VPWR _03895_ sky130_fd_sc_hd__nand2_1
XFILLER_20_77 VGND VGND VPWR VPWR sky130_fd_sc_hd__decap_6
XFILLER_136_77 VGND VGND VPWR VPWR sky130_fd_sc_hd__decap_6
X_11090_ clknet_leaf_79_clk _01147_ VGND VGND VPWR VPWR cpuregs\[24\]\[21\] sky130_fd_sc_hd__dfxtp_1
X_10110_ clknet_leaf_11_clk _00240_ VGND VGND VPWR VPWR cpuregs\[28\]\[12\] sky130_fd_sc_hd__dfxtp_1
XFILLER_121_137 VGND VGND VPWR VPWR sky130_fd_sc_hd__decap_8
XFILLER_0_434 VGND VGND VPWR VPWR sky130_fd_sc_hd__fill_2
X_10041_ clknet_leaf_146_clk _00171_ VGND VGND VPWR VPWR cpuregs\[13\]\[7\] sky130_fd_sc_hd__dfxtp_1
XFILLER_76_725 VGND VGND VPWR VPWR sky130_fd_sc_hd__fill_2
XFILLER_29_630 VGND VGND VPWR VPWR sky130_fd_sc_hd__fill_1
XFILLER_152_65 VPWR VGND VPWR VGND sky130_ef_sc_hd__decap_12
XTAP_TAPCELL_ROW_67_1401 VGND VPWR sky130_fd_sc_hd__tapvpwrvgnd_1
XFILLER_63_408 VPWR VGND VPWR VGND sky130_ef_sc_hd__decap_12
XFILLER_29_652 VPWR VGND VPWR VGND sky130_ef_sc_hd__decap_12
X_10943_ clknet_leaf_94_clk _01005_ VGND VGND VPWR VPWR decoded_imm\[25\] sky130_fd_sc_hd__dfxtp_2
XFILLER_29_696 VGND VGND VPWR VPWR sky130_fd_sc_hd__decap_4
XFILLER_44_611 VPWR VGND VPWR VGND sky130_ef_sc_hd__decap_12
X_10874_ clknet_leaf_23_clk _00936_ VGND VGND VPWR VPWR cpuregs\[1\]\[18\] sky130_fd_sc_hd__dfxtp_1
XTAP_TAPCELL_ROW_80_1612 VGND VPWR sky130_fd_sc_hd__tapvpwrvgnd_1
XFILLER_12_530 VGND VGND VPWR VPWR sky130_fd_sc_hd__fill_2
XTAP_TAPCELL_ROW_14_558 VGND VPWR sky130_fd_sc_hd__tapvpwrvgnd_1
XFILLER_40_850 VPWR VGND VPWR VGND sky130_ef_sc_hd__decap_12
XFILLER_145_719 VGND VGND VPWR VPWR sky130_fd_sc_hd__fill_1
XFILLER_8_589 VGND VGND VPWR VPWR sky130_fd_sc_hd__decap_3
XFILLER_137_281 VGND VGND VPWR VPWR sky130_fd_sc_hd__decap_8
X_11426_ clknet_leaf_70_clk _01470_ VGND VGND VPWR VPWR cpuregs\[8\]\[24\] sky130_fd_sc_hd__dfxtp_1
XANTENNA_6 _02641_ VGND VGND VPWR VPWR sky130_fd_sc_hd__diode_2
XFILLER_152_251 VGND VGND VPWR VPWR sky130_fd_sc_hd__fill_1
X_11357_ clknet_leaf_70_clk _01401_ VGND VGND VPWR VPWR cpuregs\[6\]\[19\] sky130_fd_sc_hd__dfxtp_1
XTAP_TAPCELL_ROW_111_2111 VGND VPWR sky130_fd_sc_hd__tapvpwrvgnd_1
XTAP_TAPCELL_ROW_111_2100 VGND VPWR sky130_fd_sc_hd__tapvpwrvgnd_1
XTAP_TAPCELL_ROW_78_1585 VGND VPWR sky130_fd_sc_hd__tapvpwrvgnd_1
XTAP_TAPCELL_ROW_78_1574 VGND VPWR sky130_fd_sc_hd__tapvpwrvgnd_1
XFILLER_153_785 VGND VGND VPWR VPWR sky130_fd_sc_hd__fill_2
X_10308_ clknet_leaf_53_clk _00438_ VGND VGND VPWR VPWR cpuregs\[26\]\[18\] sky130_fd_sc_hd__dfxtp_1
XFILLER_3_261 VPWR VGND VPWR VGND sky130_ef_sc_hd__decap_12
X_11288_ clknet_leaf_23_clk _01335_ VGND VGND VPWR VPWR cpuregs\[4\]\[17\] sky130_fd_sc_hd__dfxtp_1
XFILLER_79_530 VGND VGND VPWR VPWR sky130_fd_sc_hd__fill_1
XTAP_TAPCELL_ROW_91_1785 VGND VPWR sky130_fd_sc_hd__tapvpwrvgnd_1
X_10239_ clknet_leaf_26_clk _00369_ VGND VGND VPWR VPWR cpuregs\[27\]\[13\] sky130_fd_sc_hd__dfxtp_1
XFILLER_94_533 VPWR VGND VPWR VGND sky130_ef_sc_hd__decap_12
XFILLER_66_213 VGND VGND VPWR VPWR sky130_fd_sc_hd__decap_3
XTAP_TAPCELL_ROW_109_2073 VGND VPWR sky130_fd_sc_hd__tapvpwrvgnd_1
X_05780_ net177 net209 _02144_ _02334_ _02145_ VGND VGND VPWR VPWR _02347_ sky130_fd_sc_hd__o221a_1
XFILLER_66_279 VPWR VGND VPWR VGND sky130_ef_sc_hd__decap_12
XFILLER_54_408 VGND VGND VPWR VPWR sky130_fd_sc_hd__decap_4
Xrebuffer18 decoder_trigger VGND VGND VPWR VPWR net404 sky130_fd_sc_hd__dlygate4sd1_1
Xrebuffer29 _04104_ VGND VGND VPWR VPWR net415 sky130_fd_sc_hd__dlygate4sd1_1
XTAP_TAPCELL_ROW_122_2284 VGND VPWR sky130_fd_sc_hd__tapvpwrvgnd_1
X_07450_ cpuregs\[15\]\[1\] _02588_ _03567_ VGND VGND VPWR VPWR _00389_ sky130_fd_sc_hd__mux2_1
XFILLER_23_839 VGND VGND VPWR VPWR sky130_fd_sc_hd__fill_1
X_07381_ _03551_ _03554_ VGND VGND VPWR VPWR _03564_ sky130_fd_sc_hd__nor2_4
X_06401_ _01621_ _02808_ _02809_ _02715_ _02805_ VGND VGND VPWR VPWR _02836_ sky130_fd_sc_hd__o311a_1
XFILLER_148_513 VGND VGND VPWR VPWR sky130_fd_sc_hd__fill_1
X_09120_ _04747_ _04762_ VGND VGND VPWR VPWR _04763_ sky130_fd_sc_hd__nor2_1
XTAP_TAPCELL_ROW_33_856 VGND VPWR sky130_fd_sc_hd__tapvpwrvgnd_1
XTAP_TAPCELL_ROW_33_867 VGND VPWR sky130_fd_sc_hd__tapvpwrvgnd_1
X_06332_ _02748_ _02768_ VGND VGND VPWR VPWR _02769_ sky130_fd_sc_hd__xnor2_1
XFILLER_148_546 VGND VGND VPWR VPWR sky130_fd_sc_hd__fill_1
XTAP_TAPCELL_ROW_98_1906 VGND VPWR sky130_fd_sc_hd__tapvpwrvgnd_1
X_09051_ cpuregs\[8\]\[31\] cpuregs\[9\]\[31\] cpuregs\[10\]\[31\] cpuregs\[11\]\[31\]
+ net277 net272 VGND VGND VPWR VPWR _04722_ sky130_fd_sc_hd__mux4_1
XFILLER_30_371 VGND VGND VPWR VPWR sky130_fd_sc_hd__fill_1
XFILLER_129_771 VPWR VGND VPWR VGND sky130_ef_sc_hd__decap_12
X_06263_ _02700_ _02703_ _02584_ VGND VGND VPWR VPWR _02704_ sky130_fd_sc_hd__mux2_8
X_08002_ _03697_ _03796_ _03698_ VGND VGND VPWR VPWR _03824_ sky130_fd_sc_hd__a21oi_1
XPHY_EDGE_ROW_6_Right_6 VGND VGND VPWR VPWR sky130_fd_sc_hd__decap_3
XFILLER_30_393 VPWR VGND VPWR VGND sky130_ef_sc_hd__decap_12
XFILLER_128_281 VGND VGND VPWR VPWR sky130_fd_sc_hd__fill_1
XFILLER_116_421 VGND VGND VPWR VPWR sky130_fd_sc_hd__decap_8
X_06194_ reg_pc\[16\] _02644_ VGND VGND VPWR VPWR _02648_ sky130_fd_sc_hd__xor2_1
X_05214_ _01790_ _01801_ VGND VGND VPWR VPWR _01817_ sky130_fd_sc_hd__or2_1
X_05145_ cpu_state\[3\] _01745_ _01746_ _01753_ VGND VGND VPWR VPWR _04906_ sky130_fd_sc_hd__a31o_1
Xmax_cap275 net277 VGND VGND VPWR VPWR net275 sky130_fd_sc_hd__buf_12
Xmax_cap264 net268 VGND VGND VPWR VPWR net264 sky130_fd_sc_hd__buf_12
XFILLER_98_850 VGND VGND VPWR VPWR sky130_fd_sc_hd__decap_4
X_09953_ clknet_leaf_58_clk _00083_ VGND VGND VPWR VPWR net176 sky130_fd_sc_hd__dfxtp_4
X_05076_ cpu_state\[3\] _01687_ _01688_ _01689_ VGND VGND VPWR VPWR _04889_ sky130_fd_sc_hd__a31o_1
X_08904_ _01558_ _04582_ VGND VGND VPWR VPWR _04583_ sky130_fd_sc_hd__or2_1
X_09884_ cpuregs\[0\]\[14\] VGND VGND VPWR VPWR _01492_ sky130_fd_sc_hd__clkbuf_1
X_08835_ _04509_ _04510_ _04516_ _04517_ _01558_ _01559_ VGND VGND VPWR VPWR _04518_
+ sky130_fd_sc_hd__mux4_1
XFILLER_111_181 VGND VGND VPWR VPWR sky130_fd_sc_hd__decap_8
XFILLER_97_393 VPWR VGND VPWR VGND sky130_ef_sc_hd__decap_12
XFILLER_85_533 VPWR VGND VPWR VGND sky130_ef_sc_hd__decap_12
XFILLER_66_29 VPWR VGND VPWR VGND sky130_ef_sc_hd__decap_12
XTAP_TAPCELL_ROW_142_2605 VGND VPWR sky130_fd_sc_hd__tapvpwrvgnd_1
X_08766_ net270 _04449_ _04448_ _01560_ VGND VGND VPWR VPWR _04453_ sky130_fd_sc_hd__o211a_1
X_07717_ count_instr\[24\] _03618_ VGND VGND VPWR VPWR _03620_ sky130_fd_sc_hd__and2_1
X_05978_ net173 _02492_ _01582_ VGND VGND VPWR VPWR net67 sky130_fd_sc_hd__mux2_2
XTAP_TAPCELL_ROW_49_1120 VGND VPWR sky130_fd_sc_hd__tapvpwrvgnd_1
X_04929_ net177 VGND VGND VPWR VPWR _01562_ sky130_fd_sc_hd__inv_2
X_08697_ cpuregs\[16\]\[12\] cpuregs\[17\]\[12\] cpuregs\[18\]\[12\] cpuregs\[19\]\[12\]
+ net278 net273 VGND VGND VPWR VPWR _04387_ sky130_fd_sc_hd__mux4_1
XFILLER_81_794 VGND VGND VPWR VPWR sky130_fd_sc_hd__fill_2
X_07648_ _01547_ _01555_ VGND VGND VPWR VPWR _03575_ sky130_fd_sc_hd__nor2_8
X_07579_ cpuregs\[25\]\[30\] _02709_ _03571_ VGND VGND VPWR VPWR _00514_ sky130_fd_sc_hd__mux2_1
XTAP_TAPCELL_ROW_62_1331 VGND VPWR sky130_fd_sc_hd__tapvpwrvgnd_1
XTAP_TAPCELL_ROW_62_1320 VGND VPWR sky130_fd_sc_hd__tapvpwrvgnd_1
XFILLER_15_55 VGND VGND VPWR VPWR sky130_fd_sc_hd__fill_1
XFILLER_40_113 VPWR VGND VPWR VGND sky130_ef_sc_hd__decap_12
XFILLER_22_861 VGND VGND VPWR VPWR sky130_fd_sc_hd__decap_6
X_09318_ _04236_ decoded_imm_j\[11\] is_slli_srli_srai VGND VGND VPWR VPWR _04818_
+ sky130_fd_sc_hd__mux2_1
X_10590_ clknet_leaf_87_clk _00720_ VGND VGND VPWR VPWR count_cycle\[13\] sky130_fd_sc_hd__dfxtp_1
XTAP_TAPCELL_ROW_11_506 VGND VPWR sky130_fd_sc_hd__tapvpwrvgnd_1
X_09249_ cpuregs\[1\]\[28\] _02699_ net244 VGND VGND VPWR VPWR _00946_ sky130_fd_sc_hd__mux2_1
XFILLER_108_911 VGND VGND VPWR VPWR sky130_fd_sc_hd__fill_1
XTAP_TAPCELL_ROW_153_2789 VGND VPWR sky130_fd_sc_hd__tapvpwrvgnd_1
XTAP_TAPCELL_ROW_153_2778 VGND VPWR sky130_fd_sc_hd__tapvpwrvgnd_1
XFILLER_107_421 VPWR VGND VPWR VGND sky130_ef_sc_hd__decap_12
XFILLER_135_774 VGND VGND VPWR VPWR sky130_fd_sc_hd__decap_8
XFILLER_135_741 VPWR VGND VPWR VGND sky130_ef_sc_hd__decap_12
XFILLER_5_559 VGND VGND VPWR VPWR sky130_fd_sc_hd__fill_1
X_11211_ clknet_leaf_136_clk _01258_ VGND VGND VPWR VPWR cpuregs\[3\]\[4\] sky130_fd_sc_hd__dfxtp_1
XFILLER_135_785 VPWR VGND VPWR VGND sky130_ef_sc_hd__decap_12
Xoutput43 net43 VGND VGND VPWR VPWR mem_addr[18] sky130_fd_sc_hd__buf_2
X_11142_ clknet_leaf_16_clk _01189_ VGND VGND VPWR VPWR cpuregs\[31\]\[31\] sky130_fd_sc_hd__dfxtp_1
Xoutput54 net54 VGND VGND VPWR VPWR mem_addr[29] sky130_fd_sc_hd__buf_2
Xoutput76 net76 VGND VGND VPWR VPWR mem_la_addr[20] sky130_fd_sc_hd__buf_2
XFILLER_1_721 VGND VGND VPWR VPWR sky130_fd_sc_hd__decap_6
Xoutput65 net65 VGND VGND VPWR VPWR mem_instr sky130_fd_sc_hd__buf_2
Xoutput87 net87 VGND VGND VPWR VPWR mem_la_addr[30] sky130_fd_sc_hd__buf_2
XFILLER_122_468 VGND VGND VPWR VPWR sky130_fd_sc_hd__decap_8
XFILLER_103_671 VGND VGND VPWR VPWR sky130_fd_sc_hd__fill_1
XFILLER_89_872 VGND VGND VPWR VPWR sky130_fd_sc_hd__decap_4
XTAP_TAPCELL_ROW_73_1493 VGND VPWR sky130_fd_sc_hd__tapvpwrvgnd_1
XFILLER_0_253 VPWR VGND VPWR VGND sky130_ef_sc_hd__decap_12
XFILLER_1_765 VPWR VGND VPWR VGND sky130_ef_sc_hd__decap_12
X_11073_ clknet_leaf_139_clk _01130_ VGND VGND VPWR VPWR cpuregs\[24\]\[4\] sky130_fd_sc_hd__dfxtp_1
Xoutput98 net98 VGND VGND VPWR VPWR mem_la_wdata[10] sky130_fd_sc_hd__buf_2
X_10024_ clknet_leaf_43_clk _00154_ VGND VGND VPWR VPWR cpuregs\[30\]\[22\] sky130_fd_sc_hd__dfxtp_1
XFILLER_76_533 VGND VGND VPWR VPWR sky130_fd_sc_hd__decap_8
XFILLER_48_235 VGND VGND VPWR VPWR sky130_fd_sc_hd__fill_1
XFILLER_102_192 VGND VGND VPWR VPWR sky130_fd_sc_hd__decap_4
XFILLER_49_769 VPWR VGND VPWR VGND sky130_ef_sc_hd__decap_12
XFILLER_57_780 VGND VGND VPWR VPWR sky130_fd_sc_hd__decap_4
XTAP_TAPCELL_ROW_19_628 VGND VPWR sky130_fd_sc_hd__tapvpwrvgnd_1
XTAP_TAPCELL_ROW_19_639 VGND VPWR sky130_fd_sc_hd__tapvpwrvgnd_1
XFILLER_63_249 VPWR VGND VPWR VGND sky130_ef_sc_hd__decap_12
XFILLER_16_132 VGND VGND VPWR VPWR sky130_fd_sc_hd__decap_8
X_10926_ clknet_leaf_108_clk _00988_ VGND VGND VPWR VPWR net167 sky130_fd_sc_hd__dfxtp_1
XFILLER_71_293 VGND VGND VPWR VPWR sky130_fd_sc_hd__decap_3
X_10857_ clknet_leaf_115_clk _00919_ VGND VGND VPWR VPWR cpuregs\[1\]\[1\] sky130_fd_sc_hd__dfxtp_1
XFILLER_31_113 VGND VGND VPWR VPWR sky130_fd_sc_hd__decap_4
XFILLER_32_636 VGND VGND VPWR VPWR sky130_fd_sc_hd__decap_8
XFILLER_44_485 VGND VGND VPWR VPWR sky130_fd_sc_hd__decap_6
XTAP_TAPCELL_ROW_30_804 VGND VPWR sky130_fd_sc_hd__tapvpwrvgnd_1
X_10788_ clknet_leaf_103_clk _00853_ VGND VGND VPWR VPWR instr_jalr sky130_fd_sc_hd__dfxtp_2
XPHY_EDGE_ROW_59_Right_59 VGND VGND VPWR VPWR sky130_fd_sc_hd__decap_3
XFILLER_9_821 VPWR VGND VPWR VGND sky130_ef_sc_hd__decap_12
XTAP_TAPCELL_ROW_30_815 VGND VPWR sky130_fd_sc_hd__tapvpwrvgnd_1
XFILLER_40_680 VGND VGND VPWR VPWR sky130_fd_sc_hd__fill_1
XFILLER_9_865 VPWR VGND VPWR VGND sky130_ef_sc_hd__decap_12
XFILLER_8_386 VGND VGND VPWR VPWR sky130_fd_sc_hd__decap_4
XFILLER_126_741 VGND VGND VPWR VPWR sky130_fd_sc_hd__fill_1
XTAP_TAPCELL_ROW_93_1825 VGND VPWR sky130_fd_sc_hd__tapvpwrvgnd_1
XTAP_TAPCELL_ROW_93_1814 VGND VPWR sky130_fd_sc_hd__tapvpwrvgnd_1
X_11409_ clknet_leaf_145_clk _01453_ VGND VGND VPWR VPWR cpuregs\[8\]\[7\] sky130_fd_sc_hd__dfxtp_1
XFILLER_99_658 VPWR VGND VPWR VGND sky130_ef_sc_hd__decap_12
XFILLER_98_135 VGND VGND VPWR VPWR sky130_fd_sc_hd__decap_4
XFILLER_4_581 VGND VGND VPWR VPWR sky130_fd_sc_hd__decap_6
X_06950_ _03356_ _03357_ _01579_ VGND VGND VPWR VPWR _03365_ sky130_fd_sc_hd__mux2_1
XFILLER_98_168 VGND VGND VPWR VPWR sky130_fd_sc_hd__fill_1
X_05901_ instr_sub _02452_ _02453_ _02454_ VGND VGND VPWR VPWR _02455_ sky130_fd_sc_hd__o22a_1
X_06881_ _03271_ _03274_ _03297_ VGND VGND VPWR VPWR _03298_ sky130_fd_sc_hd__and3_1
XFILLER_79_393 VGND VGND VPWR VPWR sky130_fd_sc_hd__decap_4
XPHY_EDGE_ROW_68_Right_68 VGND VGND VPWR VPWR sky130_fd_sc_hd__decap_3
XFILLER_67_522 VPWR VGND VPWR VGND sky130_ef_sc_hd__decap_12
XFILLER_121_490 VGND VGND VPWR VPWR sky130_fd_sc_hd__fill_2
X_05832_ _02094_ _02237_ _02238_ _02095_ VGND VGND VPWR VPWR _02394_ sky130_fd_sc_hd__a22o_1
X_08620_ _04313_ _04314_ _04266_ _04311_ VGND VGND VPWR VPWR _04315_ sky130_fd_sc_hd__o211a_1
XTAP_TAPCELL_ROW_124_2313 VGND VPWR sky130_fd_sc_hd__tapvpwrvgnd_1
XFILLER_95_897 VGND VGND VPWR VPWR sky130_fd_sc_hd__decap_3
XFILLER_94_363 VGND VGND VPWR VPWR sky130_fd_sc_hd__fill_1
XFILLER_82_525 VGND VGND VPWR VPWR sky130_fd_sc_hd__decap_6
XTAP_TAPCELL_ROW_38_937 VGND VPWR sky130_fd_sc_hd__tapvpwrvgnd_1
X_05763_ _02146_ _02240_ _02331_ VGND VGND VPWR VPWR _02332_ sky130_fd_sc_hd__a21o_1
XPHY_EDGE_ROW_59_Left_213 VGND VGND VPWR VPWR sky130_fd_sc_hd__decap_3
XFILLER_54_249 VGND VGND VPWR VPWR sky130_fd_sc_hd__decap_3
XFILLER_54_238 VGND VGND VPWR VPWR sky130_fd_sc_hd__decap_3
X_08551_ _00010_ _04251_ VGND VGND VPWR VPWR _04252_ sky130_fd_sc_hd__nand2_1
X_07502_ cpuregs\[26\]\[20\] _02665_ _03568_ VGND VGND VPWR VPWR _00440_ sky130_fd_sc_hd__mux2_1
X_08482_ net66 net35 _04208_ VGND VGND VPWR VPWR _00780_ sky130_fd_sc_hd__mux2_1
X_05694_ _02170_ _02270_ _02271_ VGND VGND VPWR VPWR _02272_ sky130_fd_sc_hd__o21a_1
X_07433_ cpuregs\[27\]\[17\] _02654_ _03566_ VGND VGND VPWR VPWR _00373_ sky130_fd_sc_hd__mux2_1
XFILLER_50_433 VGND VGND VPWR VPWR sky130_fd_sc_hd__fill_2
XFILLER_149_833 VGND VGND VPWR VPWR sky130_fd_sc_hd__decap_6
XTAP_TAPCELL_ROW_102_1965 VGND VPWR sky130_fd_sc_hd__tapvpwrvgnd_1
XPHY_EDGE_ROW_77_Right_77 VGND VGND VPWR VPWR sky130_fd_sc_hd__decap_3
XFILLER_11_809 VPWR VGND VPWR VGND sky130_ef_sc_hd__decap_12
X_09103_ _01556_ _04751_ VGND VGND VPWR VPWR _04755_ sky130_fd_sc_hd__nor2_2
X_07364_ _02646_ cpuregs\[9\]\[15\] _03563_ VGND VGND VPWR VPWR _00307_ sky130_fd_sc_hd__mux2_1
XFILLER_50_477 VGND VGND VPWR VPWR sky130_fd_sc_hd__decap_8
XFILLER_149_877 VPWR VGND VPWR VGND sky130_ef_sc_hd__decap_12
X_07295_ cpuregs\[28\]\[13\] _02638_ net249 VGND VGND VPWR VPWR _00241_ sky130_fd_sc_hd__mux2_1
X_06315_ cpuregs\[4\]\[1\] cpuregs\[5\]\[1\] cpuregs\[6\]\[1\] cpuregs\[7\]\[1\] net268
+ net262 VGND VGND VPWR VPWR _02752_ sky130_fd_sc_hd__mux4_1
X_06246_ reg_pc\[26\] _02686_ VGND VGND VPWR VPWR _02690_ sky130_fd_sc_hd__xor2_1
XFILLER_108_218 VGND VGND VPWR VPWR sky130_fd_sc_hd__decap_6
X_09034_ cpuregs\[0\]\[30\] cpuregs\[1\]\[30\] cpuregs\[2\]\[30\] cpuregs\[3\]\[30\]
+ net277 net271 VGND VGND VPWR VPWR _04706_ sky130_fd_sc_hd__mux4_1
XTAP_TAPCELL_ROW_135_2497 VGND VPWR sky130_fd_sc_hd__tapvpwrvgnd_1
XTAP_TAPCELL_ROW_135_2486 VGND VPWR sky130_fd_sc_hd__tapvpwrvgnd_1
XPHY_EDGE_ROW_68_Left_222 VGND VGND VPWR VPWR sky130_fd_sc_hd__decap_3
XFILLER_144_560 VGND VGND VPWR VPWR sky130_fd_sc_hd__decap_8
XFILLER_117_785 VPWR VGND VPWR VGND sky130_ef_sc_hd__decap_12
XFILLER_89_113 VGND VGND VPWR VPWR sky130_fd_sc_hd__decap_6
X_06177_ reg_out\[13\] alu_out_q\[13\] net593 VGND VGND VPWR VPWR _02634_ sky130_fd_sc_hd__mux2_1
XFILLER_117_57 VGND VGND VPWR VPWR sky130_fd_sc_hd__decap_8
X_05128_ reg_pc\[5\] decoded_imm\[5\] VGND VGND VPWR VPWR _01738_ sky130_fd_sc_hd__nand2_1
X_05059_ cpu_state\[3\] cpu_state\[6\] cpu_state\[4\] VGND VGND VPWR VPWR _01674_
+ sky130_fd_sc_hd__nor3_4
XPHY_EDGE_ROW_86_Right_86 VGND VGND VPWR VPWR sky130_fd_sc_hd__decap_3
X_09936_ clknet_leaf_128_clk _00029_ VGND VGND VPWR VPWR _00009_ sky130_fd_sc_hd__dfxtp_4
XFILLER_58_533 VGND VGND VPWR VPWR sky130_fd_sc_hd__decap_4
XFILLER_86_853 VGND VGND VPWR VPWR sky130_fd_sc_hd__decap_3
XFILLER_85_352 VGND VGND VPWR VPWR sky130_fd_sc_hd__fill_1
X_09867_ decoded_imm_j\[1\] _01115_ _02513_ VGND VGND VPWR VPWR _00908_ sky130_fd_sc_hd__mux2_1
X_08818_ _04496_ _04497_ _01558_ VGND VGND VPWR VPWR _04502_ sky130_fd_sc_hd__mux2_1
XPHY_EDGE_ROW_77_Left_231 VGND VGND VPWR VPWR sky130_fd_sc_hd__decap_3
X_09798_ _02603_ cpuregs\[8\]\[5\] _04875_ VGND VGND VPWR VPWR _01451_ sky130_fd_sc_hd__mux2_1
XFILLER_45_216 VGND VGND VPWR VPWR sky130_fd_sc_hd__decap_8
X_08749_ net269 _04435_ _01559_ VGND VGND VPWR VPWR _04437_ sky130_fd_sc_hd__a21o_1
XFILLER_45_249 VGND VGND VPWR VPWR sky130_fd_sc_hd__fill_1
XFILLER_54_783 VGND VGND VPWR VPWR sky130_fd_sc_hd__decap_3
XFILLER_54_772 VGND VGND VPWR VPWR sky130_fd_sc_hd__decap_3
XFILLER_26_65 VGND VGND VPWR VPWR sky130_fd_sc_hd__fill_1
XFILLER_26_474 VGND VGND VPWR VPWR sky130_fd_sc_hd__fill_2
XPHY_EDGE_ROW_95_Right_95 VGND VGND VPWR VPWR sky130_fd_sc_hd__decap_3
XFILLER_54_794 VPWR VGND VPWR VGND sky130_ef_sc_hd__decap_12
XFILLER_13_113 VGND VGND VPWR VPWR sky130_fd_sc_hd__fill_1
X_10711_ clknet_leaf_126_clk _00808_ VGND VGND VPWR VPWR net119 sky130_fd_sc_hd__dfxtp_4
XFILLER_41_433 VGND VGND VPWR VPWR sky130_fd_sc_hd__decap_8
XFILLER_13_135 VGND VGND VPWR VPWR sky130_fd_sc_hd__decap_3
X_10642_ clknet_leaf_110_clk _04878_ VGND VGND VPWR VPWR reg_out\[0\] sky130_fd_sc_hd__dfxtp_1
XFILLER_22_680 VGND VGND VPWR VPWR sky130_fd_sc_hd__decap_8
XFILLER_41_488 VPWR VGND VPWR VGND sky130_ef_sc_hd__decap_12
X_10573_ clknet_leaf_66_clk _00703_ VGND VGND VPWR VPWR reg_next_pc\[28\] sky130_fd_sc_hd__dfxtp_1
XPHY_EDGE_ROW_86_Left_240 VGND VGND VPWR VPWR sky130_fd_sc_hd__decap_3
Xrebuffer9 _04119_ VGND VGND VPWR VPWR net395 sky130_fd_sc_hd__dlygate4sd1_1
XFILLER_6_813 VPWR VGND VPWR VGND sky130_ef_sc_hd__decap_12
XFILLER_108_730 VGND VGND VPWR VPWR sky130_fd_sc_hd__decap_3
XFILLER_108_796 VGND VGND VPWR VPWR sky130_fd_sc_hd__decap_6
XFILLER_107_262 VPWR VGND VPWR VGND sky130_ef_sc_hd__decap_12
XTAP_TAPCELL_ROW_75_1533 VGND VPWR sky130_fd_sc_hd__tapvpwrvgnd_1
XFILLER_96_617 VGND VGND VPWR VPWR sky130_fd_sc_hd__decap_3
X_11125_ clknet_leaf_27_clk _01172_ VGND VGND VPWR VPWR cpuregs\[31\]\[14\] sky130_fd_sc_hd__dfxtp_1
XFILLER_96_639 VGND VGND VPWR VPWR sky130_fd_sc_hd__decap_4
X_11056_ clknet_leaf_88_clk _01113_ VGND VGND VPWR VPWR mem_rdata_q\[19\] sky130_fd_sc_hd__dfxtp_1
XFILLER_3_69 VPWR VGND VPWR VGND sky130_ef_sc_hd__decap_12
XFILLER_95_149 VGND VGND VPWR VPWR sky130_fd_sc_hd__decap_4
XFILLER_67_83 VGND VGND VPWR VPWR sky130_fd_sc_hd__decap_8
XFILLER_49_544 VGND VGND VPWR VPWR sky130_fd_sc_hd__decap_8
X_10007_ clknet_leaf_142_clk _00137_ VGND VGND VPWR VPWR cpuregs\[30\]\[5\] sky130_fd_sc_hd__dfxtp_1
XTAP_TAPCELL_ROW_106_2021 VGND VPWR sky130_fd_sc_hd__tapvpwrvgnd_1
XFILLER_77_897 VGND VGND VPWR VPWR sky130_fd_sc_hd__decap_3
XFILLER_76_363 VGND VGND VPWR VPWR sky130_fd_sc_hd__fill_1
XTAP_TAPCELL_ROW_106_2032 VGND VPWR sky130_fd_sc_hd__tapvpwrvgnd_1
XFILLER_45_750 VPWR VGND VPWR VGND sky130_ef_sc_hd__decap_12
X_10909_ clknet_leaf_7_clk _00971_ VGND VGND VPWR VPWR net141 sky130_fd_sc_hd__dfxtp_1
XFILLER_60_764 VGND VGND VPWR VPWR sky130_fd_sc_hd__decap_8
XFILLER_20_628 VPWR VGND VPWR VGND sky130_ef_sc_hd__decap_12
XFILLER_32_477 VPWR VGND VPWR VGND sky130_ef_sc_hd__decap_12
XFILLER_146_825 VPWR VGND VPWR VGND sky130_ef_sc_hd__decap_12
X_07080_ cpuregs\[24\]\[28\] cpuregs\[25\]\[28\] cpuregs\[26\]\[28\] cpuregs\[27\]\[28\]
+ net266 net261 VGND VGND VPWR VPWR _03490_ sky130_fd_sc_hd__mux4_1
XFILLER_8_172 VPWR VGND VPWR VGND sky130_ef_sc_hd__decap_12
X_06100_ _01559_ _02570_ VGND VGND VPWR VPWR _02571_ sky130_fd_sc_hd__nand2_1
XFILLER_146_869 VPWR VGND VPWR VGND sky130_ef_sc_hd__decap_12
XFILLER_145_346 VGND VGND VPWR VPWR sky130_fd_sc_hd__fill_1
XFILLER_145_335 VGND VGND VPWR VPWR sky130_fd_sc_hd__fill_1
X_06031_ mem_rdata_q\[15\] net7 _01609_ VGND VGND VPWR VPWR _01109_ sky130_fd_sc_hd__mux2_1
XFILLER_99_433 VGND VGND VPWR VPWR sky130_fd_sc_hd__fill_2
XFILLER_99_488 VGND VGND VPWR VPWR sky130_fd_sc_hd__fill_1
XFILLER_87_617 VPWR VGND VPWR VGND sky130_ef_sc_hd__decap_12
X_07982_ _03804_ _03805_ net34 VGND VGND VPWR VPWR _00684_ sky130_fd_sc_hd__o21a_1
X_09721_ _02696_ cpuregs\[5\]\[27\] _04872_ VGND VGND VPWR VPWR _01377_ sky130_fd_sc_hd__mux2_1
XFILLER_114_799 VPWR VGND VPWR VGND sky130_ef_sc_hd__decap_12
XFILLER_113_287 VGND VGND VPWR VPWR sky130_fd_sc_hd__fill_1
X_06933_ _03346_ _03347_ _03319_ _03323_ VGND VGND VPWR VPWR _03348_ sky130_fd_sc_hd__o211ai_1
XFILLER_101_449 VGND VGND VPWR VPWR sky130_fd_sc_hd__fill_2
X_09652_ _02688_ cpuregs\[22\]\[25\] _04869_ VGND VGND VPWR VPWR _01311_ sky130_fd_sc_hd__mux2_1
X_06864_ cpuregs\[28\]\[20\] cpuregs\[29\]\[20\] cpuregs\[30\]\[20\] cpuregs\[31\]\[20\]
+ net267 _00013_ VGND VGND VPWR VPWR _03282_ sky130_fd_sc_hd__mux4_1
XFILLER_83_823 VGND VGND VPWR VPWR sky130_fd_sc_hd__fill_1
X_09583_ cpuregs\[29\]\[22\] _02675_ _04867_ VGND VGND VPWR VPWR _01244_ sky130_fd_sc_hd__mux2_1
X_05815_ _02102_ _02106_ VGND VGND VPWR VPWR _02378_ sky130_fd_sc_hd__nand2_1
X_06795_ _03188_ _03214_ _03213_ VGND VGND VPWR VPWR _03215_ sky130_fd_sc_hd__o21a_1
XFILLER_55_536 VGND VGND VPWR VPWR sky130_fd_sc_hd__fill_1
XTAP_TAPCELL_ROW_2_359 VGND VPWR sky130_fd_sc_hd__tapvpwrvgnd_1
X_08603_ net125 _01585_ _04297_ _04298_ VGND VGND VPWR VPWR _00812_ sky130_fd_sc_hd__o22a_1
XFILLER_83_889 VGND VGND VPWR VPWR sky130_fd_sc_hd__decap_6
X_05746_ _02133_ _02137_ _02286_ _02313_ _02316_ VGND VGND VPWR VPWR _02317_ sky130_fd_sc_hd__a41o_1
X_08534_ _04231_ _04235_ _02527_ _04227_ VGND VGND VPWR VPWR _04236_ sky130_fd_sc_hd__o211a_1
XFILLER_42_208 VGND VGND VPWR VPWR sky130_fd_sc_hd__decap_8
XFILLER_70_539 VGND VGND VPWR VPWR sky130_fd_sc_hd__fill_1
XFILLER_63_580 VGND VGND VPWR VPWR sky130_fd_sc_hd__decap_8
X_08465_ _00015_ _04194_ _04201_ _01581_ VGND VGND VPWR VPWR _04202_ sky130_fd_sc_hd__a211o_1
XFILLER_51_753 VGND VGND VPWR VPWR sky130_fd_sc_hd__decap_4
XTAP_TAPCELL_ROW_42_1009 VGND VPWR sky130_fd_sc_hd__tapvpwrvgnd_1
X_05677_ _02125_ _02239_ VGND VGND VPWR VPWR _02257_ sky130_fd_sc_hd__nor2_1
XFILLER_149_641 VGND VGND VPWR VPWR sky130_fd_sc_hd__fill_1
XTAP_TAPCELL_ROW_137_2526 VGND VPWR sky130_fd_sc_hd__tapvpwrvgnd_1
X_08396_ count_cycle\[50\] _04144_ _04146_ VGND VGND VPWR VPWR _00757_ sky130_fd_sc_hd__o21a_1
XFILLER_11_617 VGND VGND VPWR VPWR sky130_fd_sc_hd__fill_1
X_07416_ cpuregs\[27\]\[0\] _02586_ _03566_ VGND VGND VPWR VPWR _00356_ sky130_fd_sc_hd__mux2_1
XFILLER_109_505 VGND VGND VPWR VPWR sky130_fd_sc_hd__fill_2
X_07347_ cpuregs\[21\]\[31\] _02712_ net248 VGND VGND VPWR VPWR _00291_ sky130_fd_sc_hd__mux2_1
XFILLER_10_149 VGND VGND VPWR VPWR sky130_fd_sc_hd__fill_1
XFILLER_136_324 VGND VGND VPWR VPWR sky130_fd_sc_hd__decap_8
XFILLER_6_109 VPWR VGND VPWR VGND sky130_ef_sc_hd__decap_12
XTAP_TAPCELL_ROW_21_667 VGND VPWR sky130_fd_sc_hd__tapvpwrvgnd_1
XTAP_TAPCELL_ROW_150_2737 VGND VPWR sky130_fd_sc_hd__tapvpwrvgnd_1
XTAP_TAPCELL_ROW_150_2726 VGND VPWR sky130_fd_sc_hd__tapvpwrvgnd_1
XFILLER_148_195 VGND VGND VPWR VPWR sky130_fd_sc_hd__fill_1
X_07278_ cpuregs\[2\]\[29\] _02704_ net250 VGND VGND VPWR VPWR _00225_ sky130_fd_sc_hd__mux2_1
X_09017_ _01558_ _04680_ net269 VGND VGND VPWR VPWR _04690_ sky130_fd_sc_hd__o21a_1
XFILLER_151_316 VGND VGND VPWR VPWR sky130_fd_sc_hd__decap_4
X_06229_ reg_out\[23\] alu_out_q\[23\] net587 VGND VGND VPWR VPWR _02676_ sky130_fd_sc_hd__mux2_1
XFILLER_88_27 VGND VGND VPWR VPWR sky130_fd_sc_hd__fill_1
XTAP_TAPCELL_ROW_57_1241 VGND VPWR sky130_fd_sc_hd__tapvpwrvgnd_1
XFILLER_120_725 VGND VGND VPWR VPWR sky130_fd_sc_hd__decap_8
XFILLER_144_77 VGND VGND VPWR VPWR sky130_fd_sc_hd__decap_6
X_09919_ clknet_leaf_24_clk _00054_ VGND VGND VPWR VPWR cpuregs\[11\]\[17\] sky130_fd_sc_hd__dfxtp_1
XFILLER_77_149 VPWR VGND VPWR VGND sky130_ef_sc_hd__decap_12
XTAP_TAPCELL_ROW_70_1452 VGND VPWR sky130_fd_sc_hd__tapvpwrvgnd_1
XTAP_TAPCELL_ROW_148_2699 VGND VPWR sky130_fd_sc_hd__tapvpwrvgnd_1
XFILLER_86_683 VPWR VGND VPWR VGND sky130_ef_sc_hd__decap_12
XTAP_TAPCELL_ROW_29_789 VGND VPWR sky130_fd_sc_hd__tapvpwrvgnd_1
XFILLER_61_539 VPWR VGND VPWR VGND sky130_ef_sc_hd__decap_12
XFILLER_27_783 VGND VGND VPWR VPWR sky130_fd_sc_hd__fill_1
XFILLER_14_433 VPWR VGND VPWR VGND sky130_ef_sc_hd__decap_12
XFILLER_14_477 VPWR VGND VPWR VGND sky130_ef_sc_hd__decap_12
XFILLER_14_499 VPWR VGND VPWR VGND sky130_ef_sc_hd__decap_12
X_10625_ clknet_leaf_85_clk _00755_ VGND VGND VPWR VPWR count_cycle\[48\] sky130_fd_sc_hd__dfxtp_1
XFILLER_139_151 VPWR VGND VPWR VGND sky130_ef_sc_hd__decap_12
XFILLER_128_825 VPWR VGND VPWR VGND sky130_ef_sc_hd__decap_12
XFILLER_127_302 VGND VGND VPWR VPWR sky130_fd_sc_hd__decap_8
XTAP_TAPCELL_ROW_40_965 VGND VPWR sky130_fd_sc_hd__tapvpwrvgnd_1
XTAP_TAPCELL_ROW_40_976 VGND VPWR sky130_fd_sc_hd__tapvpwrvgnd_1
XFILLER_128_869 VPWR VGND VPWR VGND sky130_ef_sc_hd__decap_12
X_10556_ clknet_leaf_96_clk _00686_ VGND VGND VPWR VPWR reg_next_pc\[11\] sky130_fd_sc_hd__dfxtp_1
XFILLER_6_654 VGND VGND VPWR VPWR sky130_fd_sc_hd__decap_8
XFILLER_6_643 VGND VGND VPWR VPWR sky130_fd_sc_hd__fill_1
Xpicorv32_308 VGND VGND VPWR VPWR picorv32_308/HI eoi[27] sky130_fd_sc_hd__conb_1
Xpicorv32_319 VGND VGND VPWR VPWR picorv32_319/HI pcpi_insn[2] sky130_fd_sc_hd__conb_1
XFILLER_108_560 VGND VGND VPWR VPWR sky130_fd_sc_hd__decap_6
X_10487_ clknet_leaf_107_clk _00617_ VGND VGND VPWR VPWR count_instr\[36\] sky130_fd_sc_hd__dfxtp_1
XFILLER_45_7 VGND VGND VPWR VPWR sky130_fd_sc_hd__decap_3
XTAP_TAPCELL_ROW_9_470 VGND VPWR sky130_fd_sc_hd__tapvpwrvgnd_1
X_11108_ clknet_leaf_102_clk _00021_ VGND VGND VPWR VPWR cpu_state\[4\] sky130_fd_sc_hd__dfxtp_4
XTAP_TAPCELL_ROW_9_481 VGND VPWR sky130_fd_sc_hd__tapvpwrvgnd_1
XFILLER_2_893 VPWR VGND VPWR VGND sky130_ef_sc_hd__decap_12
XFILLER_84_609 VGND VGND VPWR VPWR sky130_fd_sc_hd__decap_6
XFILLER_68_138 VGND VGND VPWR VPWR sky130_fd_sc_hd__fill_2
XTAP_TAPCELL_ROW_88_1735 VGND VPWR sky130_fd_sc_hd__tapvpwrvgnd_1
X_11039_ clknet_leaf_103_clk _01096_ VGND VGND VPWR VPWR mem_rdata_q\[2\] sky130_fd_sc_hd__dfxtp_1
XFILLER_92_620 VGND VGND VPWR VPWR sky130_fd_sc_hd__decap_3
XTAP_TAPCELL_ROW_88_1746 VGND VPWR sky130_fd_sc_hd__tapvpwrvgnd_1
XFILLER_92_675 VGND VGND VPWR VPWR sky130_fd_sc_hd__decap_8
X_05600_ net193 _01571_ _02182_ VGND VGND VPWR VPWR _02183_ sky130_fd_sc_hd__a21oi_1
XFILLER_64_388 VGND VGND VPWR VPWR sky130_fd_sc_hd__decap_4
X_06580_ decoded_imm\[9\] net202 _02981_ VGND VGND VPWR VPWR _03008_ sky130_fd_sc_hd__a21oi_1
XFILLER_52_539 VGND VGND VPWR VPWR sky130_fd_sc_hd__fill_1
X_05531_ _02102_ _02106_ _02110_ _02113_ VGND VGND VPWR VPWR _02114_ sky130_fd_sc_hd__or4_1
X_08250_ _03720_ _04041_ VGND VGND VPWR VPWR _04052_ sky130_fd_sc_hd__or2_1
X_05462_ cpu_state\[6\] _01860_ _02041_ _02045_ VGND VGND VPWR VPWR _02046_ sky130_fd_sc_hd__a31o_1
XFILLER_60_561 VGND VGND VPWR VPWR sky130_fd_sc_hd__decap_8
X_07201_ cpuregs\[30\]\[19\] _02662_ _03556_ VGND VGND VPWR VPWR _00151_ sky130_fd_sc_hd__mux2_1
X_08181_ _03985_ _03988_ VGND VGND VPWR VPWR _03989_ sky130_fd_sc_hd__and2_1
XTAP_TAPCELL_ROW_119_2234 VGND VPWR sky130_fd_sc_hd__tapvpwrvgnd_1
XFILLER_146_622 VPWR VGND VPWR VGND sky130_ef_sc_hd__decap_12
X_05393_ _01980_ _01981_ VGND VGND VPWR VPWR _01982_ sky130_fd_sc_hd__nand2_1
X_07132_ cpuregs\[12\]\[30\] cpuregs\[13\]\[30\] cpuregs\[14\]\[30\] cpuregs\[15\]\[30\]
+ net265 net260 VGND VGND VPWR VPWR _03540_ sky130_fd_sc_hd__mux4_1
XTAP_TAPCELL_ROW_132_2445 VGND VPWR sky130_fd_sc_hd__tapvpwrvgnd_1
X_07063_ net237 _03458_ _03473_ _03447_ VGND VGND VPWR VPWR _00096_ sky130_fd_sc_hd__a31o_1
Xoutput200 net200 VGND VGND VPWR VPWR pcpi_rs1[7] sky130_fd_sc_hd__buf_2
Xoutput222 net222 VGND VGND VPWR VPWR pcpi_rs2[27] sky130_fd_sc_hd__buf_2
Xoutput211 net211 VGND VGND VPWR VPWR pcpi_rs2[17] sky130_fd_sc_hd__buf_2
X_06014_ net192 _02510_ _01582_ VGND VGND VPWR VPWR net85 sky130_fd_sc_hd__mux2_1
Xoutput233 net233 VGND VGND VPWR VPWR pcpi_rs2[8] sky130_fd_sc_hd__buf_2
XPHY_EDGE_ROW_151_Right_151 VGND VGND VPWR VPWR sky130_fd_sc_hd__decap_3
XFILLER_142_861 VGND VGND VPWR VPWR sky130_fd_sc_hd__decap_6
XFILLER_114_585 VGND VGND VPWR VPWR sky130_fd_sc_hd__decap_3
XFILLER_141_393 VGND VGND VPWR VPWR sky130_fd_sc_hd__decap_6
X_07965_ _03775_ _03779_ _03787_ _03789_ VGND VGND VPWR VPWR _03790_ sky130_fd_sc_hd__o211a_1
XTAP_TAPCELL_ROW_52_1160 VGND VPWR sky130_fd_sc_hd__tapvpwrvgnd_1
X_06916_ cpuregs\[20\]\[22\] cpuregs\[21\]\[22\] cpuregs\[22\]\[22\] cpuregs\[23\]\[22\]
+ net267 net261 VGND VGND VPWR VPWR _03332_ sky130_fd_sc_hd__mux4_1
XFILLER_114_47 VGND VGND VPWR VPWR sky130_fd_sc_hd__fill_1
XTAP_TAPCELL_ROW_52_1171 VGND VPWR sky130_fd_sc_hd__tapvpwrvgnd_1
X_09704_ _02624_ cpuregs\[5\]\[10\] _04872_ VGND VGND VPWR VPWR _01360_ sky130_fd_sc_hd__mux2_1
XFILLER_74_29 VPWR VGND VPWR VGND sky130_ef_sc_hd__decap_12
XFILLER_56_867 VGND VGND VPWR VPWR sky130_fd_sc_hd__fill_1
X_09635_ _02616_ cpuregs\[22\]\[8\] _04869_ VGND VGND VPWR VPWR _01294_ sky130_fd_sc_hd__mux2_1
X_07896_ _03725_ _03726_ VGND VGND VPWR VPWR _03727_ sky130_fd_sc_hd__and2b_1
X_06847_ decoded_imm\[18\] net180 _03238_ VGND VGND VPWR VPWR _03265_ sky130_fd_sc_hd__and3_1
XFILLER_82_141 VPWR VGND VPWR VGND sky130_ef_sc_hd__decap_12
X_06778_ cpuregs\[20\]\[17\] cpuregs\[21\]\[17\] cpuregs\[22\]\[17\] cpuregs\[23\]\[17\]
+ net265 net260 VGND VGND VPWR VPWR _03199_ sky130_fd_sc_hd__mux4_1
X_09566_ cpuregs\[29\]\[5\] _02603_ net239 VGND VGND VPWR VPWR _01227_ sky130_fd_sc_hd__mux2_1
XFILLER_43_539 VGND VGND VPWR VPWR sky130_fd_sc_hd__fill_1
X_05729_ _02124_ _02301_ VGND VGND VPWR VPWR _02302_ sky130_fd_sc_hd__nand2_1
X_09497_ cpuregs\[31\]\[2\] _02590_ net240 VGND VGND VPWR VPWR _01160_ sky130_fd_sc_hd__mux2_1
XTAP_TAPCELL_ROW_26_748 VGND VPWR sky130_fd_sc_hd__tapvpwrvgnd_1
X_08517_ mem_do_wdata net34 _01612_ _04219_ VGND VGND VPWR VPWR _00805_ sky130_fd_sc_hd__a31o_1
XFILLER_51_561 VGND VGND VPWR VPWR sky130_fd_sc_hd__decap_6
X_08448_ _01578_ _04184_ net258 VGND VGND VPWR VPWR _04185_ sky130_fd_sc_hd__o21a_1
XFILLER_11_414 VPWR VGND VPWR VGND sky130_ef_sc_hd__decap_12
XFILLER_11_447 VGND VGND VPWR VPWR sky130_fd_sc_hd__fill_1
XFILLER_23_55 VGND VGND VPWR VPWR sky130_fd_sc_hd__fill_1
X_10410_ clknet_leaf_70_clk _00540_ VGND VGND VPWR VPWR cpuregs\[20\]\[24\] sky130_fd_sc_hd__dfxtp_1
XFILLER_139_55 VGND VGND VPWR VPWR sky130_fd_sc_hd__fill_1
X_08379_ count_cycle\[44\] _04134_ _01549_ VGND VGND VPWR VPWR _04136_ sky130_fd_sc_hd__a21oi_1
XFILLER_149_493 VGND VGND VPWR VPWR sky130_fd_sc_hd__decap_8
X_11390_ clknet_leaf_76_clk _01434_ VGND VGND VPWR VPWR cpuregs\[7\]\[20\] sky130_fd_sc_hd__dfxtp_1
XFILLER_139_77 VGND VGND VPWR VPWR sky130_fd_sc_hd__decap_3
X_10341_ clknet_leaf_76_clk _00471_ VGND VGND VPWR VPWR cpuregs\[16\]\[19\] sky130_fd_sc_hd__dfxtp_1
XFILLER_151_113 VPWR VGND VPWR VGND sky130_ef_sc_hd__decap_12
X_10272_ clknet_leaf_26_clk _00402_ VGND VGND VPWR VPWR cpuregs\[15\]\[14\] sky130_fd_sc_hd__dfxtp_1
XFILLER_3_3 VPWR VGND VPWR VGND sky130_ef_sc_hd__decap_12
XFILLER_2_189 VGND VGND VPWR VPWR sky130_fd_sc_hd__decap_6
XFILLER_48_41 VPWR VGND VPWR VGND sky130_ef_sc_hd__decap_12
XFILLER_48_85 VGND VGND VPWR VPWR sky130_fd_sc_hd__fill_2
XFILLER_19_503 VGND VGND VPWR VPWR sky130_fd_sc_hd__fill_1
XFILLER_48_96 VGND VGND VPWR VPWR sky130_fd_sc_hd__decap_3
XFILLER_0_15 VPWR VGND VPWR VGND sky130_ef_sc_hd__decap_12
XFILLER_47_889 VGND VGND VPWR VPWR sky130_fd_sc_hd__decap_6
XFILLER_74_697 VGND VGND VPWR VPWR sky130_fd_sc_hd__decap_3
XFILLER_73_163 VGND VGND VPWR VPWR sky130_fd_sc_hd__decap_4
XFILLER_34_539 VGND VGND VPWR VPWR sky130_fd_sc_hd__fill_1
XTAP_TAPCELL_ROW_83_1665 VGND VPWR sky130_fd_sc_hd__tapvpwrvgnd_1
XTAP_TAPCELL_ROW_83_1654 VGND VPWR sky130_fd_sc_hd__tapvpwrvgnd_1
XPHY_EDGE_ROW_14_Left_168 VGND VGND VPWR VPWR sky130_fd_sc_hd__decap_3
XFILLER_15_797 VPWR VGND VPWR VGND sky130_ef_sc_hd__decap_12
XFILLER_9_57 VPWR VGND VPWR VGND sky130_ef_sc_hd__decap_12
XFILLER_80_83 VGND VGND VPWR VPWR sky130_fd_sc_hd__fill_1
X_10608_ clknet_leaf_81_clk _00738_ VGND VGND VPWR VPWR count_cycle\[31\] sky130_fd_sc_hd__dfxtp_1
XFILLER_128_699 VGND VGND VPWR VPWR sky130_fd_sc_hd__fill_1
X_10539_ clknet_leaf_64_clk _00669_ VGND VGND VPWR VPWR reg_pc\[25\] sky130_fd_sc_hd__dfxtp_1
XFILLER_142_124 VGND VGND VPWR VPWR sky130_fd_sc_hd__fill_2
XTAP_TAPCELL_ROW_114_2153 VGND VPWR sky130_fd_sc_hd__tapvpwrvgnd_1
XFILLER_142_157 VGND VGND VPWR VPWR sky130_fd_sc_hd__decap_8
XFILLER_131_809 VPWR VGND VPWR VGND sky130_ef_sc_hd__decap_12
XFILLER_124_861 VGND VGND VPWR VPWR sky130_fd_sc_hd__decap_6
XPHY_EDGE_ROW_23_Left_177 VGND VGND VPWR VPWR sky130_fd_sc_hd__decap_3
XFILLER_97_723 VGND VGND VPWR VPWR sky130_fd_sc_hd__decap_4
XFILLER_69_425 VGND VGND VPWR VPWR sky130_fd_sc_hd__fill_2
XFILLER_36_3 VPWR VGND VPWR VGND sky130_ef_sc_hd__decap_12
XFILLER_123_393 VGND VGND VPWR VPWR sky130_fd_sc_hd__fill_2
XFILLER_97_778 VGND VGND VPWR VPWR sky130_fd_sc_hd__decap_6
XFILLER_111_577 VGND VGND VPWR VPWR sky130_fd_sc_hd__decap_3
X_04962_ instr_ori instr_xori instr_addi instr_bgeu VGND VGND VPWR VPWR _01592_ sky130_fd_sc_hd__or4_1
X_07750_ count_instr\[36\] _03639_ _01549_ VGND VGND VPWR VPWR _03641_ sky130_fd_sc_hd__a21oi_1
X_06701_ net258 _03123_ _00016_ VGND VGND VPWR VPWR _03125_ sky130_fd_sc_hd__o21a_1
XFILLER_84_439 VPWR VGND VPWR VGND sky130_ef_sc_hd__decap_12
XFILLER_37_333 VGND VGND VPWR VPWR sky130_fd_sc_hd__decap_3
X_07681_ count_instr\[11\] net443 _01549_ VGND VGND VPWR VPWR _03597_ sky130_fd_sc_hd__a21oi_1
XFILLER_64_141 VPWR VGND VPWR VGND sky130_ef_sc_hd__decap_12
XFILLER_38_889 VGND VGND VPWR VPWR sky130_fd_sc_hd__decap_3
X_09420_ _02683_ cpuregs\[18\]\[24\] _04862_ VGND VGND VPWR VPWR _01054_ sky130_fd_sc_hd__mux2_1
X_06632_ _03056_ _03057_ VGND VGND VPWR VPWR _03058_ sky130_fd_sc_hd__nand2_1
XFILLER_65_686 VGND VGND VPWR VPWR sky130_fd_sc_hd__decap_8
X_09351_ decoded_imm\[20\] _04746_ _04825_ _04837_ VGND VGND VPWR VPWR _01010_ sky130_fd_sc_hd__o22a_1
XPHY_EDGE_ROW_32_Left_186 VGND VGND VPWR VPWR sky130_fd_sc_hd__decap_3
X_06563_ cpuregs\[16\]\[9\] cpuregs\[17\]\[9\] cpuregs\[18\]\[9\] cpuregs\[19\]\[9\]
+ net263 net259 VGND VGND VPWR VPWR _02992_ sky130_fd_sc_hd__mux4_1
X_05514_ _02096_ VGND VGND VPWR VPWR _02097_ sky130_fd_sc_hd__inv_2
XFILLER_100_27 VGND VGND VPWR VPWR sky130_fd_sc_hd__fill_1
X_08302_ _04085_ _04086_ VGND VGND VPWR VPWR _00723_ sky130_fd_sc_hd__nor2_1
X_09282_ net138 net100 _04206_ VGND VGND VPWR VPWR _00968_ sky130_fd_sc_hd__mux2_1
XTAP_TAPCELL_ROW_23_707 VGND VPWR sky130_fd_sc_hd__tapvpwrvgnd_1
XFILLER_33_561 VGND VGND VPWR VPWR sky130_fd_sc_hd__decap_3
X_08233_ _04032_ _04035_ instr_jal VGND VGND VPWR VPWR _04037_ sky130_fd_sc_hd__o21a_1
XFILLER_100_49 VGND VGND VPWR VPWR sky130_fd_sc_hd__decap_8
XFILLER_20_222 VGND VGND VPWR VPWR sky130_fd_sc_hd__fill_2
X_06494_ decoded_imm\[7\] net200 VGND VGND VPWR VPWR _02925_ sky130_fd_sc_hd__and2_1
X_05445_ _02016_ _02029_ _02028_ _02027_ VGND VGND VPWR VPWR _02030_ sky130_fd_sc_hd__o211ai_2
X_08164_ net34 _03973_ VGND VGND VPWR VPWR _00698_ sky130_fd_sc_hd__and2_1
X_05376_ _01674_ _01965_ _01966_ net187 cpu_state\[4\] VGND VGND VPWR VPWR _01967_
+ sky130_fd_sc_hd__a32o_1
XFILLER_107_839 VGND VGND VPWR VPWR sky130_fd_sc_hd__fill_1
X_08095_ decoded_imm_j\[17\] _03704_ _03900_ VGND VGND VPWR VPWR _03910_ sky130_fd_sc_hd__a21oi_1
X_07115_ _02714_ _03506_ _03507_ _03508_ _03523_ VGND VGND VPWR VPWR _03524_ sky130_fd_sc_hd__o41a_1
XFILLER_106_338 VGND VGND VPWR VPWR sky130_fd_sc_hd__decap_8
X_07046_ _02714_ _03454_ _03456_ VGND VGND VPWR VPWR _03457_ sky130_fd_sc_hd__or3_1
Xclkload70 clknet_leaf_58_clk VGND VGND VPWR VPWR clkload70/Y sky130_fd_sc_hd__inv_6
XPHY_EDGE_ROW_41_Left_195 VGND VGND VPWR VPWR sky130_fd_sc_hd__decap_3
XTAP_TAPCELL_ROW_54_1200 VGND VPWR sky130_fd_sc_hd__tapvpwrvgnd_1
Xclkload92 clknet_leaf_100_clk VGND VGND VPWR VPWR clkload92/X sky130_fd_sc_hd__clkbuf_4
Xclkload81 clknet_leaf_119_clk VGND VGND VPWR VPWR clkload81/Y sky130_fd_sc_hd__clkinvlp_4
XFILLER_102_500 VGND VGND VPWR VPWR sky130_fd_sc_hd__decap_4
XFILLER_88_712 VGND VGND VPWR VPWR sky130_fd_sc_hd__fill_1
XFILLER_87_200 VPWR VGND VPWR VGND sky130_ef_sc_hd__decap_12
XFILLER_125_57 VGND VGND VPWR VPWR sky130_fd_sc_hd__fill_2
XFILLER_102_533 VPWR VGND VPWR VGND sky130_ef_sc_hd__decap_12
X_08997_ cpuregs\[20\]\[28\] cpuregs\[21\]\[28\] cpuregs\[22\]\[28\] cpuregs\[23\]\[28\]
+ net280 net274 VGND VGND VPWR VPWR _04671_ sky130_fd_sc_hd__mux4_1
XTAP_TAPCELL_ROW_145_2658 VGND VPWR sky130_fd_sc_hd__tapvpwrvgnd_1
XTAP_TAPCELL_ROW_145_2647 VGND VPWR sky130_fd_sc_hd__tapvpwrvgnd_1
XFILLER_68_480 VGND VGND VPWR VPWR sky130_fd_sc_hd__fill_1
X_07948_ decoded_imm_j\[7\] _03694_ VGND VGND VPWR VPWR _03774_ sky130_fd_sc_hd__nand2_1
X_07879_ reg_pc\[27\] _01624_ _01628_ _03714_ VGND VGND VPWR VPWR _00671_ sky130_fd_sc_hd__a22o_1
XFILLER_18_77 VGND VGND VPWR VPWR sky130_fd_sc_hd__decap_6
XFILLER_29_889 VGND VGND VPWR VPWR sky130_fd_sc_hd__decap_6
X_09618_ _02683_ cpuregs\[3\]\[24\] _04868_ VGND VGND VPWR VPWR _01278_ sky130_fd_sc_hd__mux2_1
XFILLER_83_494 VGND VGND VPWR VPWR sky130_fd_sc_hd__decap_8
X_10890_ clknet_leaf_100_clk _00952_ VGND VGND VPWR VPWR is_compare sky130_fd_sc_hd__dfxtp_1
XFILLER_43_325 VGND VGND VPWR VPWR sky130_fd_sc_hd__decap_8
X_09549_ cpuregs\[23\]\[21\] _02670_ _04866_ VGND VGND VPWR VPWR _01211_ sky130_fd_sc_hd__mux2_1
XTAP_TAPCELL_ROW_65_1373 VGND VPWR sky130_fd_sc_hd__tapvpwrvgnd_1
XFILLER_140_3 VPWR VGND VPWR VGND sky130_ef_sc_hd__decap_12
XFILLER_51_391 VGND VGND VPWR VPWR sky130_fd_sc_hd__fill_1
XFILLER_109_121 VGND VGND VPWR VPWR sky130_fd_sc_hd__decap_8
X_11442_ clknet_leaf_146_clk _01486_ VGND VGND VPWR VPWR cpuregs\[0\]\[8\] sky130_fd_sc_hd__dfxtp_1
XFILLER_50_53 VPWR VGND VPWR VGND sky130_ef_sc_hd__decap_12
X_11373_ clknet_leaf_141_clk _01417_ VGND VGND VPWR VPWR cpuregs\[7\]\[3\] sky130_fd_sc_hd__dfxtp_1
XFILLER_50_97 VGND VGND VPWR VPWR sky130_fd_sc_hd__fill_1
X_10324_ clknet_leaf_119_clk _00454_ VGND VGND VPWR VPWR cpuregs\[16\]\[2\] sky130_fd_sc_hd__dfxtp_1
X_10255_ clknet_leaf_34_clk _00385_ VGND VGND VPWR VPWR cpuregs\[27\]\[29\] sky130_fd_sc_hd__dfxtp_1
X_10186_ clknet_leaf_70_clk _00316_ VGND VGND VPWR VPWR cpuregs\[9\]\[24\] sky130_fd_sc_hd__dfxtp_1
XFILLER_121_853 VPWR VGND VPWR VGND sky130_ef_sc_hd__decap_12
XFILLER_121_897 VPWR VGND VPWR VGND sky130_ef_sc_hd__decap_12
XFILLER_120_352 VPWR VGND VPWR VGND sky130_ef_sc_hd__decap_12
XFILLER_93_225 VGND VGND VPWR VPWR sky130_fd_sc_hd__fill_1
XFILLER_46_141 VGND VGND VPWR VPWR sky130_fd_sc_hd__decap_8
XFILLER_74_494 VGND VGND VPWR VPWR sky130_fd_sc_hd__decap_8
XFILLER_62_601 VGND VGND VPWR VPWR sky130_fd_sc_hd__decap_6
XFILLER_34_303 VGND VGND VPWR VPWR sky130_fd_sc_hd__decap_4
XFILLER_62_656 VGND VGND VPWR VPWR sky130_fd_sc_hd__decap_4
XFILLER_50_829 VGND VGND VPWR VPWR sky130_fd_sc_hd__fill_2
XFILLER_15_561 VPWR VGND VPWR VGND sky130_ef_sc_hd__decap_12
XFILLER_147_205 VPWR VGND VPWR VGND sky130_ef_sc_hd__decap_12
X_05230_ _01821_ _01830_ VGND VGND VPWR VPWR _01832_ sky130_fd_sc_hd__nand2_1
XFILLER_116_603 VGND VGND VPWR VPWR sky130_fd_sc_hd__decap_8
X_05161_ _01766_ _01767_ VGND VGND VPWR VPWR _01768_ sky130_fd_sc_hd__nand2_1
XTAP_TAPCELL_ROW_96_1867 VGND VPWR sky130_fd_sc_hd__tapvpwrvgnd_1
X_05092_ reg_pc\[3\] decoded_imm\[3\] VGND VGND VPWR VPWR _01704_ sky130_fd_sc_hd__nand2_1
X_08920_ net270 _04597_ VGND VGND VPWR VPWR _04598_ sky130_fd_sc_hd__or2_1
XFILLER_131_617 VGND VGND VPWR VPWR sky130_fd_sc_hd__decap_4
XFILLER_124_680 VGND VGND VPWR VPWR sky130_fd_sc_hd__fill_1
X_08851_ cpuregs\[8\]\[20\] cpuregs\[9\]\[20\] cpuregs\[10\]\[20\] cpuregs\[11\]\[20\]
+ net280 net274 VGND VGND VPWR VPWR _04533_ sky130_fd_sc_hd__mux4_1
XFILLER_130_127 VPWR VGND VPWR VGND sky130_ef_sc_hd__decap_12
X_07802_ _03673_ net34 _03672_ VGND VGND VPWR VPWR _00636_ sky130_fd_sc_hd__and3b_1
XFILLER_111_374 VGND VGND VPWR VPWR sky130_fd_sc_hd__fill_1
X_05994_ net181 _02500_ _01582_ VGND VGND VPWR VPWR net75 sky130_fd_sc_hd__mux2_1
X_08782_ _01558_ _04465_ _01560_ VGND VGND VPWR VPWR _04468_ sky130_fd_sc_hd__o21a_1
XFILLER_57_428 VGND VGND VPWR VPWR sky130_fd_sc_hd__decap_6
XTAP_TAPCELL_ROW_127_2366 VGND VPWR sky130_fd_sc_hd__tapvpwrvgnd_1
X_07733_ _03629_ _03630_ VGND VGND VPWR VPWR _00610_ sky130_fd_sc_hd__nor2_1
XFILLER_84_247 VGND VGND VPWR VPWR sky130_fd_sc_hd__decap_4
X_04945_ net260 VGND VGND VPWR VPWR _01578_ sky130_fd_sc_hd__clkinv_4
XFILLER_26_804 VGND VGND VPWR VPWR sky130_fd_sc_hd__decap_8
XFILLER_52_100 VGND VGND VPWR VPWR sky130_fd_sc_hd__fill_1
X_07664_ _03585_ _03586_ VGND VGND VPWR VPWR _00585_ sky130_fd_sc_hd__nor2_1
XFILLER_26_837 VPWR VGND VPWR VGND sky130_ef_sc_hd__decap_12
XTAP_TAPCELL_ROW_140_2566 VGND VPWR sky130_fd_sc_hd__tapvpwrvgnd_1
X_06615_ cpuregs\[16\]\[11\] cpuregs\[17\]\[11\] cpuregs\[18\]\[11\] cpuregs\[19\]\[11\]
+ net268 net259 VGND VGND VPWR VPWR _03042_ sky130_fd_sc_hd__mux4_1
X_09403_ _02612_ cpuregs\[18\]\[7\] _04862_ VGND VGND VPWR VPWR _01037_ sky130_fd_sc_hd__mux2_1
XTAP_TAPCELL_ROW_140_2577 VGND VPWR sky130_fd_sc_hd__tapvpwrvgnd_1
X_07595_ cpuregs\[20\]\[12\] _02633_ net245 VGND VGND VPWR VPWR _00528_ sky130_fd_sc_hd__mux2_1
XFILLER_52_177 VGND VGND VPWR VPWR sky130_fd_sc_hd__decap_4
X_09334_ mem_rdata_q\[28\] _01589_ VGND VGND VPWR VPWR _04829_ sky130_fd_sc_hd__and2_1
XFILLER_34_892 VPWR VGND VPWR VGND sky130_ef_sc_hd__decap_12
X_06546_ _00015_ _02972_ _02975_ _02735_ VGND VGND VPWR VPWR _02976_ sky130_fd_sc_hd__o211a_1
XTAP_TAPCELL_ROW_47_1081 VGND VPWR sky130_fd_sc_hd__tapvpwrvgnd_1
XFILLER_21_564 VGND VGND VPWR VPWR sky130_fd_sc_hd__decap_8
X_09265_ mem_do_wdata _01584_ _04807_ VGND VGND VPWR VPWR _04808_ sky130_fd_sc_hd__o21ai_1
X_06477_ cpuregs\[16\]\[6\] cpuregs\[17\]\[6\] cpuregs\[18\]\[6\] cpuregs\[19\]\[6\]
+ net263 net259 VGND VGND VPWR VPWR _02909_ sky130_fd_sc_hd__mux4_1
XFILLER_138_238 VGND VGND VPWR VPWR sky130_fd_sc_hd__decap_3
X_08216_ _04010_ _04014_ _04019_ VGND VGND VPWR VPWR _04021_ sky130_fd_sc_hd__a21oi_1
X_05428_ cpu_state\[3\] _02009_ _02013_ _02014_ VGND VGND VPWR VPWR _04898_ sky130_fd_sc_hd__a211o_1
X_09196_ decoded_rd\[0\] _01101_ _02513_ VGND VGND VPWR VPWR _00898_ sky130_fd_sc_hd__mux2_1
XTAP_TAPCELL_ROW_60_1292 VGND VPWR sky130_fd_sc_hd__tapvpwrvgnd_1
XFILLER_147_783 VGND VGND VPWR VPWR sky130_fd_sc_hd__fill_1
X_08147_ _03956_ _03957_ VGND VGND VPWR VPWR _03958_ sky130_fd_sc_hd__or2_1
X_05359_ count_cycle\[23\] _01588_ _01674_ _01950_ VGND VGND VPWR VPWR _01951_ sky130_fd_sc_hd__o211a_1
X_08078_ _03893_ _03800_ _03892_ VGND VGND VPWR VPWR _03894_ sky130_fd_sc_hd__o21a_1
X_07029_ _03432_ _03433_ _03439_ _03440_ _01579_ _01581_ VGND VGND VPWR VPWR _03441_
+ sky130_fd_sc_hd__mux4_1
XFILLER_134_477 VGND VGND VPWR VPWR sky130_fd_sc_hd__decap_8
XFILLER_103_820 VPWR VGND VPWR VGND sky130_ef_sc_hd__decap_12
XFILLER_96_38 VGND VGND VPWR VPWR sky130_fd_sc_hd__decap_4
XFILLER_96_27 VGND VGND VPWR VPWR sky130_fd_sc_hd__fill_1
XFILLER_88_531 VGND VGND VPWR VPWR sky130_fd_sc_hd__fill_1
XFILLER_88_520 VGND VGND VPWR VPWR sky130_fd_sc_hd__fill_1
X_10040_ clknet_leaf_2_clk _00170_ VGND VGND VPWR VPWR cpuregs\[13\]\[6\] sky130_fd_sc_hd__dfxtp_1
XFILLER_152_77 VGND VGND VPWR VPWR sky130_fd_sc_hd__decap_6
XFILLER_28_141 VGND VGND VPWR VPWR sky130_fd_sc_hd__fill_1
XFILLER_29_664 VGND VGND VPWR VPWR sky130_fd_sc_hd__decap_8
XFILLER_91_729 VGND VGND VPWR VPWR sky130_fd_sc_hd__fill_1
X_10942_ clknet_leaf_95_clk _01004_ VGND VGND VPWR VPWR decoded_imm\[26\] sky130_fd_sc_hd__dfxtp_2
XTAP_TAPCELL_ROW_67_1402 VGND VPWR sky130_fd_sc_hd__tapvpwrvgnd_1
XFILLER_44_623 VGND VGND VPWR VPWR sky130_fd_sc_hd__decap_4
XFILLER_45_31 VPWR VGND VPWR VGND sky130_ef_sc_hd__decap_12
XFILLER_71_420 VGND VGND VPWR VPWR sky130_fd_sc_hd__decap_6
XFILLER_43_111 VGND VGND VPWR VPWR sky130_fd_sc_hd__fill_1
XFILLER_44_645 VGND VGND VPWR VPWR sky130_fd_sc_hd__decap_4
XFILLER_44_667 VGND VGND VPWR VPWR sky130_fd_sc_hd__decap_3
X_10873_ clknet_leaf_23_clk _00935_ VGND VGND VPWR VPWR cpuregs\[1\]\[17\] sky130_fd_sc_hd__dfxtp_1
XTAP_TAPCELL_ROW_80_1613 VGND VPWR sky130_fd_sc_hd__tapvpwrvgnd_1
XFILLER_24_380 VGND VGND VPWR VPWR sky130_fd_sc_hd__fill_1
XFILLER_8_502 VPWR VGND VPWR VGND sky130_ef_sc_hd__decap_12
XTAP_TAPCELL_ROW_14_548 VGND VPWR sky130_fd_sc_hd__tapvpwrvgnd_1
XTAP_TAPCELL_ROW_14_559 VGND VPWR sky130_fd_sc_hd__tapvpwrvgnd_1
XFILLER_40_862 VGND VGND VPWR VPWR sky130_fd_sc_hd__decap_6
XFILLER_8_524 VGND VGND VPWR VPWR sky130_fd_sc_hd__decap_8
X_11425_ clknet_leaf_49_clk _01469_ VGND VGND VPWR VPWR cpuregs\[8\]\[23\] sky130_fd_sc_hd__dfxtp_1
XANTENNA_7 _02649_ VGND VGND VPWR VPWR sky130_fd_sc_hd__diode_2
XFILLER_153_742 VGND VGND VPWR VPWR sky130_fd_sc_hd__decap_3
X_11356_ clknet_leaf_42_clk _01400_ VGND VGND VPWR VPWR cpuregs\[6\]\[18\] sky130_fd_sc_hd__dfxtp_1
XTAP_TAPCELL_ROW_111_2112 VGND VPWR sky130_fd_sc_hd__tapvpwrvgnd_1
XTAP_TAPCELL_ROW_111_2101 VGND VPWR sky130_fd_sc_hd__tapvpwrvgnd_1
XTAP_TAPCELL_ROW_78_1586 VGND VPWR sky130_fd_sc_hd__tapvpwrvgnd_1
XTAP_TAPCELL_ROW_78_1575 VGND VPWR sky130_fd_sc_hd__tapvpwrvgnd_1
XFILLER_153_797 VGND VGND VPWR VPWR sky130_fd_sc_hd__decap_4
XFILLER_113_617 VGND VGND VPWR VPWR sky130_fd_sc_hd__decap_8
X_10307_ clknet_leaf_21_clk _00437_ VGND VGND VPWR VPWR cpuregs\[26\]\[17\] sky130_fd_sc_hd__dfxtp_1
X_11287_ clknet_leaf_19_clk _01334_ VGND VGND VPWR VPWR cpuregs\[4\]\[16\] sky130_fd_sc_hd__dfxtp_1
XFILLER_3_273 VGND VGND VPWR VPWR sky130_fd_sc_hd__decap_6
XTAP_TAPCELL_ROW_91_1786 VGND VPWR sky130_fd_sc_hd__tapvpwrvgnd_1
X_10238_ clknet_leaf_10_clk _00368_ VGND VGND VPWR VPWR cpuregs\[27\]\[12\] sky130_fd_sc_hd__dfxtp_1
XFILLER_39_406 VGND VGND VPWR VPWR sky130_fd_sc_hd__decap_4
XFILLER_94_545 VGND VGND VPWR VPWR sky130_fd_sc_hd__decap_4
X_10169_ clknet_leaf_145_clk _00299_ VGND VGND VPWR VPWR cpuregs\[9\]\[7\] sky130_fd_sc_hd__dfxtp_1
XTAP_TAPCELL_ROW_109_2074 VGND VPWR sky130_fd_sc_hd__tapvpwrvgnd_1
XFILLER_66_269 VGND VGND VPWR VPWR sky130_fd_sc_hd__fill_1
XFILLER_82_729 VGND VGND VPWR VPWR sky130_fd_sc_hd__fill_1
XFILLER_75_781 VGND VGND VPWR VPWR sky130_fd_sc_hd__decap_3
Xrebuffer19 net404 VGND VGND VPWR VPWR net405 sky130_fd_sc_hd__dlymetal6s4s_1
XTAP_TAPCELL_ROW_122_2285 VGND VPWR sky130_fd_sc_hd__tapvpwrvgnd_1
XFILLER_62_475 VGND VGND VPWR VPWR sky130_fd_sc_hd__fill_1
X_06400_ reg_pc\[3\] _02751_ _02834_ _02735_ _02715_ VGND VGND VPWR VPWR _02835_ sky130_fd_sc_hd__a221o_1
XPHY_EDGE_ROW_106_Left_260 VGND VGND VPWR VPWR sky130_fd_sc_hd__decap_3
XFILLER_90_795 VGND VGND VPWR VPWR sky130_fd_sc_hd__fill_1
X_07380_ _02712_ cpuregs\[9\]\[31\] _03563_ VGND VGND VPWR VPWR _00323_ sky130_fd_sc_hd__mux2_1
XFILLER_16_881 VPWR VGND VPWR VGND sky130_ef_sc_hd__decap_12
XFILLER_22_317 VGND VGND VPWR VPWR sky130_fd_sc_hd__fill_2
XTAP_TAPCELL_ROW_33_857 VGND VPWR sky130_fd_sc_hd__tapvpwrvgnd_1
X_06331_ net182 decoded_imm\[1\] VGND VGND VPWR VPWR _02768_ sky130_fd_sc_hd__xor2_2
X_06262_ _02701_ _02702_ VGND VGND VPWR VPWR _02703_ sky130_fd_sc_hd__nor2_1
XTAP_TAPCELL_ROW_98_1907 VGND VPWR sky130_fd_sc_hd__tapvpwrvgnd_1
X_09050_ cpuregs\[12\]\[31\] cpuregs\[13\]\[31\] cpuregs\[14\]\[31\] cpuregs\[15\]\[31\]
+ net277 net272 VGND VGND VPWR VPWR _04721_ sky130_fd_sc_hd__mux4_1
XFILLER_31_895 VGND VGND VPWR VPWR sky130_fd_sc_hd__fill_1
X_08001_ _03807_ _03819_ _03821_ VGND VGND VPWR VPWR _03823_ sky130_fd_sc_hd__and3_1
X_05213_ _01767_ _01781_ _01779_ VGND VGND VPWR VPWR _01816_ sky130_fd_sc_hd__o21a_1
XFILLER_129_783 VGND VGND VPWR VPWR sky130_fd_sc_hd__fill_1
X_06193_ reg_out\[16\] alu_out_q\[16\] net594 VGND VGND VPWR VPWR _02647_ sky130_fd_sc_hd__mux2_1
XFILLER_144_753 VGND VGND VPWR VPWR sky130_fd_sc_hd__decap_3
X_05144_ cpu_state\[4\] net199 _01749_ cpu_state\[6\] _01752_ VGND VGND VPWR VPWR
+ _01753_ sky130_fd_sc_hd__a221o_1
Xmax_cap243 _04864_ VGND VGND VPWR VPWR net243 sky130_fd_sc_hd__buf_6
Xmax_cap265 net267 VGND VGND VPWR VPWR net265 sky130_fd_sc_hd__buf_12
XFILLER_116_477 VPWR VGND VPWR VGND sky130_ef_sc_hd__decap_12
XFILLER_104_606 VGND VGND VPWR VPWR sky130_fd_sc_hd__fill_1
X_09952_ clknet_leaf_18_clk _00082_ VGND VGND VPWR VPWR net175 sky130_fd_sc_hd__dfxtp_4
Xmax_cap254 _02720_ VGND VGND VPWR VPWR net254 sky130_fd_sc_hd__buf_6
Xmax_cap276 net277 VGND VGND VPWR VPWR net276 sky130_fd_sc_hd__buf_12
X_05075_ net606 cpu_state\[4\] _01683_ cpu_state\[6\] _01686_ VGND VGND VPWR VPWR
+ _01689_ sky130_fd_sc_hd__a221o_1
X_08903_ cpuregs\[12\]\[23\] cpuregs\[13\]\[23\] cpuregs\[14\]\[23\] cpuregs\[15\]\[23\]
+ net276 net272 VGND VGND VPWR VPWR _04582_ sky130_fd_sc_hd__mux4_1
XFILLER_106_26 VGND VGND VPWR VPWR sky130_fd_sc_hd__fill_2
XFILLER_106_15 VGND VGND VPWR VPWR sky130_fd_sc_hd__decap_3
X_09883_ cpuregs\[0\]\[13\] VGND VGND VPWR VPWR _01491_ sky130_fd_sc_hd__clkbuf_1
X_08834_ cpuregs\[0\]\[19\] cpuregs\[1\]\[19\] cpuregs\[2\]\[19\] cpuregs\[3\]\[19\]
+ net280 net274 VGND VGND VPWR VPWR _04517_ sky130_fd_sc_hd__mux4_1
XFILLER_98_895 VGND VGND VPWR VPWR sky130_fd_sc_hd__fill_1
XFILLER_57_225 VGND VGND VPWR VPWR sky130_fd_sc_hd__decap_6
XTAP_TAPCELL_ROW_142_2606 VGND VPWR sky130_fd_sc_hd__tapvpwrvgnd_1
XFILLER_85_567 VGND VGND VPWR VPWR sky130_fd_sc_hd__decap_3
XFILLER_85_545 VGND VGND VPWR VPWR sky130_fd_sc_hd__decap_4
X_08765_ _04444_ _04450_ _04451_ _01560_ _00010_ VGND VGND VPWR VPWR _04452_ sky130_fd_sc_hd__a221o_1
X_07716_ _03618_ _03619_ VGND VGND VPWR VPWR _00604_ sky130_fd_sc_hd__nor2_1
XFILLER_73_729 VGND VGND VPWR VPWR sky130_fd_sc_hd__fill_2
X_05977_ reg_out\[11\] reg_next_pc\[11\] net596 VGND VGND VPWR VPWR _02492_ sky130_fd_sc_hd__mux2_2
XTAP_TAPCELL_ROW_49_1110 VGND VPWR sky130_fd_sc_hd__tapvpwrvgnd_1
XFILLER_82_29 VPWR VGND VPWR VGND sky130_ef_sc_hd__decap_12
X_04928_ net172 VGND VGND VPWR VPWR _01561_ sky130_fd_sc_hd__inv_2
X_08696_ cpuregs\[20\]\[12\] cpuregs\[21\]\[12\] cpuregs\[22\]\[12\] cpuregs\[23\]\[12\]
+ net278 net273 VGND VGND VPWR VPWR _04386_ sky130_fd_sc_hd__mux4_1
XTAP_TAPCELL_ROW_49_1121 VGND VPWR sky130_fd_sc_hd__tapvpwrvgnd_1
XFILLER_25_122 VGND VGND VPWR VPWR sky130_fd_sc_hd__decap_8
XFILLER_26_634 VGND VGND VPWR VPWR sky130_fd_sc_hd__decap_8
XFILLER_26_645 VGND VGND VPWR VPWR sky130_fd_sc_hd__decap_6
X_07647_ _02712_ cpuregs\[17\]\[31\] _03574_ VGND VGND VPWR VPWR _00579_ sky130_fd_sc_hd__mux2_1
XFILLER_53_475 VGND VGND VPWR VPWR sky130_fd_sc_hd__decap_8
XFILLER_25_155 VPWR VGND VPWR VGND sky130_ef_sc_hd__decap_12
X_07578_ cpuregs\[25\]\[29\] _02704_ _03571_ VGND VGND VPWR VPWR _00513_ sky130_fd_sc_hd__mux2_1
XTAP_TAPCELL_ROW_62_1321 VGND VPWR sky130_fd_sc_hd__tapvpwrvgnd_1
XFILLER_40_125 VPWR VGND VPWR VGND sky130_ef_sc_hd__decap_12
XFILLER_139_514 VGND VGND VPWR VPWR sky130_fd_sc_hd__fill_1
X_06529_ net200 _02721_ VGND VGND VPWR VPWR _02959_ sky130_fd_sc_hd__or2_1
X_09317_ reg_sh\[0\] _01642_ VGND VGND VPWR VPWR _04817_ sky130_fd_sc_hd__nor2_1
XFILLER_139_547 VPWR VGND VPWR VGND sky130_ef_sc_hd__decap_12
XTAP_TAPCELL_ROW_11_507 VGND VPWR sky130_fd_sc_hd__tapvpwrvgnd_1
XFILLER_21_350 VPWR VGND VPWR VGND sky130_ef_sc_hd__decap_12
XFILLER_127_709 VGND VGND VPWR VPWR sky130_fd_sc_hd__fill_1
X_09248_ cpuregs\[1\]\[27\] _02696_ net244 VGND VGND VPWR VPWR _00945_ sky130_fd_sc_hd__mux2_1
XFILLER_5_505 VPWR VGND VPWR VGND sky130_ef_sc_hd__decap_12
XTAP_TAPCELL_ROW_153_2779 VGND VPWR sky130_fd_sc_hd__tapvpwrvgnd_1
XFILLER_119_271 VGND VGND VPWR VPWR sky130_fd_sc_hd__decap_8
X_09179_ decoded_imm_j\[5\] _01119_ _02513_ VGND VGND VPWR VPWR _00887_ sky130_fd_sc_hd__mux2_1
XFILLER_31_55 VGND VGND VPWR VPWR sky130_fd_sc_hd__fill_1
Xclkbuf_4_10_0_clk clknet_0_clk VGND VGND VPWR VPWR clknet_4_10_0_clk sky130_fd_sc_hd__clkbuf_8
XFILLER_147_55 VGND VGND VPWR VPWR sky130_fd_sc_hd__fill_1
XFILLER_107_433 VGND VGND VPWR VPWR sky130_fd_sc_hd__decap_6
X_11210_ clknet_leaf_141_clk _01257_ VGND VGND VPWR VPWR cpuregs\[3\]\[3\] sky130_fd_sc_hd__dfxtp_1
XFILLER_150_701 VGND VGND VPWR VPWR sky130_fd_sc_hd__decap_8
XFILLER_135_797 VPWR VGND VPWR VGND sky130_ef_sc_hd__decap_12
X_11141_ clknet_leaf_24_clk _01188_ VGND VGND VPWR VPWR cpuregs\[31\]\[30\] sky130_fd_sc_hd__dfxtp_1
Xoutput44 net44 VGND VGND VPWR VPWR mem_addr[19] sky130_fd_sc_hd__buf_2
XFILLER_0_221 VGND VGND VPWR VPWR sky130_fd_sc_hd__decap_3
Xoutput66 net66 VGND VGND VPWR VPWR mem_la_addr[10] sky130_fd_sc_hd__buf_2
Xoutput55 net55 VGND VGND VPWR VPWR mem_addr[2] sky130_fd_sc_hd__buf_2
Xoutput88 net88 VGND VGND VPWR VPWR mem_la_addr[31] sky130_fd_sc_hd__buf_2
Xoutput77 net77 VGND VGND VPWR VPWR mem_la_addr[21] sky130_fd_sc_hd__buf_2
XFILLER_110_609 VGND VGND VPWR VPWR sky130_fd_sc_hd__fill_1
XTAP_TAPCELL_ROW_73_1494 VGND VPWR sky130_fd_sc_hd__tapvpwrvgnd_1
XFILLER_49_704 VGND VGND VPWR VPWR sky130_fd_sc_hd__fill_1
XFILLER_1_777 VGND VGND VPWR VPWR sky130_fd_sc_hd__decap_6
X_11072_ clknet_leaf_122_clk _01129_ VGND VGND VPWR VPWR cpuregs\[24\]\[3\] sky130_fd_sc_hd__dfxtp_1
Xoutput99 net99 VGND VGND VPWR VPWR mem_la_wdata[11] sky130_fd_sc_hd__buf_2
X_10023_ clknet_leaf_80_clk _00153_ VGND VGND VPWR VPWR cpuregs\[30\]\[21\] sky130_fd_sc_hd__dfxtp_1
XFILLER_76_512 VPWR VGND VPWR VGND sky130_ef_sc_hd__decap_12
XFILLER_49_726 VGND VGND VPWR VPWR sky130_fd_sc_hd__fill_2
XFILLER_0_265 VPWR VGND VPWR VGND sky130_ef_sc_hd__decap_12
XFILLER_102_182 VGND VGND VPWR VPWR sky130_fd_sc_hd__fill_1
XFILLER_56_41 VGND VGND VPWR VPWR sky130_fd_sc_hd__decap_8
XFILLER_17_601 VGND VGND VPWR VPWR sky130_fd_sc_hd__fill_1
XTAP_TAPCELL_ROW_19_629 VGND VPWR sky130_fd_sc_hd__tapvpwrvgnd_1
XFILLER_56_85 VPWR VGND VPWR VGND sky130_ef_sc_hd__decap_12
X_10925_ clknet_leaf_29_clk _00987_ VGND VGND VPWR VPWR net159 sky130_fd_sc_hd__dfxtp_1
XFILLER_17_689 VGND VGND VPWR VPWR sky130_fd_sc_hd__fill_1
XFILLER_112_80 VGND VGND VPWR VPWR sky130_fd_sc_hd__decap_4
X_10856_ clknet_leaf_124_clk _00918_ VGND VGND VPWR VPWR cpuregs\[1\]\[0\] sky130_fd_sc_hd__dfxtp_1
XTAP_TAPCELL_ROW_30_805 VGND VPWR sky130_fd_sc_hd__tapvpwrvgnd_1
X_10787_ clknet_leaf_98_clk _00852_ VGND VGND VPWR VPWR instr_bgeu sky130_fd_sc_hd__dfxtp_1
XFILLER_9_833 VGND VGND VPWR VPWR sky130_fd_sc_hd__decap_6
XFILLER_12_372 VPWR VGND VPWR VGND sky130_ef_sc_hd__decap_12
XFILLER_13_895 VGND VGND VPWR VPWR sky130_fd_sc_hd__fill_1
XTAP_TAPCELL_ROW_30_816 VGND VPWR sky130_fd_sc_hd__tapvpwrvgnd_1
XFILLER_31_169 VPWR VGND VPWR VGND sky130_ef_sc_hd__decap_12
XFILLER_9_877 VPWR VGND VPWR VGND sky130_ef_sc_hd__decap_12
XTAP_TAPCELL_ROW_93_1826 VGND VPWR sky130_fd_sc_hd__tapvpwrvgnd_1
XTAP_TAPCELL_ROW_93_1815 VGND VPWR sky130_fd_sc_hd__tapvpwrvgnd_1
X_11408_ clknet_leaf_1_clk _01452_ VGND VGND VPWR VPWR cpuregs\[8\]\[6\] sky130_fd_sc_hd__dfxtp_1
XFILLER_99_615 VGND VGND VPWR VPWR sky130_fd_sc_hd__fill_1
X_11339_ clknet_leaf_120_clk _01383_ VGND VGND VPWR VPWR cpuregs\[6\]\[1\] sky130_fd_sc_hd__dfxtp_1
XFILLER_97_92 VPWR VGND VPWR VGND sky130_ef_sc_hd__decap_12
XFILLER_86_309 VPWR VGND VPWR VGND sky130_ef_sc_hd__decap_12
XFILLER_79_361 VGND VGND VPWR VPWR sky130_fd_sc_hd__decap_8
XFILLER_140_299 VGND VGND VPWR VPWR sky130_fd_sc_hd__decap_8
X_05900_ _01567_ net223 instr_sub VGND VGND VPWR VPWR _02454_ sky130_fd_sc_hd__o21ai_1
X_06880_ _03295_ _03296_ VGND VGND VPWR VPWR _03297_ sky130_fd_sc_hd__or2_1
XFILLER_67_534 VPWR VGND VPWR VGND sky130_ef_sc_hd__decap_12
XFILLER_39_214 VGND VGND VPWR VPWR sky130_fd_sc_hd__decap_8
X_05831_ _02096_ _02391_ VGND VGND VPWR VPWR _02393_ sky130_fd_sc_hd__or2_1
XFILLER_95_876 VGND VGND VPWR VPWR sky130_fd_sc_hd__decap_6
XTAP_TAPCELL_ROW_124_2314 VGND VPWR sky130_fd_sc_hd__tapvpwrvgnd_1
XFILLER_55_729 VGND VGND VPWR VPWR sky130_fd_sc_hd__decap_4
XTAP_TAPCELL_ROW_38_938 VGND VPWR sky130_fd_sc_hd__tapvpwrvgnd_1
X_05762_ _02145_ _02237_ _02238_ _02144_ VGND VGND VPWR VPWR _02331_ sky130_fd_sc_hd__a22o_1
X_08550_ _04249_ _04250_ _01558_ VGND VGND VPWR VPWR _04251_ sky130_fd_sc_hd__mux2_1
X_07501_ cpuregs\[26\]\[19\] _02662_ _03568_ VGND VGND VPWR VPWR _00439_ sky130_fd_sc_hd__mux2_1
XFILLER_63_751 VGND VGND VPWR VPWR sky130_fd_sc_hd__fill_1
X_08481_ net95 net64 _04208_ VGND VGND VPWR VPWR _00779_ sky130_fd_sc_hd__mux2_1
XFILLER_23_615 VGND VGND VPWR VPWR sky130_fd_sc_hd__fill_1
X_05693_ _02170_ _02270_ _02242_ VGND VGND VPWR VPWR _02271_ sky130_fd_sc_hd__a21oi_1
X_07432_ cpuregs\[27\]\[16\] _02649_ _03566_ VGND VGND VPWR VPWR _00372_ sky130_fd_sc_hd__mux2_1
XFILLER_50_401 VGND VGND VPWR VPWR sky130_fd_sc_hd__fill_1
XFILLER_23_648 VPWR VGND VPWR VGND sky130_ef_sc_hd__decap_12
XTAP_TAPCELL_ROW_102_1966 VGND VPWR sky130_fd_sc_hd__tapvpwrvgnd_1
XFILLER_50_445 VGND VGND VPWR VPWR sky130_fd_sc_hd__decap_8
XTAP_TAPCELL_ROW_44_1040 VGND VPWR sky130_fd_sc_hd__tapvpwrvgnd_1
X_07363_ _02641_ cpuregs\[9\]\[14\] _03563_ VGND VGND VPWR VPWR _00306_ sky130_fd_sc_hd__mux2_1
X_09102_ instr_blt _04748_ _04750_ _04754_ VGND VGND VPWR VPWR _00849_ sky130_fd_sc_hd__a22o_1
XFILLER_10_309 VGND VGND VPWR VPWR sky130_fd_sc_hd__decap_6
XFILLER_149_889 VGND VGND VPWR VPWR sky130_fd_sc_hd__decap_6
X_06314_ instr_lui is_lui_auipc_jal VGND VGND VPWR VPWR _02751_ sky130_fd_sc_hd__and2b_4
X_07294_ cpuregs\[28\]\[12\] _02633_ net249 VGND VGND VPWR VPWR _00240_ sky130_fd_sc_hd__mux2_1
X_06245_ reg_out\[26\] alu_out_q\[26\] net587 VGND VGND VPWR VPWR _02689_ sky130_fd_sc_hd__mux2_1
X_09033_ cpuregs\[4\]\[30\] cpuregs\[5\]\[30\] cpuregs\[6\]\[30\] cpuregs\[7\]\[30\]
+ net277 net271 VGND VGND VPWR VPWR _04705_ sky130_fd_sc_hd__mux4_1
XTAP_TAPCELL_ROW_135_2498 VGND VPWR sky130_fd_sc_hd__tapvpwrvgnd_1
XTAP_TAPCELL_ROW_135_2487 VGND VPWR sky130_fd_sc_hd__tapvpwrvgnd_1
X_06176_ _02633_ cpuregs\[11\]\[12\] _02582_ VGND VGND VPWR VPWR _00049_ sky130_fd_sc_hd__mux2_1
XFILLER_117_797 VGND VGND VPWR VPWR sky130_fd_sc_hd__decap_3
X_05127_ reg_pc\[5\] decoded_imm\[5\] VGND VGND VPWR VPWR _01737_ sky130_fd_sc_hd__or2_1
XFILLER_132_745 VGND VGND VPWR VPWR sky130_fd_sc_hd__decap_8
XFILLER_131_222 VGND VGND VPWR VPWR sky130_fd_sc_hd__fill_2
XFILLER_89_169 VGND VGND VPWR VPWR sky130_fd_sc_hd__decap_6
X_05058_ net8 _01669_ net130 net1 _01671_ VGND VGND VPWR VPWR _01673_ sky130_fd_sc_hd__a221o_1
X_09935_ clknet_leaf_111_clk _00028_ VGND VGND VPWR VPWR _00008_ sky130_fd_sc_hd__dfxtp_4
XFILLER_100_620 VPWR VGND VPWR VGND sky130_ef_sc_hd__decap_12
XFILLER_98_681 VPWR VGND VPWR VGND sky130_ef_sc_hd__decap_12
XFILLER_86_821 VGND VGND VPWR VPWR sky130_fd_sc_hd__fill_1
XFILLER_86_810 VGND VGND VPWR VPWR sky130_fd_sc_hd__fill_2
X_09866_ decoded_imm_j\[11\] _01114_ _02513_ VGND VGND VPWR VPWR _00907_ sky130_fd_sc_hd__mux2_1
XFILLER_133_57 VPWR VGND VPWR VGND sky130_ef_sc_hd__decap_12
X_08817_ net270 _04493_ net269 VGND VGND VPWR VPWR _04501_ sky130_fd_sc_hd__o21a_1
XFILLER_58_567 VGND VGND VPWR VPWR sky130_fd_sc_hd__decap_6
XFILLER_85_386 VGND VGND VPWR VPWR sky130_fd_sc_hd__decap_6
XFILLER_58_589 VGND VGND VPWR VPWR sky130_fd_sc_hd__decap_4
X_09797_ _02598_ cpuregs\[8\]\[4\] _04875_ VGND VGND VPWR VPWR _01450_ sky130_fd_sc_hd__mux2_1
X_08748_ net270 _04431_ _04430_ _01560_ VGND VGND VPWR VPWR _04436_ sky130_fd_sc_hd__o211a_1
X_08679_ net204 _01585_ _04369_ _04370_ VGND VGND VPWR VPWR _00816_ sky130_fd_sc_hd__o22a_1
XFILLER_60_209 VGND VGND VPWR VPWR sky130_fd_sc_hd__decap_6
XFILLER_81_570 VPWR VGND VPWR VGND sky130_ef_sc_hd__decap_12
XFILLER_53_272 VGND VGND VPWR VPWR sky130_fd_sc_hd__decap_8
X_10710_ clknet_leaf_126_clk _00807_ VGND VGND VPWR VPWR net108 sky130_fd_sc_hd__dfxtp_4
XFILLER_41_445 VGND VGND VPWR VPWR sky130_fd_sc_hd__decap_3
X_10641_ clknet_leaf_58_clk _00771_ VGND VGND VPWR VPWR net195 sky130_fd_sc_hd__dfxtp_4
XFILLER_13_169 VPWR VGND VPWR VGND sky130_ef_sc_hd__decap_12
XFILLER_139_355 VGND VGND VPWR VPWR sky130_fd_sc_hd__fill_1
X_10572_ clknet_leaf_65_clk _00702_ VGND VGND VPWR VPWR reg_next_pc\[27\] sky130_fd_sc_hd__dfxtp_1
XFILLER_42_54 VPWR VGND VPWR VGND sky130_ef_sc_hd__decap_12
XFILLER_139_377 VPWR VGND VPWR VGND sky130_ef_sc_hd__decap_12
XFILLER_6_825 VPWR VGND VPWR VGND sky130_ef_sc_hd__decap_12
XFILLER_6_869 VPWR VGND VPWR VGND sky130_ef_sc_hd__decap_12
XFILLER_5_335 VGND VGND VPWR VPWR sky130_fd_sc_hd__fill_1
XFILLER_135_550 VGND VGND VPWR VPWR sky130_fd_sc_hd__decap_8
XTAP_TAPCELL_ROW_75_1534 VGND VPWR sky130_fd_sc_hd__tapvpwrvgnd_1
XFILLER_150_531 VGND VGND VPWR VPWR sky130_fd_sc_hd__fill_1
XFILLER_135_594 VGND VGND VPWR VPWR sky130_fd_sc_hd__fill_2
XFILLER_107_274 VGND VGND VPWR VPWR sky130_fd_sc_hd__decap_6
XFILLER_122_244 VGND VGND VPWR VPWR sky130_fd_sc_hd__decap_8
X_11124_ clknet_leaf_10_clk _01171_ VGND VGND VPWR VPWR cpuregs\[31\]\[13\] sky130_fd_sc_hd__dfxtp_1
XFILLER_68_309 VGND VGND VPWR VPWR sky130_fd_sc_hd__decap_4
XFILLER_3_15 VPWR VGND VPWR VGND sky130_ef_sc_hd__decap_12
XFILLER_1_541 VPWR VGND VPWR VGND sky130_ef_sc_hd__decap_12
X_11055_ clknet_leaf_87_clk _01112_ VGND VGND VPWR VPWR mem_rdata_q\[18\] sky130_fd_sc_hd__dfxtp_1
XFILLER_77_821 VGND VGND VPWR VPWR sky130_fd_sc_hd__fill_1
XFILLER_67_73 VGND VGND VPWR VPWR sky130_fd_sc_hd__fill_1
XFILLER_49_534 VGND VGND VPWR VPWR sky130_fd_sc_hd__decap_6
X_10006_ clknet_leaf_139_clk _00136_ VGND VGND VPWR VPWR cpuregs\[30\]\[4\] sky130_fd_sc_hd__dfxtp_1
XTAP_TAPCELL_ROW_106_2022 VGND VPWR sky130_fd_sc_hd__tapvpwrvgnd_1
XFILLER_92_813 VGND VGND VPWR VPWR sky130_fd_sc_hd__decap_3
XFILLER_76_375 VGND VGND VPWR VPWR sky130_fd_sc_hd__fill_2
XFILLER_37_729 VGND VGND VPWR VPWR sky130_fd_sc_hd__decap_6
XTAP_TAPCELL_ROW_106_2033 VGND VPWR sky130_fd_sc_hd__tapvpwrvgnd_1
XFILLER_91_345 VPWR VGND VPWR VGND sky130_ef_sc_hd__decap_12
XTAP_TAPCELL_ROW_4_390 VGND VPWR sky130_fd_sc_hd__tapvpwrvgnd_1
XFILLER_45_762 VGND VGND VPWR VPWR sky130_fd_sc_hd__decap_4
X_10908_ clknet_leaf_7_clk _00970_ VGND VGND VPWR VPWR net140 sky130_fd_sc_hd__dfxtp_1
X_10839_ clknet_leaf_87_clk _00904_ VGND VGND VPWR VPWR decoded_imm_j\[16\] sky130_fd_sc_hd__dfxtp_1
XFILLER_20_618 VGND VGND VPWR VPWR sky130_fd_sc_hd__fill_1
XFILLER_32_489 VPWR VGND VPWR VGND sky130_ef_sc_hd__decap_12
XFILLER_9_641 VGND VGND VPWR VPWR sky130_fd_sc_hd__fill_1
XFILLER_12_180 VPWR VGND VPWR VGND sky130_ef_sc_hd__decap_12
XFILLER_146_837 VPWR VGND VPWR VGND sky130_ef_sc_hd__decap_12
XPHY_EDGE_ROW_132_Right_132 VGND VGND VPWR VPWR sky130_fd_sc_hd__decap_3
XFILLER_145_358 VPWR VGND VPWR VGND sky130_ef_sc_hd__decap_12
XFILLER_8_184 VPWR VGND VPWR VGND sky130_ef_sc_hd__decap_12
X_06030_ decoded_imm_j\[4\] _01118_ _02513_ VGND VGND VPWR VPWR _00031_ sky130_fd_sc_hd__mux2_1
XFILLER_113_255 VGND VGND VPWR VPWR sky130_fd_sc_hd__fill_1
X_07981_ _01547_ reg_next_pc\[9\] _01645_ _03696_ VGND VGND VPWR VPWR _03805_ sky130_fd_sc_hd__a22o_1
X_09720_ _02691_ cpuregs\[5\]\[26\] _04872_ VGND VGND VPWR VPWR _01376_ sky130_fd_sc_hd__mux2_1
XFILLER_113_277 VGND VGND VPWR VPWR sky130_fd_sc_hd__decap_3
X_06932_ decoded_imm\[23\] net186 VGND VGND VPWR VPWR _03347_ sky130_fd_sc_hd__and2_1
XFILLER_87_629 VGND VGND VPWR VPWR sky130_fd_sc_hd__decap_8
XFILLER_86_139 VGND VGND VPWR VPWR sky130_fd_sc_hd__fill_1
X_06863_ cpuregs\[16\]\[20\] cpuregs\[17\]\[20\] cpuregs\[18\]\[20\] cpuregs\[19\]\[20\]
+ _00012_ _00013_ VGND VGND VPWR VPWR _03281_ sky130_fd_sc_hd__mux4_1
X_09651_ _02683_ cpuregs\[22\]\[24\] _04869_ VGND VGND VPWR VPWR _01310_ sky130_fd_sc_hd__mux2_1
XFILLER_95_684 VGND VGND VPWR VPWR sky130_fd_sc_hd__decap_4
XFILLER_27_206 VPWR VGND VPWR VGND sky130_ef_sc_hd__decap_12
X_09582_ cpuregs\[29\]\[21\] _02670_ _04867_ VGND VGND VPWR VPWR _01243_ sky130_fd_sc_hd__mux2_1
X_05814_ net255 _02374_ _02375_ _02377_ VGND VGND VPWR VPWR alu_out\[19\] sky130_fd_sc_hd__a31o_1
X_06794_ decoded_imm\[17\] net179 _03190_ VGND VGND VPWR VPWR _03214_ sky130_fd_sc_hd__a21o_1
XFILLER_83_868 VGND VGND VPWR VPWR sky130_fd_sc_hd__fill_1
XFILLER_55_559 VGND VGND VPWR VPWR sky130_fd_sc_hd__fill_1
X_08602_ decoded_imm\[6\] _01654_ _01586_ VGND VGND VPWR VPWR _04298_ sky130_fd_sc_hd__a21o_1
X_05745_ _02117_ _02121_ _02315_ _02118_ VGND VGND VPWR VPWR _02316_ sky130_fd_sc_hd__o31a_1
X_08533_ _00010_ _04234_ _01560_ VGND VGND VPWR VPWR _04235_ sky130_fd_sc_hd__a21o_1
XFILLER_36_751 VGND VGND VPWR VPWR sky130_fd_sc_hd__decap_4
X_08464_ _00015_ _04200_ VGND VGND VPWR VPWR _04201_ sky130_fd_sc_hd__nor2_1
X_05676_ _02242_ _02254_ _02256_ VGND VGND VPWR VPWR alu_out\[2\] sky130_fd_sc_hd__o21ai_1
XTAP_TAPCELL_ROW_137_2516 VGND VPWR sky130_fd_sc_hd__tapvpwrvgnd_1
X_08395_ _04144_ count_cycle\[50\] _01549_ VGND VGND VPWR VPWR _04146_ sky130_fd_sc_hd__a21oi_1
XFILLER_51_776 VGND VGND VPWR VPWR sky130_fd_sc_hd__decap_8
XFILLER_50_275 VGND VGND VPWR VPWR sky130_fd_sc_hd__decap_4
XFILLER_50_253 VGND VGND VPWR VPWR sky130_fd_sc_hd__decap_4
X_07415_ latched_rd\[1\] latched_rd\[0\] _03565_ VGND VGND VPWR VPWR _03566_ sky130_fd_sc_hd__and3_4
XFILLER_148_141 VPWR VGND VPWR VGND sky130_ef_sc_hd__decap_12
XTAP_TAPCELL_ROW_137_2527 VGND VPWR sky130_fd_sc_hd__tapvpwrvgnd_1
X_07346_ cpuregs\[21\]\[30\] _02709_ net248 VGND VGND VPWR VPWR _00290_ sky130_fd_sc_hd__mux2_1
XFILLER_50_297 VGND VGND VPWR VPWR sky130_fd_sc_hd__decap_8
XFILLER_10_139 VGND VGND VPWR VPWR sky130_fd_sc_hd__fill_1
XTAP_TAPCELL_ROW_21_668 VGND VPWR sky130_fd_sc_hd__tapvpwrvgnd_1
XTAP_TAPCELL_ROW_150_2738 VGND VPWR sky130_fd_sc_hd__tapvpwrvgnd_1
XTAP_TAPCELL_ROW_150_2727 VGND VPWR sky130_fd_sc_hd__tapvpwrvgnd_1
X_07277_ cpuregs\[2\]\[28\] _02699_ net250 VGND VGND VPWR VPWR _00224_ sky130_fd_sc_hd__mux2_1
X_09016_ cpuregs\[8\]\[29\] cpuregs\[9\]\[29\] cpuregs\[10\]\[29\] cpuregs\[11\]\[29\]
+ net275 net271 VGND VGND VPWR VPWR _04689_ sky130_fd_sc_hd__mux4_1
X_06228_ _02675_ cpuregs\[11\]\[22\] _02582_ VGND VGND VPWR VPWR _00059_ sky130_fd_sc_hd__mux2_1
XFILLER_117_561 VGND VGND VPWR VPWR sky130_fd_sc_hd__decap_4
X_06159_ _02583_ _02619_ VGND VGND VPWR VPWR _02620_ sky130_fd_sc_hd__nor2_1
XTAP_TAPCELL_ROW_57_1242 VGND VPWR sky130_fd_sc_hd__tapvpwrvgnd_1
XFILLER_3_839 VGND VGND VPWR VPWR sky130_fd_sc_hd__fill_1
X_09918_ clknet_leaf_21_clk _00053_ VGND VGND VPWR VPWR cpuregs\[11\]\[16\] sky130_fd_sc_hd__dfxtp_1
XTAP_TAPCELL_ROW_70_1453 VGND VPWR sky130_fd_sc_hd__tapvpwrvgnd_1
X_09849_ _02678_ cpuregs\[10\]\[23\] _04876_ VGND VGND VPWR VPWR _01533_ sky130_fd_sc_hd__mux2_1
XFILLER_19_729 VGND VGND VPWR VPWR sky130_fd_sc_hd__decap_4
XFILLER_86_695 VGND VGND VPWR VPWR sky130_fd_sc_hd__decap_4
XFILLER_18_239 VPWR VGND VPWR VGND sky130_ef_sc_hd__decap_12
XFILLER_26_250 VGND VGND VPWR VPWR sky130_fd_sc_hd__fill_2
XFILLER_14_445 VPWR VGND VPWR VGND sky130_ef_sc_hd__decap_12
XFILLER_30_905 VGND VGND VPWR VPWR sky130_fd_sc_hd__decap_3
XFILLER_42_754 VGND VGND VPWR VPWR sky130_fd_sc_hd__fill_2
XFILLER_14_489 VGND VGND VPWR VPWR sky130_fd_sc_hd__decap_3
XFILLER_139_141 VGND VGND VPWR VPWR sky130_fd_sc_hd__fill_1
X_10624_ clknet_leaf_85_clk _00754_ VGND VGND VPWR VPWR count_cycle\[47\] sky130_fd_sc_hd__dfxtp_1
XFILLER_139_163 VGND VGND VPWR VPWR sky130_fd_sc_hd__decap_4
XFILLER_128_837 VPWR VGND VPWR VGND sky130_ef_sc_hd__decap_12
XTAP_TAPCELL_ROW_40_966 VGND VPWR sky130_fd_sc_hd__tapvpwrvgnd_1
XTAP_TAPCELL_ROW_40_977 VGND VPWR sky130_fd_sc_hd__tapvpwrvgnd_1
Xpicorv32_309 VGND VGND VPWR VPWR picorv32_309/HI eoi[28] sky130_fd_sc_hd__conb_1
X_10555_ clknet_leaf_97_clk _00685_ VGND VGND VPWR VPWR reg_next_pc\[10\] sky130_fd_sc_hd__dfxtp_1
X_10486_ clknet_leaf_107_clk _00616_ VGND VGND VPWR VPWR count_instr\[35\] sky130_fd_sc_hd__dfxtp_1
XFILLER_52_9 VPWR VGND VPWR VGND sky130_ef_sc_hd__decap_12
XFILLER_136_881 VPWR VGND VPWR VGND sky130_ef_sc_hd__decap_12
XFILLER_6_699 VGND VGND VPWR VPWR sky130_fd_sc_hd__fill_1
XFILLER_123_542 VPWR VGND VPWR VGND sky130_ef_sc_hd__decap_12
XFILLER_2_861 VGND VGND VPWR VPWR sky130_fd_sc_hd__decap_6
XFILLER_151_895 VGND VGND VPWR VPWR sky130_fd_sc_hd__fill_1
XFILLER_110_214 VGND VGND VPWR VPWR sky130_fd_sc_hd__fill_1
X_11107_ clknet_leaf_102_clk _00020_ VGND VGND VPWR VPWR cpu_state\[3\] sky130_fd_sc_hd__dfxtp_4
XTAP_TAPCELL_ROW_9_482 VGND VPWR sky130_fd_sc_hd__tapvpwrvgnd_1
XTAP_TAPCELL_ROW_9_471 VGND VPWR sky130_fd_sc_hd__tapvpwrvgnd_1
XFILLER_1_360 VGND VGND VPWR VPWR sky130_fd_sc_hd__decap_4
XFILLER_150_394 VPWR VGND VPWR VGND sky130_ef_sc_hd__decap_12
XFILLER_110_247 VGND VGND VPWR VPWR sky130_fd_sc_hd__decap_4
XFILLER_1_393 VPWR VGND VPWR VGND sky130_ef_sc_hd__decap_12
XFILLER_83_109 VGND VGND VPWR VPWR sky130_fd_sc_hd__decap_3
XFILLER_77_673 VPWR VGND VPWR VGND sky130_ef_sc_hd__decap_12
X_11038_ clknet_leaf_104_clk _01095_ VGND VGND VPWR VPWR mem_rdata_q\[1\] sky130_fd_sc_hd__dfxtp_1
XTAP_TAPCELL_ROW_88_1747 VGND VPWR sky130_fd_sc_hd__tapvpwrvgnd_1
XTAP_TAPCELL_ROW_88_1736 VGND VPWR sky130_fd_sc_hd__tapvpwrvgnd_1
XFILLER_76_172 VGND VGND VPWR VPWR sky130_fd_sc_hd__decap_8
XFILLER_94_93 VGND VGND VPWR VPWR sky130_fd_sc_hd__fill_1
XFILLER_52_507 VGND VGND VPWR VPWR sky130_fd_sc_hd__decap_3
XFILLER_91_164 VGND VGND VPWR VPWR sky130_fd_sc_hd__decap_4
X_05530_ _02111_ _02112_ VGND VGND VPWR VPWR _02113_ sky130_fd_sc_hd__nor2_1
XFILLER_60_540 VGND VGND VPWR VPWR sky130_fd_sc_hd__decap_4
X_05461_ net256 _02043_ _02044_ net195 cpu_state\[4\] VGND VGND VPWR VPWR _02045_
+ sky130_fd_sc_hd__a32o_1
XFILLER_32_253 VGND VGND VPWR VPWR sky130_fd_sc_hd__decap_4
X_08180_ _03986_ _03987_ VGND VGND VPWR VPWR _03988_ sky130_fd_sc_hd__nor2_1
XTAP_TAPCELL_ROW_119_2235 VGND VPWR sky130_fd_sc_hd__tapvpwrvgnd_1
X_07200_ cpuregs\[30\]\[18\] _02657_ _03556_ VGND VGND VPWR VPWR _00150_ sky130_fd_sc_hd__mux2_1
X_05392_ reg_pc\[26\] decoded_imm\[26\] VGND VGND VPWR VPWR _01981_ sky130_fd_sc_hd__nand2_1
X_07131_ cpuregs\[0\]\[30\] cpuregs\[1\]\[30\] cpuregs\[2\]\[30\] cpuregs\[3\]\[30\]
+ net266 net261 VGND VGND VPWR VPWR _03539_ sky130_fd_sc_hd__mux4_1
XFILLER_146_645 VPWR VGND VPWR VGND sky130_ef_sc_hd__decap_12
XFILLER_146_634 VGND VGND VPWR VPWR sky130_fd_sc_hd__decap_8
XFILLER_146_689 VGND VGND VPWR VPWR sky130_fd_sc_hd__fill_2
XTAP_TAPCELL_ROW_132_2446 VGND VPWR sky130_fd_sc_hd__tapvpwrvgnd_1
X_07062_ reg_pc\[27\] _02751_ _03472_ _02715_ VGND VGND VPWR VPWR _03473_ sky130_fd_sc_hd__a211o_1
Xoutput201 net201 VGND VGND VPWR VPWR pcpi_rs1[8] sky130_fd_sc_hd__buf_2
Xoutput223 net223 VGND VGND VPWR VPWR pcpi_rs2[28] sky130_fd_sc_hd__buf_2
Xoutput212 net212 VGND VGND VPWR VPWR pcpi_rs2[18] sky130_fd_sc_hd__buf_2
X_06013_ reg_out\[29\] reg_next_pc\[29\] net596 VGND VGND VPWR VPWR _02510_ sky130_fd_sc_hd__mux2_1
Xoutput234 net234 VGND VGND VPWR VPWR pcpi_rs2[9] sky130_fd_sc_hd__buf_2
XFILLER_114_542 VPWR VGND VPWR VGND sky130_ef_sc_hd__decap_12
XFILLER_114_15 VPWR VGND VPWR VGND sky130_ef_sc_hd__decap_12
XFILLER_101_247 VGND VGND VPWR VPWR sky130_fd_sc_hd__fill_1
XFILLER_99_297 VGND VGND VPWR VPWR sky130_fd_sc_hd__fill_1
X_07964_ decoded_imm_j\[8\] _03695_ VGND VGND VPWR VPWR _03789_ sky130_fd_sc_hd__or2_1
X_06915_ _01579_ _03330_ VGND VGND VPWR VPWR _03331_ sky130_fd_sc_hd__or2_1
XFILLER_56_802 VGND VGND VPWR VPWR sky130_fd_sc_hd__decap_8
XTAP_TAPCELL_ROW_52_1161 VGND VPWR sky130_fd_sc_hd__tapvpwrvgnd_1
X_09703_ _02621_ cpuregs\[5\]\[9\] _04872_ VGND VGND VPWR VPWR _01359_ sky130_fd_sc_hd__mux2_1
X_07895_ decoded_imm_j\[2\] _03688_ VGND VGND VPWR VPWR _03726_ sky130_fd_sc_hd__or2_1
X_06846_ _03213_ _03238_ _03239_ VGND VGND VPWR VPWR _03264_ sky130_fd_sc_hd__and3_1
X_09634_ _02612_ cpuregs\[22\]\[7\] _04869_ VGND VGND VPWR VPWR _01293_ sky130_fd_sc_hd__mux2_1
XFILLER_82_153 VGND VGND VPWR VPWR sky130_fd_sc_hd__fill_1
X_06777_ cpuregs\[28\]\[17\] cpuregs\[29\]\[17\] cpuregs\[30\]\[17\] cpuregs\[31\]\[17\]
+ net265 net260 VGND VGND VPWR VPWR _03198_ sky130_fd_sc_hd__mux4_1
XFILLER_71_838 VGND VGND VPWR VPWR sky130_fd_sc_hd__fill_2
XFILLER_24_710 VGND VGND VPWR VPWR sky130_fd_sc_hd__decap_8
X_09565_ cpuregs\[29\]\[4\] _02598_ net239 VGND VGND VPWR VPWR _01226_ sky130_fd_sc_hd__mux2_1
XFILLER_82_197 VGND VGND VPWR VPWR sky130_fd_sc_hd__decap_4
X_05728_ _02300_ _02192_ instr_sub VGND VGND VPWR VPWR _02301_ sky130_fd_sc_hd__mux2_1
X_08516_ mem_do_wdata _04218_ _01614_ _04217_ VGND VGND VPWR VPWR _04219_ sky130_fd_sc_hd__and4bb_1
X_09496_ cpuregs\[31\]\[1\] _02588_ net240 VGND VGND VPWR VPWR _01159_ sky130_fd_sc_hd__mux2_1
XFILLER_12_905 VGND VGND VPWR VPWR sky130_fd_sc_hd__decap_4
XTAP_TAPCELL_ROW_26_749 VGND VPWR sky130_fd_sc_hd__tapvpwrvgnd_1
XFILLER_90_29 VGND VGND VPWR VPWR sky130_fd_sc_hd__decap_3
X_05659_ is_compare _02237_ _02238_ _02240_ VGND VGND VPWR VPWR _02242_ sky130_fd_sc_hd__or4_4
X_08447_ cpuregs\[6\]\[31\] cpuregs\[7\]\[31\] net264 VGND VGND VPWR VPWR _04184_
+ sky130_fd_sc_hd__mux2_1
XFILLER_11_426 VGND VGND VPWR VPWR sky130_fd_sc_hd__fill_1
XFILLER_149_483 VGND VGND VPWR VPWR sky130_fd_sc_hd__fill_1
XFILLER_149_461 VGND VGND VPWR VPWR sky130_fd_sc_hd__decap_6
X_08378_ _04134_ _04135_ VGND VGND VPWR VPWR _00750_ sky130_fd_sc_hd__nor2_1
X_07329_ cpuregs\[21\]\[13\] _02638_ net248 VGND VGND VPWR VPWR _00273_ sky130_fd_sc_hd__mux2_1
X_10340_ clknet_leaf_53_clk _00470_ VGND VGND VPWR VPWR cpuregs\[16\]\[18\] sky130_fd_sc_hd__dfxtp_1
XFILLER_151_125 VPWR VGND VPWR VGND sky130_ef_sc_hd__decap_12
XFILLER_118_881 VPWR VGND VPWR VGND sky130_ef_sc_hd__decap_12
X_10271_ clknet_leaf_10_clk _00401_ VGND VGND VPWR VPWR cpuregs\[15\]\[13\] sky130_fd_sc_hd__dfxtp_1
XFILLER_3_614 VGND VGND VPWR VPWR sky130_fd_sc_hd__fill_2
XFILLER_151_169 VPWR VGND VPWR VGND sky130_ef_sc_hd__decap_12
XFILLER_117_391 VGND VGND VPWR VPWR sky130_fd_sc_hd__fill_1
XFILLER_79_905 VGND VGND VPWR VPWR sky130_fd_sc_hd__decap_3
XFILLER_133_895 VGND VGND VPWR VPWR sky130_fd_sc_hd__fill_1
XFILLER_120_556 VGND VGND VPWR VPWR sky130_fd_sc_hd__fill_1
XTAP_TAPCELL_ROW_6_430 VGND VPWR sky130_fd_sc_hd__tapvpwrvgnd_1
XFILLER_101_770 VGND VGND VPWR VPWR sky130_fd_sc_hd__fill_1
XFILLER_93_418 VGND VGND VPWR VPWR sky130_fd_sc_hd__decap_6
XFILLER_48_53 VPWR VGND VPWR VGND sky130_ef_sc_hd__decap_12
XFILLER_62_805 VGND VGND VPWR VPWR sky130_fd_sc_hd__decap_3
XFILLER_0_27 VGND VGND VPWR VPWR sky130_fd_sc_hd__fill_1
XFILLER_19_559 VGND VGND VPWR VPWR sky130_fd_sc_hd__fill_1
XFILLER_34_507 VGND VGND VPWR VPWR sky130_fd_sc_hd__decap_3
XFILLER_64_41 VPWR VGND VPWR VGND sky130_ef_sc_hd__decap_12
XTAP_TAPCELL_ROW_83_1655 VGND VPWR sky130_fd_sc_hd__tapvpwrvgnd_1
XFILLER_14_231 VGND VGND VPWR VPWR sky130_fd_sc_hd__decap_3
XTAP_TAPCELL_ROW_83_1666 VGND VPWR sky130_fd_sc_hd__tapvpwrvgnd_1
XFILLER_14_253 VGND VGND VPWR VPWR sky130_fd_sc_hd__decap_3
XFILLER_42_551 VPWR VGND VPWR VGND sky130_ef_sc_hd__decap_12
XFILLER_9_69 VPWR VGND VPWR VGND sky130_ef_sc_hd__decap_12
XFILLER_128_645 VPWR VGND VPWR VGND sky130_ef_sc_hd__decap_12
X_10607_ clknet_leaf_81_clk _00737_ VGND VGND VPWR VPWR count_cycle\[30\] sky130_fd_sc_hd__dfxtp_1
X_10538_ clknet_leaf_64_clk _00668_ VGND VGND VPWR VPWR reg_pc\[24\] sky130_fd_sc_hd__dfxtp_1
XTAP_TAPCELL_ROW_114_2154 VGND VPWR sky130_fd_sc_hd__tapvpwrvgnd_1
XFILLER_109_892 VGND VGND VPWR VPWR sky130_fd_sc_hd__decap_4
XFILLER_6_474 VGND VGND VPWR VPWR sky130_fd_sc_hd__fill_2
X_10469_ clknet_leaf_84_clk _00599_ VGND VGND VPWR VPWR count_instr\[18\] sky130_fd_sc_hd__dfxtp_1
XFILLER_151_670 VGND VGND VPWR VPWR sky130_fd_sc_hd__fill_2
XFILLER_130_309 VPWR VGND VPWR VGND sky130_ef_sc_hd__decap_12
XFILLER_111_534 VGND VGND VPWR VPWR sky130_fd_sc_hd__decap_8
XFILLER_96_223 VGND VGND VPWR VPWR sky130_fd_sc_hd__decap_8
X_04961_ instr_bltu instr_bge instr_blt instr_bne VGND VGND VPWR VPWR _01591_ sky130_fd_sc_hd__or4_1
XFILLER_29_3 VPWR VGND VPWR VGND sky130_ef_sc_hd__decap_12
XFILLER_38_802 VGND VGND VPWR VPWR sky130_fd_sc_hd__decap_8
XFILLER_38_813 VPWR VGND VPWR VGND sky130_ef_sc_hd__decap_12
X_06700_ _03115_ _03116_ _03119_ _03120_ _01579_ _00016_ VGND VGND VPWR VPWR _03124_
+ sky130_fd_sc_hd__mux4_1
XFILLER_77_481 VGND VGND VPWR VPWR sky130_fd_sc_hd__decap_4
XFILLER_38_846 VPWR VGND VPWR VGND sky130_ef_sc_hd__decap_12
X_07680_ net389 _03596_ VGND VGND VPWR VPWR _00591_ sky130_fd_sc_hd__nor2_1
X_06631_ decoded_imm\[12\] net174 VGND VGND VPWR VPWR _03057_ sky130_fd_sc_hd__nand2_1
XFILLER_64_153 VGND VGND VPWR VPWR sky130_fd_sc_hd__decap_3
X_09350_ mem_rdata_q\[20\] _01589_ VGND VGND VPWR VPWR _04837_ sky130_fd_sc_hd__and2_1
XFILLER_64_197 VGND VGND VPWR VPWR sky130_fd_sc_hd__decap_3
X_06562_ cpuregs\[20\]\[9\] cpuregs\[21\]\[9\] cpuregs\[22\]\[9\] cpuregs\[23\]\[9\]
+ net263 net259 VGND VGND VPWR VPWR _02991_ sky130_fd_sc_hd__mux4_1
X_05513_ _02093_ _02095_ VGND VGND VPWR VPWR _02096_ sky130_fd_sc_hd__nor2_2
X_08301_ count_cycle\[16\] net448 net34 VGND VGND VPWR VPWR _04086_ sky130_fd_sc_hd__o21ai_1
X_09281_ net137 net99 _04206_ VGND VGND VPWR VPWR _00967_ sky130_fd_sc_hd__mux2_1
XFILLER_33_573 VGND VGND VPWR VPWR sky130_fd_sc_hd__decap_3
XFILLER_138_409 VGND VGND VPWR VPWR sky130_fd_sc_hd__fill_2
X_08232_ _04032_ _04035_ VGND VGND VPWR VPWR _04036_ sky130_fd_sc_hd__nand2_1
XFILLER_20_212 VGND VGND VPWR VPWR sky130_fd_sc_hd__fill_1
X_06493_ decoded_imm\[7\] net200 VGND VGND VPWR VPWR _02924_ sky130_fd_sc_hd__or2_1
X_05444_ _02015_ _02018_ VGND VGND VPWR VPWR _02029_ sky130_fd_sc_hd__and2b_1
X_08163_ _03575_ _03971_ _03972_ VGND VGND VPWR VPWR _03973_ sky130_fd_sc_hd__a21o_1
XFILLER_119_656 VPWR VGND VPWR VGND sky130_ef_sc_hd__decap_12
X_05375_ count_cycle\[24\] _01588_ VGND VGND VPWR VPWR _01966_ sky130_fd_sc_hd__or2_1
XFILLER_134_615 VGND VGND VPWR VPWR sky130_fd_sc_hd__fill_1
X_07114_ reg_pc\[29\] _02751_ _03522_ _02715_ VGND VGND VPWR VPWR _03523_ sky130_fd_sc_hd__a211o_1
X_08094_ _03907_ _03908_ VGND VGND VPWR VPWR _03909_ sky130_fd_sc_hd__and2_1
Xclkload71 clknet_leaf_43_clk VGND VGND VPWR VPWR clkload71/Y sky130_fd_sc_hd__inv_6
Xclkload60 clknet_leaf_38_clk VGND VGND VPWR VPWR clkload60/Y sky130_fd_sc_hd__clkinv_8
X_07045_ net186 _02721_ _02744_ _03455_ VGND VGND VPWR VPWR _03456_ sky130_fd_sc_hd__o211a_1
XTAP_TAPCELL_ROW_54_1201 VGND VPWR sky130_fd_sc_hd__tapvpwrvgnd_1
Xclkload82 clknet_leaf_121_clk VGND VGND VPWR VPWR clkload82/Y sky130_fd_sc_hd__inv_6
Xclkload93 clknet_leaf_130_clk VGND VGND VPWR VPWR clkload93/Y sky130_fd_sc_hd__inv_6
XFILLER_133_169 VGND VGND VPWR VPWR sky130_fd_sc_hd__decap_3
XFILLER_114_361 VGND VGND VPWR VPWR sky130_fd_sc_hd__decap_3
XFILLER_87_212 VGND VGND VPWR VPWR sky130_fd_sc_hd__fill_1
XFILLER_0_617 VGND VGND VPWR VPWR sky130_fd_sc_hd__decap_8
X_08996_ cpuregs\[0\]\[28\] cpuregs\[1\]\[28\] cpuregs\[2\]\[28\] cpuregs\[3\]\[28\]
+ net280 net274 VGND VGND VPWR VPWR _04670_ sky130_fd_sc_hd__mux4_1
XFILLER_102_545 VGND VGND VPWR VPWR sky130_fd_sc_hd__fill_1
XFILLER_88_779 VGND VGND VPWR VPWR sky130_fd_sc_hd__decap_8
X_07947_ _03772_ _03773_ net34 VGND VGND VPWR VPWR _00681_ sky130_fd_sc_hd__o21a_1
XTAP_TAPCELL_ROW_145_2659 VGND VPWR sky130_fd_sc_hd__tapvpwrvgnd_1
XTAP_TAPCELL_ROW_145_2648 VGND VPWR sky130_fd_sc_hd__tapvpwrvgnd_1
XFILLER_28_323 VGND VGND VPWR VPWR sky130_fd_sc_hd__fill_1
X_07878_ _03714_ VGND VGND VPWR VPWR _03715_ sky130_fd_sc_hd__inv_2
XFILLER_141_57 VPWR VGND VPWR VGND sky130_ef_sc_hd__decap_12
X_06829_ cpuregs\[24\]\[19\] cpuregs\[25\]\[19\] cpuregs\[26\]\[19\] cpuregs\[27\]\[19\]
+ net267 _00013_ VGND VGND VPWR VPWR _03248_ sky130_fd_sc_hd__mux4_1
X_09617_ _02678_ cpuregs\[3\]\[23\] _04868_ VGND VGND VPWR VPWR _01277_ sky130_fd_sc_hd__mux2_1
XFILLER_56_676 VGND VGND VPWR VPWR sky130_fd_sc_hd__fill_1
XFILLER_44_849 VGND VGND VPWR VPWR sky130_fd_sc_hd__fill_1
X_09548_ cpuregs\[23\]\[20\] _02665_ _04866_ VGND VGND VPWR VPWR _01210_ sky130_fd_sc_hd__mux2_1
XFILLER_70_145 VGND VGND VPWR VPWR sky130_fd_sc_hd__fill_1
XTAP_TAPCELL_ROW_65_1374 VGND VPWR sky130_fd_sc_hd__tapvpwrvgnd_1
X_09479_ cpuregs\[24\]\[17\] _02654_ net241 VGND VGND VPWR VPWR _01143_ sky130_fd_sc_hd__mux2_1
Xclkbuf_leaf_144_clk clknet_4_2_0_clk VGND VGND VPWR VPWR clknet_leaf_144_clk sky130_fd_sc_hd__clkbuf_8
XFILLER_133_3 VPWR VGND VPWR VGND sky130_ef_sc_hd__decap_12
XFILLER_11_245 VPWR VGND VPWR VGND sky130_ef_sc_hd__decap_12
XFILLER_7_205 VPWR VGND VPWR VGND sky130_ef_sc_hd__decap_12
XFILLER_12_757 VPWR VGND VPWR VGND sky130_ef_sc_hd__decap_12
XFILLER_137_431 VPWR VGND VPWR VGND sky130_ef_sc_hd__decap_12
XFILLER_50_21 VGND VGND VPWR VPWR sky130_fd_sc_hd__decap_6
X_11441_ clknet_leaf_143_clk _01485_ VGND VGND VPWR VPWR cpuregs\[0\]\[7\] sky130_fd_sc_hd__dfxtp_1
XFILLER_153_902 VGND VGND VPWR VPWR sky130_fd_sc_hd__fill_1
XFILLER_50_65 VPWR VGND VPWR VGND sky130_ef_sc_hd__decap_12
X_11372_ clknet_leaf_121_clk _01416_ VGND VGND VPWR VPWR cpuregs\[7\]\[2\] sky130_fd_sc_hd__dfxtp_1
XFILLER_152_401 VPWR VGND VPWR VGND sky130_ef_sc_hd__decap_12
XFILLER_125_637 VGND VGND VPWR VPWR sky130_fd_sc_hd__decap_3
XFILLER_109_166 VGND VGND VPWR VPWR sky130_fd_sc_hd__fill_2
X_10323_ clknet_leaf_116_clk _00453_ VGND VGND VPWR VPWR cpuregs\[16\]\[1\] sky130_fd_sc_hd__dfxtp_1
X_10254_ clknet_leaf_41_clk _00384_ VGND VGND VPWR VPWR cpuregs\[27\]\[28\] sky130_fd_sc_hd__dfxtp_1
XFILLER_121_821 VPWR VGND VPWR VGND sky130_ef_sc_hd__decap_12
XFILLER_112_309 VGND VGND VPWR VPWR sky130_fd_sc_hd__decap_8
XFILLER_106_873 VGND VGND VPWR VPWR sky130_fd_sc_hd__fill_2
XFILLER_132_191 VGND VGND VPWR VPWR sky130_fd_sc_hd__decap_4
X_10185_ clknet_leaf_50_clk _00315_ VGND VGND VPWR VPWR cpuregs\[9\]\[23\] sky130_fd_sc_hd__dfxtp_1
XFILLER_121_865 VPWR VGND VPWR VGND sky130_ef_sc_hd__decap_12
XFILLER_78_289 VGND VGND VPWR VPWR sky130_fd_sc_hd__fill_2
XFILLER_93_248 VGND VGND VPWR VPWR sky130_fd_sc_hd__fill_1
XFILLER_61_134 VGND VGND VPWR VPWR sky130_fd_sc_hd__decap_3
XFILLER_34_359 VGND VGND VPWR VPWR sky130_fd_sc_hd__decap_4
XFILLER_61_167 VGND VGND VPWR VPWR sky130_fd_sc_hd__fill_1
XFILLER_15_551 VGND VGND VPWR VPWR sky130_fd_sc_hd__decap_8
XFILLER_91_61 VGND VGND VPWR VPWR sky130_fd_sc_hd__fill_1
Xclkbuf_leaf_135_clk clknet_4_3_0_clk VGND VGND VPWR VPWR clknet_leaf_135_clk sky130_fd_sc_hd__clkbuf_8
XFILLER_15_573 VGND VGND VPWR VPWR sky130_fd_sc_hd__decap_6
XFILLER_30_510 VGND VGND VPWR VPWR sky130_fd_sc_hd__fill_2
XFILLER_147_217 VGND VGND VPWR VPWR sky130_fd_sc_hd__decap_6
XFILLER_128_431 VGND VGND VPWR VPWR sky130_fd_sc_hd__decap_3
XFILLER_30_587 VGND VGND VPWR VPWR sky130_fd_sc_hd__fill_1
X_05160_ reg_pc\[8\] decoded_imm\[8\] VGND VGND VPWR VPWR _01767_ sky130_fd_sc_hd__nand2_1
XFILLER_128_497 VGND VGND VPWR VPWR sky130_fd_sc_hd__fill_1
XTAP_TAPCELL_ROW_96_1868 VGND VPWR sky130_fd_sc_hd__tapvpwrvgnd_1
X_05091_ _01687_ _01694_ _01693_ VGND VGND VPWR VPWR _01703_ sky130_fd_sc_hd__o21ai_1
X_08850_ _01558_ _04531_ VGND VGND VPWR VPWR _04532_ sky130_fd_sc_hd__or2_1
XFILLER_130_139 VGND VGND VPWR VPWR sky130_fd_sc_hd__fill_1
XFILLER_124_692 VGND VGND VPWR VPWR sky130_fd_sc_hd__decap_8
XFILLER_111_320 VGND VGND VPWR VPWR sky130_fd_sc_hd__fill_1
XFILLER_112_876 VPWR VGND VPWR VGND sky130_ef_sc_hd__decap_12
X_07801_ _03669_ count_instr\[54\] count_instr\[55\] VGND VGND VPWR VPWR _03673_ sky130_fd_sc_hd__and3_1
XTAP_TAPCELL_ROW_127_2356 VGND VPWR sky130_fd_sc_hd__tapvpwrvgnd_1
X_05993_ reg_out\[19\] reg_next_pc\[19\] net596 VGND VGND VPWR VPWR _02500_ sky130_fd_sc_hd__mux2_1
X_08781_ net270 _04466_ VGND VGND VPWR VPWR _04467_ sky130_fd_sc_hd__or2_1
XTAP_TAPCELL_ROW_127_2367 VGND VPWR sky130_fd_sc_hd__tapvpwrvgnd_1
X_07732_ count_instr\[29\] _03628_ net34 VGND VGND VPWR VPWR _03630_ sky130_fd_sc_hd__o21ai_1
X_04944_ net211 VGND VGND VPWR VPWR _01577_ sky130_fd_sc_hd__inv_2
XFILLER_38_643 VGND VGND VPWR VPWR sky130_fd_sc_hd__fill_1
X_07663_ count_instr\[4\] _03583_ net34 VGND VGND VPWR VPWR _03586_ sky130_fd_sc_hd__o21ai_1
XFILLER_1_81 VPWR VGND VPWR VGND sky130_ef_sc_hd__decap_12
XFILLER_25_304 VGND VGND VPWR VPWR sky130_fd_sc_hd__decap_3
XTAP_TAPCELL_ROW_140_2567 VGND VPWR sky130_fd_sc_hd__tapvpwrvgnd_1
XFILLER_111_38 VGND VGND VPWR VPWR sky130_fd_sc_hd__fill_2
XFILLER_80_421 VGND VGND VPWR VPWR sky130_fd_sc_hd__decap_8
X_09402_ _02607_ cpuregs\[18\]\[6\] _04862_ VGND VGND VPWR VPWR _01036_ sky130_fd_sc_hd__mux2_1
X_06614_ cpuregs\[20\]\[11\] cpuregs\[21\]\[11\] cpuregs\[22\]\[11\] cpuregs\[23\]\[11\]
+ net268 net259 VGND VGND VPWR VPWR _03041_ sky130_fd_sc_hd__mux4_1
XFILLER_25_337 VGND VGND VPWR VPWR sky130_fd_sc_hd__decap_8
XFILLER_26_849 VPWR VGND VPWR VGND sky130_ef_sc_hd__decap_12
XTAP_TAPCELL_ROW_140_2578 VGND VPWR sky130_fd_sc_hd__tapvpwrvgnd_1
X_09333_ decoded_imm\[29\] _04746_ _04825_ _04828_ VGND VGND VPWR VPWR _01001_ sky130_fd_sc_hd__o22a_1
X_07594_ cpuregs\[20\]\[11\] _02630_ net245 VGND VGND VPWR VPWR _00527_ sky130_fd_sc_hd__mux2_1
Xclkbuf_leaf_126_clk clknet_4_8_0_clk VGND VGND VPWR VPWR clknet_leaf_126_clk sky130_fd_sc_hd__clkbuf_8
X_06545_ _02966_ _02973_ _02974_ _00016_ _01580_ VGND VGND VPWR VPWR _02975_ sky130_fd_sc_hd__a221o_1
XTAP_TAPCELL_ROW_47_1082 VGND VPWR sky130_fd_sc_hd__tapvpwrvgnd_1
XFILLER_139_729 VPWR VGND VPWR VGND sky130_ef_sc_hd__decap_12
XTAP_TAPCELL_ROW_16_590 VGND VPWR sky130_fd_sc_hd__tapvpwrvgnd_1
X_06476_ cpuregs\[20\]\[6\] cpuregs\[21\]\[6\] cpuregs\[22\]\[6\] cpuregs\[23\]\[6\]
+ net263 net259 VGND VGND VPWR VPWR _02908_ sky130_fd_sc_hd__mux4_1
X_09264_ mem_do_rdata mem_do_rinst mem_state\[1\] mem_state\[0\] VGND VGND VPWR VPWR
+ _04807_ sky130_fd_sc_hd__or4b_1
X_08215_ _04019_ VGND VGND VPWR VPWR _04020_ sky130_fd_sc_hd__inv_2
X_05427_ cpu_state\[6\] _01860_ _02010_ cpu_state\[4\] net191 VGND VGND VPWR VPWR
+ _02014_ sky130_fd_sc_hd__a32o_1
X_09195_ mem_rdata_q\[7\] net30 _01609_ VGND VGND VPWR VPWR _01101_ sky130_fd_sc_hd__mux2_1
XFILLER_153_209 VPWR VGND VPWR VGND sky130_ef_sc_hd__decap_12
XFILLER_146_250 VGND VGND VPWR VPWR sky130_fd_sc_hd__fill_2
X_08146_ _03938_ _03948_ _03954_ _01551_ VGND VGND VPWR VPWR _03957_ sky130_fd_sc_hd__a31o_1
XFILLER_119_442 VGND VGND VPWR VPWR sky130_fd_sc_hd__decap_6
XTAP_TAPCELL_ROW_60_1293 VGND VPWR sky130_fd_sc_hd__tapvpwrvgnd_1
X_05358_ count_instr\[55\] instr_rdinstrh _01587_ _01949_ VGND VGND VPWR VPWR _01950_
+ sky130_fd_sc_hd__a211o_1
XFILLER_150_905 VGND VGND VPWR VPWR sky130_fd_sc_hd__decap_4
X_05289_ reg_pc\[18\] decoded_imm\[18\] VGND VGND VPWR VPWR _01886_ sky130_fd_sc_hd__nor2_1
X_08077_ _03798_ _03808_ _03845_ _03891_ VGND VGND VPWR VPWR _03893_ sky130_fd_sc_hd__nand4b_1
X_07028_ cpuregs\[0\]\[26\] cpuregs\[1\]\[26\] cpuregs\[2\]\[26\] cpuregs\[3\]\[26\]
+ net267 net261 VGND VGND VPWR VPWR _03440_ sky130_fd_sc_hd__mux4_1
XFILLER_106_158 VGND VGND VPWR VPWR sky130_fd_sc_hd__decap_6
XFILLER_103_832 VGND VGND VPWR VPWR sky130_fd_sc_hd__fill_1
XFILLER_0_414 VGND VGND VPWR VPWR sky130_fd_sc_hd__fill_2
X_08979_ cpuregs\[4\]\[27\] cpuregs\[5\]\[27\] cpuregs\[6\]\[27\] cpuregs\[7\]\[27\]
+ net280 net271 VGND VGND VPWR VPWR _04654_ sky130_fd_sc_hd__mux4_1
XFILLER_88_587 VGND VGND VPWR VPWR sky130_fd_sc_hd__fill_1
XFILLER_90_218 VGND VGND VPWR VPWR sky130_fd_sc_hd__decap_3
X_10941_ clknet_leaf_94_clk _01003_ VGND VGND VPWR VPWR decoded_imm\[27\] sky130_fd_sc_hd__dfxtp_2
XTAP_TAPCELL_ROW_67_1403 VGND VPWR sky130_fd_sc_hd__tapvpwrvgnd_1
XFILLER_83_270 VGND VGND VPWR VPWR sky130_fd_sc_hd__fill_1
XFILLER_28_186 VGND VGND VPWR VPWR sky130_fd_sc_hd__fill_1
XFILLER_28_197 VGND VGND VPWR VPWR sky130_fd_sc_hd__decap_4
XFILLER_45_43 VPWR VGND VPWR VGND sky130_ef_sc_hd__decap_12
X_10872_ clknet_leaf_22_clk _00934_ VGND VGND VPWR VPWR cpuregs\[1\]\[16\] sky130_fd_sc_hd__dfxtp_1
XTAP_TAPCELL_ROW_80_1614 VGND VPWR sky130_fd_sc_hd__tapvpwrvgnd_1
XFILLER_71_498 VGND VGND VPWR VPWR sky130_fd_sc_hd__fill_1
Xclkbuf_leaf_117_clk clknet_4_10_0_clk VGND VGND VPWR VPWR clknet_leaf_117_clk sky130_fd_sc_hd__clkbuf_8
XFILLER_61_31 VPWR VGND VPWR VGND sky130_ef_sc_hd__decap_12
XTAP_TAPCELL_ROW_14_549 VGND VPWR sky130_fd_sc_hd__tapvpwrvgnd_1
XFILLER_8_514 VGND VGND VPWR VPWR sky130_fd_sc_hd__fill_1
XFILLER_138_751 VGND VGND VPWR VPWR sky130_fd_sc_hd__decap_4
X_11424_ clknet_leaf_46_clk _01468_ VGND VGND VPWR VPWR cpuregs\[8\]\[22\] sky130_fd_sc_hd__dfxtp_1
XFILLER_6_15 VPWR VGND VPWR VGND sky130_ef_sc_hd__decap_12
XFILLER_153_721 VGND VGND VPWR VPWR sky130_fd_sc_hd__decap_3
XANTENNA_8 _03001_ VGND VGND VPWR VPWR sky130_fd_sc_hd__diode_2
XFILLER_153_765 VGND VGND VPWR VPWR sky130_fd_sc_hd__fill_1
XFILLER_125_445 VGND VGND VPWR VPWR sky130_fd_sc_hd__decap_3
XTAP_TAPCELL_ROW_111_2113 VGND VPWR sky130_fd_sc_hd__tapvpwrvgnd_1
XTAP_TAPCELL_ROW_111_2102 VGND VPWR sky130_fd_sc_hd__tapvpwrvgnd_1
X_11355_ clknet_leaf_24_clk _01399_ VGND VGND VPWR VPWR cpuregs\[6\]\[17\] sky130_fd_sc_hd__dfxtp_1
XTAP_TAPCELL_ROW_78_1587 VGND VPWR sky130_fd_sc_hd__tapvpwrvgnd_1
XTAP_TAPCELL_ROW_78_1576 VGND VPWR sky130_fd_sc_hd__tapvpwrvgnd_1
XFILLER_153_776 VGND VGND VPWR VPWR sky130_fd_sc_hd__decap_4
XFILLER_152_253 VPWR VGND VPWR VGND sky130_ef_sc_hd__decap_12
XFILLER_125_467 VGND VGND VPWR VPWR sky130_fd_sc_hd__fill_1
XFILLER_98_307 VGND VGND VPWR VPWR sky130_fd_sc_hd__fill_1
X_10306_ clknet_leaf_19_clk _00436_ VGND VGND VPWR VPWR cpuregs\[26\]\[16\] sky130_fd_sc_hd__dfxtp_1
X_11286_ clknet_leaf_15_clk _01333_ VGND VGND VPWR VPWR cpuregs\[4\]\[15\] sky130_fd_sc_hd__dfxtp_1
XFILLER_140_437 VGND VGND VPWR VPWR sky130_fd_sc_hd__fill_1
XFILLER_112_139 VGND VGND VPWR VPWR sky130_fd_sc_hd__fill_1
X_10237_ clknet_leaf_147_clk _00367_ VGND VGND VPWR VPWR cpuregs\[27\]\[11\] sky130_fd_sc_hd__dfxtp_1
XFILLER_94_502 VPWR VGND VPWR VGND sky130_ef_sc_hd__decap_12
XTAP_TAPCELL_ROW_91_1787 VGND VPWR sky130_fd_sc_hd__tapvpwrvgnd_1
XFILLER_67_727 VGND VGND VPWR VPWR sky130_fd_sc_hd__fill_1
X_10168_ clknet_leaf_2_clk _00298_ VGND VGND VPWR VPWR cpuregs\[9\]\[6\] sky130_fd_sc_hd__dfxtp_1
XFILLER_66_248 VGND VGND VPWR VPWR sky130_fd_sc_hd__decap_4
X_10099_ clknet_leaf_115_clk _00229_ VGND VGND VPWR VPWR cpuregs\[28\]\[1\] sky130_fd_sc_hd__dfxtp_1
XTAP_TAPCELL_ROW_109_2075 VGND VPWR sky130_fd_sc_hd__tapvpwrvgnd_1
XFILLER_63_911 VGND VGND VPWR VPWR sky130_fd_sc_hd__fill_1
XFILLER_62_421 VGND VGND VPWR VPWR sky130_fd_sc_hd__decap_6
XFILLER_34_123 VGND VGND VPWR VPWR sky130_fd_sc_hd__fill_1
XTAP_TAPCELL_ROW_122_2286 VGND VPWR sky130_fd_sc_hd__tapvpwrvgnd_1
XFILLER_62_454 VGND VGND VPWR VPWR sky130_fd_sc_hd__fill_2
XFILLER_22_307 VGND VGND VPWR VPWR sky130_fd_sc_hd__fill_1
Xclkbuf_leaf_108_clk clknet_4_11_0_clk VGND VGND VPWR VPWR clknet_leaf_108_clk sky130_fd_sc_hd__clkbuf_8
XFILLER_16_893 VPWR VGND VPWR VGND sky130_ef_sc_hd__decap_12
XFILLER_31_841 VPWR VGND VPWR VGND sky130_ef_sc_hd__decap_12
XTAP_TAPCELL_ROW_33_858 VGND VPWR sky130_fd_sc_hd__tapvpwrvgnd_1
X_06330_ net182 decoded_imm\[1\] VGND VGND VPWR VPWR _02767_ sky130_fd_sc_hd__and2_1
X_06261_ reg_pc\[29\] reg_pc\[28\] _02694_ VGND VGND VPWR VPWR _02702_ sky130_fd_sc_hd__and3_1
X_08000_ _03807_ _03821_ _03819_ VGND VGND VPWR VPWR _03822_ sky130_fd_sc_hd__a21oi_1
X_05212_ reg_pc\[11\] decoded_imm\[11\] _01814_ VGND VGND VPWR VPWR _01815_ sky130_fd_sc_hd__a21oi_1
XFILLER_128_250 VGND VGND VPWR VPWR sky130_fd_sc_hd__fill_2
XFILLER_116_401 VPWR VGND VPWR VGND sky130_ef_sc_hd__decap_12
X_06192_ _02646_ cpuregs\[11\]\[15\] _02582_ VGND VGND VPWR VPWR _00052_ sky130_fd_sc_hd__mux2_1
XFILLER_143_220 VGND VGND VPWR VPWR sky130_fd_sc_hd__decap_4
XFILLER_132_905 VGND VGND VPWR VPWR sky130_fd_sc_hd__decap_4
XFILLER_116_445 VGND VGND VPWR VPWR sky130_fd_sc_hd__decap_3
X_05143_ count_cycle\[6\] _01588_ net256 _01751_ VGND VGND VPWR VPWR _01752_ sky130_fd_sc_hd__o211a_1
Xmax_cap266 net267 VGND VGND VPWR VPWR net266 sky130_fd_sc_hd__buf_12
XFILLER_116_489 VGND VGND VPWR VPWR sky130_fd_sc_hd__fill_2
XFILLER_89_307 VGND VGND VPWR VPWR sky130_fd_sc_hd__decap_4
Xmax_cap255 _02241_ VGND VGND VPWR VPWR net255 sky130_fd_sc_hd__buf_4
X_09951_ clknet_leaf_18_clk _00081_ VGND VGND VPWR VPWR net174 sky130_fd_sc_hd__dfxtp_4
Xmax_cap277 net278 VGND VGND VPWR VPWR net277 sky130_fd_sc_hd__buf_12
X_05074_ reg_pc\[1\] decoded_imm\[1\] VGND VGND VPWR VPWR _01688_ sky130_fd_sc_hd__or2_1
X_08902_ cpuregs\[0\]\[23\] cpuregs\[1\]\[23\] cpuregs\[2\]\[23\] cpuregs\[3\]\[23\]
+ net276 net272 VGND VGND VPWR VPWR _04581_ sky130_fd_sc_hd__mux4_1
XFILLER_112_651 VGND VGND VPWR VPWR sky130_fd_sc_hd__fill_1
XFILLER_58_716 VGND VGND VPWR VPWR sky130_fd_sc_hd__decap_4
X_09882_ cpuregs\[0\]\[12\] VGND VGND VPWR VPWR _01490_ sky130_fd_sc_hd__clkbuf_1
X_08833_ cpuregs\[4\]\[19\] cpuregs\[5\]\[19\] cpuregs\[6\]\[19\] cpuregs\[7\]\[19\]
+ net280 net274 VGND VGND VPWR VPWR _04516_ sky130_fd_sc_hd__mux4_1
XFILLER_100_813 VPWR VGND VPWR VGND sky130_ef_sc_hd__decap_12
XFILLER_97_384 VGND VGND VPWR VPWR sky130_fd_sc_hd__decap_8
XTAP_TAPCELL_ROW_142_2607 VGND VPWR sky130_fd_sc_hd__tapvpwrvgnd_1
X_08764_ _04445_ _04446_ _01558_ VGND VGND VPWR VPWR _04451_ sky130_fd_sc_hd__mux2_1
X_05976_ net172 _02491_ _01582_ VGND VGND VPWR VPWR net66 sky130_fd_sc_hd__mux2_1
XFILLER_122_15 VPWR VGND VPWR VGND sky130_ef_sc_hd__decap_12
X_07715_ count_instr\[23\] _03616_ net34 VGND VGND VPWR VPWR _03619_ sky130_fd_sc_hd__o21ai_1
X_04927_ net269 VGND VGND VPWR VPWR _01560_ sky130_fd_sc_hd__inv_16
XTAP_TAPCELL_ROW_49_1111 VGND VPWR sky130_fd_sc_hd__tapvpwrvgnd_1
XFILLER_65_281 VGND VGND VPWR VPWR sky130_fd_sc_hd__fill_1
XFILLER_53_432 VGND VGND VPWR VPWR sky130_fd_sc_hd__fill_1
XTAP_TAPCELL_ROW_49_1122 VGND VPWR sky130_fd_sc_hd__tapvpwrvgnd_1
X_08695_ net205 _01585_ _04384_ _04385_ VGND VGND VPWR VPWR _00817_ sky130_fd_sc_hd__o22a_1
XPHY_EDGE_ROW_146_Right_146 VGND VGND VPWR VPWR sky130_fd_sc_hd__decap_3
X_07646_ _02709_ cpuregs\[17\]\[30\] _03574_ VGND VGND VPWR VPWR _00578_ sky130_fd_sc_hd__mux2_1
XFILLER_25_167 VGND VGND VPWR VPWR sky130_fd_sc_hd__fill_1
XFILLER_26_668 VGND VGND VPWR VPWR sky130_fd_sc_hd__fill_2
X_07577_ cpuregs\[25\]\[28\] _02699_ _03571_ VGND VGND VPWR VPWR _00512_ sky130_fd_sc_hd__mux2_1
XTAP_TAPCELL_ROW_62_1322 VGND VPWR sky130_fd_sc_hd__tapvpwrvgnd_1
XFILLER_15_57 VPWR VGND VPWR VGND sky130_ef_sc_hd__decap_12
XFILLER_41_638 VGND VGND VPWR VPWR sky130_fd_sc_hd__decap_3
XFILLER_41_649 VPWR VGND VPWR VGND sky130_ef_sc_hd__decap_12
X_06528_ net174 _02720_ VGND VGND VPWR VPWR _02958_ sky130_fd_sc_hd__or2_1
X_09316_ latched_rd\[4\] _04815_ _04816_ decoded_rd\[4\] VGND VGND VPWR VPWR _00996_
+ sky130_fd_sc_hd__a22o_1
XFILLER_40_137 VGND VGND VPWR VPWR sky130_fd_sc_hd__decap_3
X_09247_ cpuregs\[1\]\[26\] _02691_ net244 VGND VGND VPWR VPWR _00944_ sky130_fd_sc_hd__mux2_1
XTAP_TAPCELL_ROW_11_508 VGND VPWR sky130_fd_sc_hd__tapvpwrvgnd_1
XFILLER_21_362 VGND VGND VPWR VPWR sky130_fd_sc_hd__decap_8
XFILLER_139_559 VGND VGND VPWR VPWR sky130_fd_sc_hd__fill_1
X_06459_ _00016_ _02891_ VGND VGND VPWR VPWR _02892_ sky130_fd_sc_hd__or2_1
X_09178_ mem_rdata_q\[25\] net18 _01609_ VGND VGND VPWR VPWR _01119_ sky130_fd_sc_hd__mux2_1
XFILLER_5_517 VPWR VGND VPWR VGND sky130_ef_sc_hd__decap_12
X_08129_ _03919_ _03929_ VGND VGND VPWR VPWR _03941_ sky130_fd_sc_hd__and2_1
X_11140_ clknet_leaf_33_clk _01187_ VGND VGND VPWR VPWR cpuregs\[31\]\[29\] sky130_fd_sc_hd__dfxtp_1
Xoutput56 net56 VGND VGND VPWR VPWR mem_addr[30] sky130_fd_sc_hd__buf_2
XFILLER_150_757 VPWR VGND VPWR VGND sky130_ef_sc_hd__decap_12
Xoutput45 net45 VGND VGND VPWR VPWR mem_addr[20] sky130_fd_sc_hd__buf_2
XFILLER_89_841 VGND VGND VPWR VPWR sky130_fd_sc_hd__decap_8
Xoutput67 net67 VGND VGND VPWR VPWR mem_la_addr[11] sky130_fd_sc_hd__buf_2
Xoutput78 net78 VGND VGND VPWR VPWR mem_la_addr[22] sky130_fd_sc_hd__buf_2
XFILLER_103_662 VGND VGND VPWR VPWR sky130_fd_sc_hd__fill_1
Xoutput89 net89 VGND VGND VPWR VPWR mem_la_addr[3] sky130_fd_sc_hd__buf_2
X_11071_ clknet_leaf_120_clk _01128_ VGND VGND VPWR VPWR cpuregs\[24\]\[2\] sky130_fd_sc_hd__dfxtp_1
X_10022_ clknet_leaf_73_clk _00152_ VGND VGND VPWR VPWR cpuregs\[30\]\[20\] sky130_fd_sc_hd__dfxtp_1
XFILLER_88_395 VGND VGND VPWR VPWR sky130_fd_sc_hd__fill_2
XFILLER_76_524 VGND VGND VPWR VPWR sky130_fd_sc_hd__decap_8
XTAP_TAPCELL_ROW_73_1495 VGND VPWR sky130_fd_sc_hd__tapvpwrvgnd_1
XFILLER_0_277 VGND VGND VPWR VPWR sky130_fd_sc_hd__decap_3
XFILLER_56_97 VGND VGND VPWR VPWR sky130_fd_sc_hd__decap_3
XFILLER_44_421 VPWR VGND VPWR VGND sky130_ef_sc_hd__decap_12
X_10924_ clknet_leaf_36_clk _00986_ VGND VGND VPWR VPWR net158 sky130_fd_sc_hd__dfxtp_1
XPHY_EDGE_ROW_113_Right_113 VGND VGND VPWR VPWR sky130_fd_sc_hd__decap_3
XFILLER_72_41 VGND VGND VPWR VPWR sky130_fd_sc_hd__decap_8
X_10855_ clknet_leaf_102_clk _00917_ VGND VGND VPWR VPWR is_beq_bne_blt_bge_bltu_bgeu
+ sky130_fd_sc_hd__dfxtp_2
XFILLER_31_104 VGND VGND VPWR VPWR sky130_fd_sc_hd__decap_8
XFILLER_13_841 VPWR VGND VPWR VGND sky130_ef_sc_hd__decap_12
XFILLER_31_126 VGND VGND VPWR VPWR sky130_fd_sc_hd__decap_4
X_10786_ clknet_leaf_98_clk _00851_ VGND VGND VPWR VPWR instr_bltu sky130_fd_sc_hd__dfxtp_1
XTAP_TAPCELL_ROW_30_806 VGND VPWR sky130_fd_sc_hd__tapvpwrvgnd_1
XTAP_TAPCELL_ROW_30_817 VGND VPWR sky130_fd_sc_hd__tapvpwrvgnd_1
XFILLER_12_384 VGND VGND VPWR VPWR sky130_fd_sc_hd__decap_6
XFILLER_138_570 VPWR VGND VPWR VGND sky130_ef_sc_hd__decap_12
XFILLER_9_889 VGND VGND VPWR VPWR sky130_fd_sc_hd__decap_6
XTAP_TAPCELL_ROW_93_1816 VGND VPWR sky130_fd_sc_hd__tapvpwrvgnd_1
X_11407_ clknet_leaf_137_clk _01451_ VGND VGND VPWR VPWR cpuregs\[8\]\[5\] sky130_fd_sc_hd__dfxtp_1
XFILLER_99_627 VGND VGND VPWR VPWR sky130_fd_sc_hd__decap_4
XTAP_TAPCELL_ROW_93_1827 VGND VPWR sky130_fd_sc_hd__tapvpwrvgnd_1
X_11338_ clknet_leaf_124_clk _01382_ VGND VGND VPWR VPWR cpuregs\[6\]\[0\] sky130_fd_sc_hd__dfxtp_1
XFILLER_141_779 VGND VGND VPWR VPWR sky130_fd_sc_hd__decap_4
XFILLER_140_234 VPWR VGND VPWR VGND sky130_ef_sc_hd__decap_12
X_11269_ clknet_leaf_33_clk _01316_ VGND VGND VPWR VPWR cpuregs\[22\]\[30\] sky130_fd_sc_hd__dfxtp_1
XFILLER_95_811 VPWR VGND VPWR VGND sky130_ef_sc_hd__decap_12
Xsplit220 net609 VGND VGND VPWR VPWR net606 sky130_fd_sc_hd__clkbuf_8
X_05830_ _02096_ _02391_ VGND VGND VPWR VPWR _02392_ sky130_fd_sc_hd__nand2_1
XFILLER_95_866 VGND VGND VPWR VPWR sky130_fd_sc_hd__decap_3
XFILLER_11_3 VPWR VGND VPWR VGND sky130_ef_sc_hd__decap_12
XTAP_TAPCELL_ROW_124_2315 VGND VPWR sky130_fd_sc_hd__tapvpwrvgnd_1
XFILLER_94_365 VGND VGND VPWR VPWR sky130_fd_sc_hd__decap_4
X_07500_ cpuregs\[26\]\[18\] _02657_ _03568_ VGND VGND VPWR VPWR _00438_ sky130_fd_sc_hd__mux2_1
X_05761_ _02151_ _02238_ _02324_ _02330_ VGND VGND VPWR VPWR alu_out\[13\] sky130_fd_sc_hd__a211o_1
XTAP_TAPCELL_ROW_38_939 VGND VPWR sky130_fd_sc_hd__tapvpwrvgnd_1
XFILLER_47_281 VPWR VGND VPWR VGND sky130_ef_sc_hd__decap_12
XFILLER_62_251 VGND VGND VPWR VPWR sky130_fd_sc_hd__fill_1
X_05692_ _02269_ _02186_ instr_sub VGND VGND VPWR VPWR _02270_ sky130_fd_sc_hd__mux2_1
X_08480_ net94 net63 _04208_ VGND VGND VPWR VPWR _00778_ sky130_fd_sc_hd__mux2_1
X_07431_ cpuregs\[27\]\[15\] _02646_ _03566_ VGND VGND VPWR VPWR _00371_ sky130_fd_sc_hd__mux2_1
XFILLER_63_785 VGND VGND VPWR VPWR sky130_fd_sc_hd__decap_3
XFILLER_35_487 VPWR VGND VPWR VGND sky130_ef_sc_hd__decap_12
XTAP_TAPCELL_ROW_102_1956 VGND VPWR sky130_fd_sc_hd__tapvpwrvgnd_1
X_07362_ _02638_ cpuregs\[9\]\[13\] _03563_ VGND VGND VPWR VPWR _00305_ sky130_fd_sc_hd__mux2_1
XTAP_TAPCELL_ROW_44_1030 VGND VPWR sky130_fd_sc_hd__tapvpwrvgnd_1
XTAP_TAPCELL_ROW_44_1041 VGND VPWR sky130_fd_sc_hd__tapvpwrvgnd_1
XTAP_TAPCELL_ROW_102_1967 VGND VPWR sky130_fd_sc_hd__tapvpwrvgnd_1
X_09101_ mem_rdata_q\[13\] _01557_ mem_rdata_q\[14\] VGND VGND VPWR VPWR _04754_ sky130_fd_sc_hd__and3b_1
X_06313_ net171 _02750_ _02724_ VGND VGND VPWR VPWR _00069_ sky130_fd_sc_hd__mux2_1
X_07293_ cpuregs\[28\]\[11\] _02630_ net249 VGND VGND VPWR VPWR _00239_ sky130_fd_sc_hd__mux2_1
X_06244_ _02688_ cpuregs\[11\]\[25\] _02582_ VGND VGND VPWR VPWR _00062_ sky130_fd_sc_hd__mux2_1
X_09032_ cpuregs\[20\]\[30\] cpuregs\[21\]\[30\] cpuregs\[22\]\[30\] cpuregs\[23\]\[30\]
+ net275 net271 VGND VGND VPWR VPWR _04704_ sky130_fd_sc_hd__mux4_1
XTAP_TAPCELL_ROW_135_2499 VGND VPWR sky130_fd_sc_hd__tapvpwrvgnd_1
XTAP_TAPCELL_ROW_135_2488 VGND VPWR sky130_fd_sc_hd__tapvpwrvgnd_1
X_06175_ _02631_ _02632_ _02584_ VGND VGND VPWR VPWR _02633_ sky130_fd_sc_hd__mux2_8
XFILLER_116_253 VGND VGND VPWR VPWR sky130_fd_sc_hd__fill_2
X_05126_ _01716_ _01719_ VGND VGND VPWR VPWR _01736_ sky130_fd_sc_hd__nor2_1
X_05057_ net608 net171 _01667_ _01672_ VGND VGND VPWR VPWR net130 sky130_fd_sc_hd__a2bb2o_4
X_09934_ clknet_leaf_111_clk _00027_ VGND VGND VPWR VPWR _00007_ sky130_fd_sc_hd__dfxtp_4
XFILLER_98_693 VGND VGND VPWR VPWR sky130_fd_sc_hd__decap_6
X_09865_ decoded_imm_j\[18\] _01112_ _02513_ VGND VGND VPWR VPWR _00906_ sky130_fd_sc_hd__mux2_1
X_08816_ cpuregs\[8\]\[18\] cpuregs\[9\]\[18\] cpuregs\[10\]\[18\] cpuregs\[11\]\[18\]
+ net276 net272 VGND VGND VPWR VPWR _04500_ sky130_fd_sc_hd__mux4_1
XFILLER_100_632 VGND VGND VPWR VPWR sky130_fd_sc_hd__decap_6
XFILLER_86_877 VGND VGND VPWR VPWR sky130_fd_sc_hd__fill_1
XFILLER_133_69 VGND VGND VPWR VPWR sky130_fd_sc_hd__decap_8
XFILLER_73_505 VGND VGND VPWR VPWR sky130_fd_sc_hd__decap_8
XFILLER_58_579 VGND VGND VPWR VPWR sky130_fd_sc_hd__decap_8
X_09796_ _02593_ cpuregs\[8\]\[3\] _04875_ VGND VGND VPWR VPWR _01449_ sky130_fd_sc_hd__mux2_1
XFILLER_39_771 VGND VGND VPWR VPWR sky130_fd_sc_hd__decap_3
X_08747_ _04422_ _04423_ net270 VGND VGND VPWR VPWR _04435_ sky130_fd_sc_hd__mux2_1
XFILLER_26_421 VGND VGND VPWR VPWR sky130_fd_sc_hd__decap_3
X_05959_ reg_out\[2\] reg_next_pc\[2\] net597 VGND VGND VPWR VPWR _02483_ sky130_fd_sc_hd__mux2_1
X_08678_ decoded_imm\[10\] _01654_ _01586_ VGND VGND VPWR VPWR _04370_ sky130_fd_sc_hd__a21o_1
XFILLER_81_582 VGND VGND VPWR VPWR sky130_fd_sc_hd__decap_6
X_07629_ _02638_ cpuregs\[17\]\[13\] _03574_ VGND VGND VPWR VPWR _00561_ sky130_fd_sc_hd__mux2_1
X_10640_ clknet_leaf_78_clk _00770_ VGND VGND VPWR VPWR count_cycle\[63\] sky130_fd_sc_hd__dfxtp_1
XFILLER_139_312 VGND VGND VPWR VPWR sky130_fd_sc_hd__fill_1
XFILLER_10_811 VGND VGND VPWR VPWR sky130_fd_sc_hd__fill_1
X_10571_ clknet_leaf_65_clk _00701_ VGND VGND VPWR VPWR reg_next_pc\[26\] sky130_fd_sc_hd__dfxtp_1
XFILLER_42_66 VGND VGND VPWR VPWR sky130_fd_sc_hd__decap_8
XFILLER_139_389 VGND VGND VPWR VPWR sky130_fd_sc_hd__decap_3
XFILLER_6_837 VPWR VGND VPWR VGND sky130_ef_sc_hd__decap_12
XFILLER_21_192 VGND VGND VPWR VPWR sky130_fd_sc_hd__fill_2
XPHY_EDGE_ROW_125_Left_279 VGND VGND VPWR VPWR sky130_fd_sc_hd__decap_3
XTAP_TAPCELL_ROW_75_1535 VGND VPWR sky130_fd_sc_hd__tapvpwrvgnd_1
XTAP_TAPCELL_ROW_75_1524 VGND VPWR sky130_fd_sc_hd__tapvpwrvgnd_1
XFILLER_122_212 VGND VGND VPWR VPWR sky130_fd_sc_hd__decap_6
X_11123_ clknet_leaf_12_clk _01170_ VGND VGND VPWR VPWR cpuregs\[31\]\[12\] sky130_fd_sc_hd__dfxtp_1
XFILLER_3_27 VPWR VGND VPWR VGND sky130_ef_sc_hd__decap_12
XFILLER_1_553 VGND VGND VPWR VPWR sky130_fd_sc_hd__decap_6
XFILLER_150_587 VGND VGND VPWR VPWR sky130_fd_sc_hd__fill_1
X_11054_ clknet_leaf_88_clk _01111_ VGND VGND VPWR VPWR mem_rdata_q\[17\] sky130_fd_sc_hd__dfxtp_1
XFILLER_76_321 VGND VGND VPWR VPWR sky130_fd_sc_hd__decap_4
X_10005_ clknet_leaf_123_clk _00135_ VGND VGND VPWR VPWR cpuregs\[30\]\[3\] sky130_fd_sc_hd__dfxtp_1
XPHY_EDGE_ROW_134_Left_288 VGND VGND VPWR VPWR sky130_fd_sc_hd__decap_3
XFILLER_76_365 VGND VGND VPWR VPWR sky130_fd_sc_hd__decap_4
XFILLER_18_911 VGND VGND VPWR VPWR sky130_fd_sc_hd__fill_1
XFILLER_37_708 VGND VGND VPWR VPWR sky130_fd_sc_hd__decap_6
XTAP_TAPCELL_ROW_106_2034 VGND VPWR sky130_fd_sc_hd__tapvpwrvgnd_1
XTAP_TAPCELL_ROW_106_2023 VGND VPWR sky130_fd_sc_hd__tapvpwrvgnd_1
XFILLER_91_335 VGND VGND VPWR VPWR sky130_fd_sc_hd__fill_1
XTAP_TAPCELL_ROW_4_391 VGND VPWR sky130_fd_sc_hd__tapvpwrvgnd_1
XFILLER_91_357 VPWR VGND VPWR VGND sky130_ef_sc_hd__decap_12
XFILLER_83_73 VGND VGND VPWR VPWR sky130_fd_sc_hd__decap_6
X_10907_ clknet_leaf_28_clk _00969_ VGND VGND VPWR VPWR net139 sky130_fd_sc_hd__dfxtp_1
XFILLER_17_476 VGND VGND VPWR VPWR sky130_fd_sc_hd__fill_1
XFILLER_44_251 VGND VGND VPWR VPWR sky130_fd_sc_hd__fill_1
XFILLER_45_785 VGND VGND VPWR VPWR sky130_fd_sc_hd__fill_1
X_10838_ clknet_leaf_88_clk _00903_ VGND VGND VPWR VPWR decoded_imm_j\[15\] sky130_fd_sc_hd__dfxtp_1
XFILLER_13_671 VGND VGND VPWR VPWR sky130_fd_sc_hd__fill_1
X_10769_ clknet_leaf_65_clk alu_out\[22\] VGND VGND VPWR VPWR alu_out_q\[22\] sky130_fd_sc_hd__dfxtp_1
XFILLER_13_682 VGND VGND VPWR VPWR sky130_fd_sc_hd__decap_8
XFILLER_146_849 VPWR VGND VPWR VGND sky130_ef_sc_hd__decap_12
XPHY_EDGE_ROW_143_Left_297 VGND VGND VPWR VPWR sky130_fd_sc_hd__decap_3
XFILLER_8_141 VGND VGND VPWR VPWR sky130_fd_sc_hd__decap_3
XFILLER_12_192 VGND VGND VPWR VPWR sky130_fd_sc_hd__decap_4
XTAP_TAPCELL_ROW_117_2196 VGND VPWR sky130_fd_sc_hd__tapvpwrvgnd_1
X_07980_ _03576_ _03803_ VGND VGND VPWR VPWR _03804_ sky130_fd_sc_hd__nor2_1
X_06931_ decoded_imm\[23\] net186 VGND VGND VPWR VPWR _03346_ sky130_fd_sc_hd__nor2_1
X_09650_ _02678_ cpuregs\[22\]\[23\] _04869_ VGND VGND VPWR VPWR _01309_ sky130_fd_sc_hd__mux2_1
XFILLER_67_343 VPWR VGND VPWR VGND sky130_ef_sc_hd__decap_12
X_06862_ cpuregs\[20\]\[20\] cpuregs\[21\]\[20\] cpuregs\[22\]\[20\] cpuregs\[23\]\[20\]
+ _00012_ _00013_ VGND VGND VPWR VPWR _03280_ sky130_fd_sc_hd__mux4_1
XFILLER_95_663 VGND VGND VPWR VPWR sky130_fd_sc_hd__fill_2
XFILLER_55_505 VPWR VGND VPWR VGND sky130_ef_sc_hd__decap_12
XFILLER_28_708 VGND VGND VPWR VPWR sky130_fd_sc_hd__decap_6
X_08601_ _04295_ _04296_ _04266_ _04293_ VGND VGND VPWR VPWR _04297_ sky130_fd_sc_hd__o211a_1
X_09581_ cpuregs\[29\]\[20\] _02665_ _04867_ VGND VGND VPWR VPWR _01242_ sky130_fd_sc_hd__mux2_1
X_05813_ _02101_ _02376_ _02238_ _02100_ VGND VGND VPWR VPWR _02377_ sky130_fd_sc_hd__a2bb2o_1
X_06793_ decoded_imm\[18\] net180 VGND VGND VPWR VPWR _03213_ sky130_fd_sc_hd__xor2_1
XFILLER_27_218 VGND VGND VPWR VPWR sky130_fd_sc_hd__fill_1
X_05744_ _02124_ _02314_ VGND VGND VPWR VPWR _02315_ sky130_fd_sc_hd__nor2_1
X_08532_ _04232_ _04233_ _01558_ VGND VGND VPWR VPWR _04234_ sky130_fd_sc_hd__mux2_1
XFILLER_91_880 VGND VGND VPWR VPWR sky130_fd_sc_hd__fill_2
X_08463_ _01579_ _04199_ _04196_ _04198_ VGND VGND VPWR VPWR _04200_ sky130_fd_sc_hd__o2bb2a_1
XFILLER_36_774 VGND VGND VPWR VPWR sky130_fd_sc_hd__decap_3
X_07414_ latched_rd\[2\] latched_rd\[3\] latched_rd\[4\] _02580_ VGND VGND VPWR VPWR
+ _03565_ sky130_fd_sc_hd__and4b_1
X_05675_ _02165_ _02238_ _02255_ _02166_ VGND VGND VPWR VPWR _02256_ sky130_fd_sc_hd__o2bb2a_1
XTAP_TAPCELL_ROW_137_2517 VGND VPWR sky130_fd_sc_hd__tapvpwrvgnd_1
X_08394_ _04144_ _04145_ VGND VGND VPWR VPWR _00756_ sky130_fd_sc_hd__nor2_1
XTAP_TAPCELL_ROW_137_2528 VGND VPWR sky130_fd_sc_hd__tapvpwrvgnd_1
X_07345_ cpuregs\[21\]\[29\] _02704_ net248 VGND VGND VPWR VPWR _00289_ sky130_fd_sc_hd__mux2_1
XFILLER_148_153 VPWR VGND VPWR VGND sky130_ef_sc_hd__decap_12
X_07276_ cpuregs\[2\]\[27\] _02696_ net250 VGND VGND VPWR VPWR _00223_ sky130_fd_sc_hd__mux2_1
Xclkbuf_leaf_30_clk clknet_4_4_0_clk VGND VGND VPWR VPWR clknet_leaf_30_clk sky130_fd_sc_hd__clkbuf_8
XTAP_TAPCELL_ROW_21_669 VGND VPWR sky130_fd_sc_hd__tapvpwrvgnd_1
XTAP_TAPCELL_ROW_150_2728 VGND VPWR sky130_fd_sc_hd__tapvpwrvgnd_1
XFILLER_148_197 VPWR VGND VPWR VGND sky130_ef_sc_hd__decap_12
X_06227_ _02671_ _02674_ _02584_ VGND VGND VPWR VPWR _02675_ sky130_fd_sc_hd__mux2_8
X_09015_ _01558_ _04687_ VGND VGND VPWR VPWR _04688_ sky130_fd_sc_hd__or2_1
XTAP_TAPCELL_ROW_150_2739 VGND VPWR sky130_fd_sc_hd__tapvpwrvgnd_1
XFILLER_132_521 VGND VGND VPWR VPWR sky130_fd_sc_hd__decap_8
XFILLER_117_573 VPWR VGND VPWR VGND sky130_ef_sc_hd__decap_12
XFILLER_88_29 VPWR VGND VPWR VGND sky130_ef_sc_hd__decap_12
X_06158_ reg_pc\[9\] reg_pc\[8\] _02610_ VGND VGND VPWR VPWR _02619_ sky130_fd_sc_hd__and3_1
XTAP_TAPCELL_ROW_57_1243 VGND VPWR sky130_fd_sc_hd__tapvpwrvgnd_1
XFILLER_2_328 VGND VGND VPWR VPWR sky130_fd_sc_hd__decap_8
XFILLER_2_339 VPWR VGND VPWR VGND sky130_ef_sc_hd__decap_12
X_06089_ cpuregs\[4\]\[4\] cpuregs\[5\]\[4\] cpuregs\[6\]\[4\] cpuregs\[7\]\[4\] net278
+ net273 VGND VGND VPWR VPWR _02560_ sky130_fd_sc_hd__mux4_1
X_05109_ _01715_ _01717_ _01718_ VGND VGND VPWR VPWR _01720_ sky130_fd_sc_hd__a21o_1
XFILLER_120_738 VPWR VGND VPWR VGND sky130_ef_sc_hd__decap_12
X_09917_ clknet_leaf_11_clk _00052_ VGND VGND VPWR VPWR cpuregs\[11\]\[15\] sky130_fd_sc_hd__dfxtp_1
XFILLER_59_822 VPWR VGND VPWR VGND sky130_ef_sc_hd__decap_12
XTAP_TAPCELL_ROW_70_1454 VGND VPWR sky130_fd_sc_hd__tapvpwrvgnd_1
Xclkbuf_leaf_97_clk clknet_4_9_0_clk VGND VGND VPWR VPWR clknet_leaf_97_clk sky130_fd_sc_hd__clkbuf_8
X_09848_ _02675_ cpuregs\[10\]\[22\] _04876_ VGND VGND VPWR VPWR _01532_ sky130_fd_sc_hd__mux2_1
XFILLER_86_652 VGND VGND VPWR VPWR sky130_fd_sc_hd__fill_1
XFILLER_85_140 VGND VGND VPWR VPWR sky130_fd_sc_hd__decap_3
X_09779_ _02662_ cpuregs\[7\]\[19\] _04874_ VGND VGND VPWR VPWR _01433_ sky130_fd_sc_hd__mux2_1
XFILLER_85_184 VGND VGND VPWR VPWR sky130_fd_sc_hd__decap_6
XFILLER_73_324 VPWR VGND VPWR VGND sky130_ef_sc_hd__decap_12
XFILLER_37_55 VGND VGND VPWR VPWR sky130_fd_sc_hd__fill_1
XFILLER_73_357 VPWR VGND VPWR VGND sky130_ef_sc_hd__decap_12
XTAP_TAPCELL_ROW_1_350 VGND VPWR sky130_fd_sc_hd__tapvpwrvgnd_1
XFILLER_82_880 VGND VGND VPWR VPWR sky130_fd_sc_hd__fill_1
XFILLER_27_785 VPWR VGND VPWR VGND sky130_ef_sc_hd__decap_12
XFILLER_26_295 VPWR VGND VPWR VGND sky130_ef_sc_hd__decap_12
XFILLER_41_221 VGND VGND VPWR VPWR sky130_fd_sc_hd__decap_3
XFILLER_14_457 VGND VGND VPWR VPWR sky130_fd_sc_hd__decap_4
X_10623_ clknet_leaf_85_clk _00753_ VGND VGND VPWR VPWR count_cycle\[46\] sky130_fd_sc_hd__dfxtp_1
Xclkbuf_leaf_21_clk clknet_4_4_0_clk VGND VGND VPWR VPWR clknet_leaf_21_clk sky130_fd_sc_hd__clkbuf_8
X_10554_ clknet_leaf_131_clk _00684_ VGND VGND VPWR VPWR reg_next_pc\[9\] sky130_fd_sc_hd__dfxtp_1
XFILLER_10_630 VPWR VGND VPWR VGND sky130_ef_sc_hd__decap_12
XFILLER_6_601 VGND VGND VPWR VPWR sky130_fd_sc_hd__decap_3
XTAP_TAPCELL_ROW_40_967 VGND VPWR sky130_fd_sc_hd__tapvpwrvgnd_1
XTAP_TAPCELL_ROW_40_978 VGND VPWR sky130_fd_sc_hd__tapvpwrvgnd_1
XFILLER_128_849 VPWR VGND VPWR VGND sky130_ef_sc_hd__decap_12
XFILLER_127_337 VGND VGND VPWR VPWR sky130_fd_sc_hd__decap_4
XFILLER_5_111 VGND VGND VPWR VPWR sky130_fd_sc_hd__fill_1
X_10485_ clknet_leaf_107_clk _00615_ VGND VGND VPWR VPWR count_instr\[34\] sky130_fd_sc_hd__dfxtp_1
XFILLER_136_893 VPWR VGND VPWR VGND sky130_ef_sc_hd__decap_12
XFILLER_151_841 VPWR VGND VPWR VGND sky130_ef_sc_hd__decap_12
XFILLER_123_554 VGND VGND VPWR VPWR sky130_fd_sc_hd__decap_6
XFILLER_123_565 VGND VGND VPWR VPWR sky130_fd_sc_hd__fill_1
XFILLER_111_727 VGND VGND VPWR VPWR sky130_fd_sc_hd__fill_1
XTAP_TAPCELL_ROW_9_483 VGND VPWR sky130_fd_sc_hd__tapvpwrvgnd_1
XTAP_TAPCELL_ROW_9_472 VGND VPWR sky130_fd_sc_hd__tapvpwrvgnd_1
X_11106_ clknet_leaf_101_clk _00019_ VGND VGND VPWR VPWR cpu_state\[2\] sky130_fd_sc_hd__dfxtp_4
XFILLER_96_449 VPWR VGND VPWR VGND sky130_ef_sc_hd__decap_12
Xclkbuf_leaf_88_clk clknet_4_14_0_clk VGND VGND VPWR VPWR clknet_leaf_88_clk sky130_fd_sc_hd__clkbuf_8
XFILLER_110_259 VPWR VGND VPWR VGND sky130_ef_sc_hd__decap_12
XFILLER_92_600 VGND VGND VPWR VPWR sky130_fd_sc_hd__fill_1
X_11037_ clknet_leaf_104_clk _01094_ VGND VGND VPWR VPWR mem_rdata_q\[0\] sky130_fd_sc_hd__dfxtp_1
XTAP_TAPCELL_ROW_88_1737 VGND VPWR sky130_fd_sc_hd__tapvpwrvgnd_1
XFILLER_77_685 VGND VGND VPWR VPWR sky130_fd_sc_hd__fill_1
XFILLER_64_302 VGND VGND VPWR VPWR sky130_fd_sc_hd__decap_6
XFILLER_49_376 VGND VGND VPWR VPWR sky130_fd_sc_hd__fill_2
XFILLER_94_83 VGND VGND VPWR VPWR sky130_fd_sc_hd__fill_1
XFILLER_91_121 VGND VGND VPWR VPWR sky130_fd_sc_hd__decap_3
XTAP_TAPCELL_ROW_28_780 VGND VPWR sky130_fd_sc_hd__tapvpwrvgnd_1
XPHY_EDGE_ROW_151_Left_305 VGND VGND VPWR VPWR sky130_fd_sc_hd__decap_3
X_05460_ count_cycle\[31\] _01588_ VGND VGND VPWR VPWR _02044_ sky130_fd_sc_hd__or2_1
XFILLER_33_766 VGND VGND VPWR VPWR sky130_fd_sc_hd__fill_1
XTAP_TAPCELL_ROW_119_2236 VGND VPWR sky130_fd_sc_hd__tapvpwrvgnd_1
X_05391_ reg_pc\[26\] decoded_imm\[26\] VGND VGND VPWR VPWR _01980_ sky130_fd_sc_hd__or2_1
XFILLER_32_276 VGND VGND VPWR VPWR sky130_fd_sc_hd__decap_3
XFILLER_118_315 VGND VGND VPWR VPWR sky130_fd_sc_hd__fill_1
X_07130_ cpuregs\[4\]\[30\] cpuregs\[5\]\[30\] cpuregs\[6\]\[30\] cpuregs\[7\]\[30\]
+ net266 net261 VGND VGND VPWR VPWR _03538_ sky130_fd_sc_hd__mux4_1
Xclkbuf_leaf_12_clk clknet_4_1_0_clk VGND VGND VPWR VPWR clknet_leaf_12_clk sky130_fd_sc_hd__clkbuf_8
XFILLER_146_657 VPWR VGND VPWR VGND sky130_ef_sc_hd__decap_12
XTAP_TAPCELL_ROW_132_2447 VGND VPWR sky130_fd_sc_hd__tapvpwrvgnd_1
XTAP_TAPCELL_ROW_132_2436 VGND VPWR sky130_fd_sc_hd__tapvpwrvgnd_1
X_07061_ _00015_ _03468_ _03471_ _02735_ VGND VGND VPWR VPWR _03472_ sky130_fd_sc_hd__o211a_1
Xoutput213 net213 VGND VGND VPWR VPWR pcpi_rs2[19] sky130_fd_sc_hd__buf_2
X_06012_ net191 _02509_ _01582_ VGND VGND VPWR VPWR net84 sky130_fd_sc_hd__mux2_1
XFILLER_126_381 VGND VGND VPWR VPWR sky130_fd_sc_hd__decap_6
Xoutput224 net224 VGND VGND VPWR VPWR pcpi_rs2[29] sky130_fd_sc_hd__buf_2
Xoutput202 net202 VGND VGND VPWR VPWR pcpi_rs1[9] sky130_fd_sc_hd__buf_2
Xoutput235 net235 VGND VGND VPWR VPWR trap sky130_fd_sc_hd__buf_2
XFILLER_114_554 VPWR VGND VPWR VGND sky130_ef_sc_hd__decap_12
XFILLER_87_405 VGND VGND VPWR VPWR sky130_fd_sc_hd__decap_4
Xclkbuf_leaf_79_clk clknet_4_15_0_clk VGND VGND VPWR VPWR clknet_leaf_79_clk sky130_fd_sc_hd__clkbuf_8
XFILLER_101_215 VGND VGND VPWR VPWR sky130_fd_sc_hd__decap_8
X_07963_ _03787_ VGND VGND VPWR VPWR _03788_ sky130_fd_sc_hd__inv_2
X_06914_ cpuregs\[28\]\[22\] cpuregs\[29\]\[22\] cpuregs\[30\]\[22\] cpuregs\[31\]\[22\]
+ net266 net261 VGND VGND VPWR VPWR _03330_ sky130_fd_sc_hd__mux4_1
XFILLER_114_27 VGND VGND VPWR VPWR sky130_fd_sc_hd__fill_1
XFILLER_67_151 VPWR VGND VPWR VGND sky130_ef_sc_hd__decap_12
XTAP_TAPCELL_ROW_52_1162 VGND VPWR sky130_fd_sc_hd__tapvpwrvgnd_1
X_09702_ _02616_ cpuregs\[5\]\[8\] _04872_ VGND VGND VPWR VPWR _01358_ sky130_fd_sc_hd__mux2_1
X_07894_ decoded_imm_j\[2\] _03688_ VGND VGND VPWR VPWR _03725_ sky130_fd_sc_hd__and2_1
XTAP_TAPCELL_ROW_147_2690 VGND VPWR sky130_fd_sc_hd__tapvpwrvgnd_1
X_06845_ net183 _02725_ VGND VGND VPWR VPWR _03263_ sky130_fd_sc_hd__and2_1
XFILLER_95_493 VGND VGND VPWR VPWR sky130_fd_sc_hd__decap_8
XFILLER_28_549 VGND VGND VPWR VPWR sky130_fd_sc_hd__fill_1
X_09633_ _02607_ cpuregs\[22\]\[6\] _04869_ VGND VGND VPWR VPWR _01292_ sky130_fd_sc_hd__mux2_1
XFILLER_55_357 VPWR VGND VPWR VGND sky130_ef_sc_hd__decap_12
XFILLER_55_346 VGND VGND VPWR VPWR sky130_fd_sc_hd__fill_2
XFILLER_55_335 VGND VGND VPWR VPWR sky130_fd_sc_hd__fill_1
X_09564_ cpuregs\[29\]\[3\] _02593_ net239 VGND VGND VPWR VPWR _01225_ sky130_fd_sc_hd__mux2_1
XFILLER_130_15 VPWR VGND VPWR VGND sky130_ef_sc_hd__decap_12
X_06776_ cpuregs\[24\]\[17\] cpuregs\[25\]\[17\] cpuregs\[26\]\[17\] cpuregs\[27\]\[17\]
+ net265 net260 VGND VGND VPWR VPWR _03197_ sky130_fd_sc_hd__mux4_1
X_08515_ _01552_ net256 VGND VGND VPWR VPWR _04218_ sky130_fd_sc_hd__nand2_1
X_05727_ _02135_ _02295_ _02136_ VGND VGND VPWR VPWR _02300_ sky130_fd_sc_hd__a21oi_1
XFILLER_51_541 VGND VGND VPWR VPWR sky130_fd_sc_hd__fill_2
X_09495_ cpuregs\[31\]\[0\] _02586_ net240 VGND VGND VPWR VPWR _01158_ sky130_fd_sc_hd__mux2_1
X_05658_ is_compare _02237_ _02238_ _02240_ VGND VGND VPWR VPWR _02241_ sky130_fd_sc_hd__nor4_4
X_08446_ net259 _04182_ VGND VGND VPWR VPWR _04183_ sky130_fd_sc_hd__or2_1
X_08377_ count_cycle\[43\] _04133_ net34 VGND VGND VPWR VPWR _04135_ sky130_fd_sc_hd__o21ai_1
X_07328_ cpuregs\[21\]\[12\] _02633_ net248 VGND VGND VPWR VPWR _00272_ sky130_fd_sc_hd__mux2_1
X_05589_ _02127_ _02143_ _02167_ _02170_ VGND VGND VPWR VPWR _02172_ sky130_fd_sc_hd__or4_1
XFILLER_23_57 VPWR VGND VPWR VGND sky130_ef_sc_hd__decap_12
XFILLER_139_57 VPWR VGND VPWR VGND sky130_ef_sc_hd__decap_12
XFILLER_109_337 VGND VGND VPWR VPWR sky130_fd_sc_hd__decap_4
XFILLER_125_808 VPWR VGND VPWR VGND sky130_ef_sc_hd__decap_12
XFILLER_124_307 VGND VGND VPWR VPWR sky130_fd_sc_hd__fill_1
X_07259_ cpuregs\[2\]\[10\] _02624_ net250 VGND VGND VPWR VPWR _00206_ sky130_fd_sc_hd__mux2_1
XFILLER_118_893 VPWR VGND VPWR VGND sky130_ef_sc_hd__decap_12
X_10270_ clknet_leaf_9_clk _00400_ VGND VGND VPWR VPWR cpuregs\[15\]\[12\] sky130_fd_sc_hd__dfxtp_1
XFILLER_151_137 VPWR VGND VPWR VGND sky130_ef_sc_hd__decap_12
XFILLER_133_841 VPWR VGND VPWR VGND sky130_ef_sc_hd__decap_12
XFILLER_105_532 VGND VGND VPWR VPWR sky130_fd_sc_hd__fill_1
XFILLER_105_565 VGND VGND VPWR VPWR sky130_fd_sc_hd__fill_1
XTAP_TAPCELL_ROW_6_420 VGND VPWR sky130_fd_sc_hd__tapvpwrvgnd_1
XFILLER_78_438 VGND VGND VPWR VPWR sky130_fd_sc_hd__fill_1
XTAP_TAPCELL_ROW_6_431 VGND VPWR sky130_fd_sc_hd__tapvpwrvgnd_1
XFILLER_120_568 VPWR VGND VPWR VGND sky130_ef_sc_hd__decap_12
XFILLER_48_65 VGND VGND VPWR VPWR sky130_fd_sc_hd__decap_3
XFILLER_64_53 VGND VGND VPWR VPWR sky130_fd_sc_hd__decap_8
XFILLER_15_700 VGND VGND VPWR VPWR sky130_fd_sc_hd__decap_4
XTAP_TAPCELL_ROW_83_1656 VGND VPWR sky130_fd_sc_hd__tapvpwrvgnd_1
XFILLER_55_891 VGND VGND VPWR VPWR sky130_fd_sc_hd__decap_4
XTAP_TAPCELL_ROW_83_1667 VGND VPWR sky130_fd_sc_hd__tapvpwrvgnd_1
XFILLER_9_15 VPWR VGND VPWR VGND sky130_ef_sc_hd__decap_12
XFILLER_14_243 VGND VGND VPWR VPWR sky130_fd_sc_hd__decap_8
XFILLER_42_563 VGND VGND VPWR VPWR sky130_fd_sc_hd__decap_4
XFILLER_80_41 VGND VGND VPWR VPWR sky130_fd_sc_hd__decap_8
X_10606_ clknet_leaf_81_clk _00736_ VGND VGND VPWR VPWR count_cycle\[29\] sky130_fd_sc_hd__dfxtp_1
XFILLER_80_85 VGND VGND VPWR VPWR sky130_fd_sc_hd__decap_6
XFILLER_128_657 VGND VGND VPWR VPWR sky130_fd_sc_hd__decap_4
X_10537_ clknet_leaf_63_clk _00667_ VGND VGND VPWR VPWR reg_pc\[23\] sky130_fd_sc_hd__dfxtp_1
XFILLER_116_808 VGND VGND VPWR VPWR sky130_fd_sc_hd__decap_4
XFILLER_127_178 VGND VGND VPWR VPWR sky130_fd_sc_hd__decap_8
XFILLER_127_167 VGND VGND VPWR VPWR sky130_fd_sc_hd__fill_1
XFILLER_115_318 VGND VGND VPWR VPWR sky130_fd_sc_hd__decap_8
XTAP_TAPCELL_ROW_114_2155 VGND VPWR sky130_fd_sc_hd__tapvpwrvgnd_1
X_10468_ clknet_leaf_84_clk _00598_ VGND VGND VPWR VPWR count_instr\[17\] sky130_fd_sc_hd__dfxtp_1
XFILLER_6_486 VGND VGND VPWR VPWR sky130_fd_sc_hd__decap_4
XFILLER_151_682 VPWR VGND VPWR VGND sky130_ef_sc_hd__decap_12
X_10399_ clknet_leaf_10_clk _00529_ VGND VGND VPWR VPWR cpuregs\[20\]\[13\] sky130_fd_sc_hd__dfxtp_1
XFILLER_69_405 VPWR VGND VPWR VGND sky130_ef_sc_hd__decap_12
XFILLER_96_213 VGND VGND VPWR VPWR sky130_fd_sc_hd__fill_1
XFILLER_85_909 VGND VGND VPWR VPWR sky130_fd_sc_hd__decap_3
XFILLER_2_681 VPWR VGND VPWR VGND sky130_ef_sc_hd__decap_12
X_04960_ instr_srli instr_lhu instr_sb instr_lw VGND VGND VPWR VPWR _01590_ sky130_fd_sc_hd__or4_1
Xclkbuf_leaf_1_clk clknet_4_0_0_clk VGND VGND VPWR VPWR clknet_leaf_1_clk sky130_fd_sc_hd__clkbuf_8
XFILLER_38_825 VGND VGND VPWR VPWR sky130_fd_sc_hd__decap_4
X_06630_ decoded_imm\[12\] net174 VGND VGND VPWR VPWR _03056_ sky130_fd_sc_hd__or2_1
XFILLER_64_132 VGND VGND VPWR VPWR sky130_fd_sc_hd__decap_8
XFILLER_38_858 VGND VGND VPWR VPWR sky130_fd_sc_hd__decap_8
XFILLER_38_869 VPWR VGND VPWR VGND sky130_ef_sc_hd__decap_12
XFILLER_92_485 VGND VGND VPWR VPWR sky130_fd_sc_hd__fill_1
XFILLER_52_305 VGND VGND VPWR VPWR sky130_fd_sc_hd__decap_3
X_06561_ _01579_ _02989_ VGND VGND VPWR VPWR _02990_ sky130_fd_sc_hd__or2_1
X_05512_ net184 net216 VGND VGND VPWR VPWR _02095_ sky130_fd_sc_hd__and2_1
X_08300_ count_cycle\[16\] _04083_ VGND VGND VPWR VPWR _04085_ sky130_fd_sc_hd__and2_1
X_09280_ net136 net98 _04206_ VGND VGND VPWR VPWR _00966_ sky130_fd_sc_hd__mux2_1
X_06492_ net236 _02907_ _02922_ _02923_ VGND VGND VPWR VPWR _00075_ sky130_fd_sc_hd__a31o_1
X_08231_ _04033_ _04034_ VGND VGND VPWR VPWR _04035_ sky130_fd_sc_hd__nor2_1
X_05443_ reg_pc\[30\] decoded_imm\[30\] VGND VGND VPWR VPWR _02028_ sky130_fd_sc_hd__or2_1
XFILLER_146_421 VPWR VGND VPWR VGND sky130_ef_sc_hd__decap_12
X_08162_ _01547_ reg_next_pc\[23\] _01645_ _03710_ VGND VGND VPWR VPWR _03972_ sky130_fd_sc_hd__a22o_1
X_05374_ instr_rdcycleh count_cycle\[56\] _01587_ _01964_ VGND VGND VPWR VPWR _01965_
+ sky130_fd_sc_hd__a211o_1
XFILLER_119_668 VGND VGND VPWR VPWR sky130_fd_sc_hd__fill_1
X_07113_ _00015_ _03518_ _03521_ _02735_ VGND VGND VPWR VPWR _03522_ sky130_fd_sc_hd__o211a_1
X_08093_ decoded_imm_j\[18\] _03705_ VGND VGND VPWR VPWR _03908_ sky130_fd_sc_hd__or2_1
Xclkload61 clknet_leaf_39_clk VGND VGND VPWR VPWR clkload61/Y sky130_fd_sc_hd__inv_6
X_07044_ _01568_ _02721_ VGND VGND VPWR VPWR _03455_ sky130_fd_sc_hd__nand2_1
Xclkload50 clknet_leaf_26_clk VGND VGND VPWR VPWR clkload50/Y sky130_fd_sc_hd__clkinv_4
Xclkload72 clknet_leaf_44_clk VGND VGND VPWR VPWR clkload72/Y sky130_fd_sc_hd__inv_8
XFILLER_115_841 VGND VGND VPWR VPWR sky130_fd_sc_hd__decap_8
Xclkload94 clknet_leaf_131_clk VGND VGND VPWR VPWR clkload94/Y sky130_fd_sc_hd__bufinv_16
XTAP_TAPCELL_ROW_54_1202 VGND VPWR sky130_fd_sc_hd__tapvpwrvgnd_1
Xclkload83 clknet_leaf_122_clk VGND VGND VPWR VPWR clkload83/Y sky130_fd_sc_hd__inv_6
XFILLER_130_800 VPWR VGND VPWR VGND sky130_ef_sc_hd__decap_12
XFILLER_125_15 VPWR VGND VPWR VGND sky130_ef_sc_hd__decap_12
X_08995_ cpuregs\[4\]\[28\] cpuregs\[5\]\[28\] cpuregs\[6\]\[28\] cpuregs\[7\]\[28\]
+ net280 net274 VGND VGND VPWR VPWR _04669_ sky130_fd_sc_hd__mux4_1
XFILLER_114_373 VPWR VGND VPWR VGND sky130_ef_sc_hd__decap_12
XFILLER_102_579 VGND VGND VPWR VPWR sky130_fd_sc_hd__decap_8
XFILLER_87_279 VGND VGND VPWR VPWR sky130_fd_sc_hd__fill_1
X_07946_ _01547_ reg_next_pc\[6\] _01645_ _03693_ VGND VGND VPWR VPWR _03773_ sky130_fd_sc_hd__a22o_1
XTAP_TAPCELL_ROW_145_2649 VGND VPWR sky130_fd_sc_hd__tapvpwrvgnd_1
XFILLER_96_780 VGND VGND VPWR VPWR sky130_fd_sc_hd__decap_3
XFILLER_28_313 VGND VGND VPWR VPWR sky130_fd_sc_hd__fill_1
X_07877_ _02692_ reg_next_pc\[27\] net596 VGND VGND VPWR VPWR _03714_ sky130_fd_sc_hd__mux2_2
XFILLER_95_290 VGND VGND VPWR VPWR sky130_fd_sc_hd__decap_4
X_09616_ _02675_ cpuregs\[3\]\[22\] _04868_ VGND VGND VPWR VPWR _01276_ sky130_fd_sc_hd__mux2_1
XFILLER_141_69 VPWR VGND VPWR VGND sky130_ef_sc_hd__decap_12
X_06828_ _01622_ _03242_ _03246_ _02714_ VGND VGND VPWR VPWR _03247_ sky130_fd_sc_hd__a211o_1
XFILLER_56_699 VGND VGND VPWR VPWR sky130_fd_sc_hd__fill_1
X_09547_ cpuregs\[23\]\[19\] _02662_ _04866_ VGND VGND VPWR VPWR _01209_ sky130_fd_sc_hd__mux2_1
X_06759_ net258 _03179_ _01581_ VGND VGND VPWR VPWR _03181_ sky130_fd_sc_hd__o21a_1
XFILLER_71_647 VGND VGND VPWR VPWR sky130_fd_sc_hd__fill_2
XTAP_TAPCELL_ROW_65_1364 VGND VPWR sky130_fd_sc_hd__tapvpwrvgnd_1
X_09478_ cpuregs\[24\]\[16\] _02649_ net241 VGND VGND VPWR VPWR _01142_ sky130_fd_sc_hd__mux2_1
XTAP_TAPCELL_ROW_65_1375 VGND VPWR sky130_fd_sc_hd__tapvpwrvgnd_1
XFILLER_11_202 VGND VGND VPWR VPWR sky130_fd_sc_hd__decap_8
XFILLER_138_911 VGND VGND VPWR VPWR sky130_fd_sc_hd__fill_1
X_08429_ count_cycle\[62\] _04165_ net34 VGND VGND VPWR VPWR _04168_ sky130_fd_sc_hd__o21ai_1
XFILLER_11_257 VGND VGND VPWR VPWR sky130_fd_sc_hd__decap_4
XFILLER_12_769 VPWR VGND VPWR VGND sky130_ef_sc_hd__decap_12
XFILLER_126_3 VPWR VGND VPWR VGND sky130_ef_sc_hd__decap_12
XFILLER_11_279 VGND VGND VPWR VPWR sky130_fd_sc_hd__fill_1
XFILLER_7_217 VGND VGND VPWR VPWR sky130_fd_sc_hd__decap_6
Xclkload0 clknet_4_0_0_clk VGND VGND VPWR VPWR clkload0/Y sky130_fd_sc_hd__inv_6
X_11440_ clknet_leaf_3_clk _01484_ VGND VGND VPWR VPWR cpuregs\[0\]\[6\] sky130_fd_sc_hd__dfxtp_1
XFILLER_137_443 VGND VGND VPWR VPWR sky130_fd_sc_hd__decap_4
X_11371_ clknet_leaf_116_clk _01415_ VGND VGND VPWR VPWR cpuregs\[7\]\[1\] sky130_fd_sc_hd__dfxtp_1
XFILLER_152_413 VGND VGND VPWR VPWR sky130_fd_sc_hd__decap_6
XFILLER_50_77 VGND VGND VPWR VPWR sky130_fd_sc_hd__decap_6
X_10322_ clknet_leaf_127_clk _00452_ VGND VGND VPWR VPWR cpuregs\[16\]\[0\] sky130_fd_sc_hd__dfxtp_1
XFILLER_133_671 VGND VGND VPWR VPWR sky130_fd_sc_hd__fill_1
X_10253_ clknet_leaf_34_clk _00383_ VGND VGND VPWR VPWR cpuregs\[27\]\[27\] sky130_fd_sc_hd__dfxtp_1
X_10184_ clknet_leaf_44_clk _00314_ VGND VGND VPWR VPWR cpuregs\[9\]\[22\] sky130_fd_sc_hd__dfxtp_1
XFILLER_121_833 VGND VGND VPWR VPWR sky130_fd_sc_hd__decap_6
XFILLER_121_877 VPWR VGND VPWR VGND sky130_ef_sc_hd__decap_12
XFILLER_120_365 VPWR VGND VPWR VGND sky130_ef_sc_hd__decap_12
XFILLER_66_419 VGND VGND VPWR VPWR sky130_fd_sc_hd__fill_1
XFILLER_115_70 VGND VGND VPWR VPWR sky130_fd_sc_hd__fill_1
XFILLER_87_791 VGND VGND VPWR VPWR sky130_fd_sc_hd__decap_6
XFILLER_59_493 VGND VGND VPWR VPWR sky130_fd_sc_hd__decap_3
XFILLER_47_644 VPWR VGND VPWR VGND sky130_ef_sc_hd__decap_12
XFILLER_35_839 VGND VGND VPWR VPWR sky130_fd_sc_hd__fill_1
XFILLER_62_636 VGND VGND VPWR VPWR sky130_fd_sc_hd__fill_1
XFILLER_61_113 VGND VGND VPWR VPWR sky130_fd_sc_hd__decap_4
XFILLER_91_51 VGND VGND VPWR VPWR sky130_fd_sc_hd__decap_4
XFILLER_98_7 VGND VGND VPWR VPWR sky130_fd_sc_hd__fill_2
XFILLER_30_533 VGND VGND VPWR VPWR sky130_fd_sc_hd__decap_8
XFILLER_128_421 VGND VGND VPWR VPWR sky130_fd_sc_hd__fill_1
XFILLER_128_454 VGND VGND VPWR VPWR sky130_fd_sc_hd__fill_1
XTAP_TAPCELL_ROW_96_1869 VGND VPWR sky130_fd_sc_hd__tapvpwrvgnd_1
X_05090_ cpu_state\[6\] _01692_ _01701_ _01702_ VGND VGND VPWR VPWR _04900_ sky130_fd_sc_hd__a211o_1
XFILLER_69_235 VGND VGND VPWR VPWR sky130_fd_sc_hd__decap_6
XFILLER_112_888 VPWR VGND VPWR VGND sky130_ef_sc_hd__decap_12
X_07800_ count_instr\[54\] _03669_ count_instr\[55\] VGND VGND VPWR VPWR _03672_ sky130_fd_sc_hd__a21o_1
X_08780_ cpuregs\[0\]\[16\] cpuregs\[1\]\[16\] cpuregs\[2\]\[16\] cpuregs\[3\]\[16\]
+ net276 net272 VGND VGND VPWR VPWR _04466_ sky130_fd_sc_hd__mux4_1
XPHY_EDGE_ROW_127_Right_127 VGND VGND VPWR VPWR sky130_fd_sc_hd__decap_3
X_07731_ _03624_ count_instr\[28\] count_instr\[27\] count_instr\[29\] VGND VGND VPWR
+ VPWR _03629_ sky130_fd_sc_hd__and4_1
X_05992_ net180 _02499_ _01582_ VGND VGND VPWR VPWR net74 sky130_fd_sc_hd__mux2_1
XFILLER_97_588 VGND VGND VPWR VPWR sky130_fd_sc_hd__decap_4
XTAP_TAPCELL_ROW_127_2368 VGND VPWR sky130_fd_sc_hd__tapvpwrvgnd_1
XTAP_TAPCELL_ROW_127_2357 VGND VPWR sky130_fd_sc_hd__tapvpwrvgnd_1
X_04943_ net212 VGND VGND VPWR VPWR _01576_ sky130_fd_sc_hd__inv_2
XFILLER_93_783 VGND VGND VPWR VPWR sky130_fd_sc_hd__fill_1
XFILLER_53_614 VGND VGND VPWR VPWR sky130_fd_sc_hd__fill_2
X_07662_ _03579_ count_instr\[3\] count_instr\[2\] count_instr\[4\] VGND VGND VPWR
+ VPWR _03585_ sky130_fd_sc_hd__and4_1
XFILLER_38_699 VGND VGND VPWR VPWR sky130_fd_sc_hd__fill_1
XFILLER_93_794 VGND VGND VPWR VPWR sky130_fd_sc_hd__fill_1
X_06613_ _01622_ _03037_ _03038_ _03039_ _02714_ VGND VGND VPWR VPWR _03040_ sky130_fd_sc_hd__a2111o_1
X_07593_ cpuregs\[20\]\[10\] _02624_ net245 VGND VGND VPWR VPWR _00526_ sky130_fd_sc_hd__mux2_1
XFILLER_1_93 VPWR VGND VPWR VGND sky130_ef_sc_hd__decap_12
X_09401_ _02603_ cpuregs\[18\]\[5\] _04862_ VGND VGND VPWR VPWR _01035_ sky130_fd_sc_hd__mux2_1
XTAP_TAPCELL_ROW_140_2579 VGND VPWR sky130_fd_sc_hd__tapvpwrvgnd_1
XTAP_TAPCELL_ROW_140_2568 VGND VPWR sky130_fd_sc_hd__tapvpwrvgnd_1
X_09332_ mem_rdata_q\[29\] _01589_ VGND VGND VPWR VPWR _04828_ sky130_fd_sc_hd__and2_1
XFILLER_53_669 VGND VGND VPWR VPWR sky130_fd_sc_hd__decap_3
XFILLER_34_861 VGND VGND VPWR VPWR sky130_fd_sc_hd__decap_6
X_06544_ _02970_ _02971_ _01579_ VGND VGND VPWR VPWR _02974_ sky130_fd_sc_hd__mux2_1
XTAP_TAPCELL_ROW_47_1083 VGND VPWR sky130_fd_sc_hd__tapvpwrvgnd_1
XTAP_TAPCELL_ROW_16_580 VGND VPWR sky130_fd_sc_hd__tapvpwrvgnd_1
XTAP_TAPCELL_ROW_16_591 VGND VPWR sky130_fd_sc_hd__tapvpwrvgnd_1
X_06475_ _02901_ _02902_ _02906_ VGND VGND VPWR VPWR _02907_ sky130_fd_sc_hd__a21o_1
X_09263_ net34 _04805_ VGND VGND VPWR VPWR _04806_ sky130_fd_sc_hd__and2_1
XFILLER_138_218 VPWR VGND VPWR VGND sky130_ef_sc_hd__decap_12
X_08214_ decoded_imm_j\[20\] _03716_ VGND VGND VPWR VPWR _04019_ sky130_fd_sc_hd__xnor2_1
X_05426_ count_cycle\[28\] _01588_ _01674_ _02012_ VGND VGND VPWR VPWR _02013_ sky130_fd_sc_hd__o211a_1
X_09194_ decoded_imm_j\[20\] _01125_ _02513_ VGND VGND VPWR VPWR _00897_ sky130_fd_sc_hd__mux2_1
X_08145_ _03938_ _03948_ _03954_ VGND VGND VPWR VPWR _03956_ sky130_fd_sc_hd__a21oi_1
XFILLER_107_605 VGND VGND VPWR VPWR sky130_fd_sc_hd__decap_8
X_05357_ count_instr\[23\] instr_rdinstr count_cycle\[55\] instr_rdcycleh VGND VGND
+ VPWR VPWR _01949_ sky130_fd_sc_hd__a22o_1
XTAP_TAPCELL_ROW_60_1294 VGND VPWR sky130_fd_sc_hd__tapvpwrvgnd_1
XFILLER_147_785 VPWR VGND VPWR VGND sky130_ef_sc_hd__decap_12
XFILLER_119_476 VGND VGND VPWR VPWR sky130_fd_sc_hd__fill_1
XFILLER_106_115 VPWR VGND VPWR VGND sky130_ef_sc_hd__decap_12
XFILLER_4_209 VPWR VGND VPWR VGND sky130_ef_sc_hd__decap_12
XFILLER_146_284 VGND VGND VPWR VPWR sky130_fd_sc_hd__fill_1
X_05288_ cpu_state\[6\] _01860_ _01880_ _01885_ VGND VGND VPWR VPWR _04886_ sky130_fd_sc_hd__a31o_1
X_08076_ _03848_ _03891_ VGND VGND VPWR VPWR _03892_ sky130_fd_sc_hd__nand2_1
X_07027_ cpuregs\[4\]\[26\] cpuregs\[5\]\[26\] cpuregs\[6\]\[26\] cpuregs\[7\]\[26\]
+ net266 net261 VGND VGND VPWR VPWR _03439_ sky130_fd_sc_hd__mux4_1
XFILLER_122_619 VPWR VGND VPWR VGND sky130_ef_sc_hd__decap_12
XFILLER_1_905 VGND VGND VPWR VPWR sky130_fd_sc_hd__decap_3
X_08978_ cpuregs\[12\]\[27\] cpuregs\[13\]\[27\] cpuregs\[14\]\[27\] cpuregs\[15\]\[27\]
+ net275 net271 VGND VGND VPWR VPWR _04653_ sky130_fd_sc_hd__mux4_1
XFILLER_29_611 VGND VGND VPWR VPWR sky130_fd_sc_hd__decap_4
XFILLER_102_398 VGND VGND VPWR VPWR sky130_fd_sc_hd__decap_3
XFILLER_84_750 VGND VGND VPWR VPWR sky130_fd_sc_hd__decap_6
X_07929_ _03691_ _03738_ _03692_ VGND VGND VPWR VPWR _03757_ sky130_fd_sc_hd__a21oi_1
X_10940_ clknet_leaf_94_clk _01002_ VGND VGND VPWR VPWR decoded_imm\[28\] sky130_fd_sc_hd__dfxtp_2
XTAP_TAPCELL_ROW_67_1404 VGND VPWR sky130_fd_sc_hd__tapvpwrvgnd_1
XFILLER_56_463 VGND VGND VPWR VPWR sky130_fd_sc_hd__decap_3
XFILLER_17_839 VGND VGND VPWR VPWR sky130_fd_sc_hd__fill_1
XFILLER_29_677 VGND VGND VPWR VPWR sky130_fd_sc_hd__fill_1
XFILLER_43_102 VGND VGND VPWR VPWR sky130_fd_sc_hd__decap_3
XFILLER_43_113 VGND VGND VPWR VPWR sky130_fd_sc_hd__fill_1
XFILLER_44_636 VGND VGND VPWR VPWR sky130_fd_sc_hd__decap_8
XFILLER_45_55 VGND VGND VPWR VPWR sky130_fd_sc_hd__fill_1
X_10871_ clknet_leaf_25_clk _00933_ VGND VGND VPWR VPWR cpuregs\[1\]\[15\] sky130_fd_sc_hd__dfxtp_1
XFILLER_43_157 VGND VGND VPWR VPWR sky130_fd_sc_hd__fill_2
XTAP_TAPCELL_ROW_80_1615 VGND VPWR sky130_fd_sc_hd__tapvpwrvgnd_1
XTAP_TAPCELL_ROW_80_1604 VGND VPWR sky130_fd_sc_hd__tapvpwrvgnd_1
XFILLER_61_43 VPWR VGND VPWR VGND sky130_ef_sc_hd__decap_12
XFILLER_129_218 VGND VGND VPWR VPWR sky130_fd_sc_hd__decap_6
XFILLER_12_566 VGND VGND VPWR VPWR sky130_fd_sc_hd__decap_3
XFILLER_138_741 VGND VGND VPWR VPWR sky130_fd_sc_hd__fill_1
X_11423_ clknet_leaf_80_clk _01467_ VGND VGND VPWR VPWR cpuregs\[8\]\[21\] sky130_fd_sc_hd__dfxtp_1
XFILLER_137_262 VPWR VGND VPWR VGND sky130_ef_sc_hd__decap_12
XANTENNA_9 _03472_ VGND VGND VPWR VPWR sky130_fd_sc_hd__diode_2
XFILLER_6_27 VGND VGND VPWR VPWR sky130_fd_sc_hd__fill_1
XFILLER_152_221 VPWR VGND VPWR VGND sky130_ef_sc_hd__decap_12
XTAP_TAPCELL_ROW_111_2114 VGND VPWR sky130_fd_sc_hd__tapvpwrvgnd_1
XTAP_TAPCELL_ROW_111_2103 VGND VPWR sky130_fd_sc_hd__tapvpwrvgnd_1
X_11354_ clknet_leaf_22_clk _01398_ VGND VGND VPWR VPWR cpuregs\[6\]\[16\] sky130_fd_sc_hd__dfxtp_1
XTAP_TAPCELL_ROW_78_1577 VGND VPWR sky130_fd_sc_hd__tapvpwrvgnd_1
XFILLER_152_265 VPWR VGND VPWR VGND sky130_ef_sc_hd__decap_12
X_11285_ clknet_leaf_27_clk _01332_ VGND VGND VPWR VPWR cpuregs\[4\]\[14\] sky130_fd_sc_hd__dfxtp_1
X_10305_ clknet_leaf_15_clk _00435_ VGND VGND VPWR VPWR cpuregs\[26\]\[15\] sky130_fd_sc_hd__dfxtp_1
X_10236_ clknet_leaf_11_clk _00366_ VGND VGND VPWR VPWR cpuregs\[27\]\[10\] sky130_fd_sc_hd__dfxtp_1
XTAP_TAPCELL_ROW_91_1788 VGND VPWR sky130_fd_sc_hd__tapvpwrvgnd_1
XFILLER_121_685 VGND VGND VPWR VPWR sky130_fd_sc_hd__fill_1
XFILLER_94_514 VGND VGND VPWR VPWR sky130_fd_sc_hd__fill_2
X_10167_ clknet_leaf_137_clk _00297_ VGND VGND VPWR VPWR cpuregs\[9\]\[5\] sky130_fd_sc_hd__dfxtp_1
XFILLER_120_195 VGND VGND VPWR VPWR sky130_fd_sc_hd__fill_1
XFILLER_94_569 VPWR VGND VPWR VGND sky130_ef_sc_hd__decap_12
X_10098_ clknet_leaf_116_clk _00228_ VGND VGND VPWR VPWR cpuregs\[28\]\[0\] sky130_fd_sc_hd__dfxtp_1
XTAP_TAPCELL_ROW_109_2076 VGND VPWR sky130_fd_sc_hd__tapvpwrvgnd_1
XFILLER_19_165 VGND VGND VPWR VPWR sky130_fd_sc_hd__decap_3
XTAP_TAPCELL_ROW_122_2276 VGND VPWR sky130_fd_sc_hd__tapvpwrvgnd_1
XFILLER_90_753 VGND VGND VPWR VPWR sky130_fd_sc_hd__decap_3
XFILLER_50_606 VGND VGND VPWR VPWR sky130_fd_sc_hd__decap_4
XFILLER_16_861 VGND VGND VPWR VPWR sky130_fd_sc_hd__decap_6
XFILLER_23_809 VPWR VGND VPWR VGND sky130_ef_sc_hd__decap_12
XTAP_TAPCELL_ROW_122_2287 VGND VPWR sky130_fd_sc_hd__tapvpwrvgnd_1
XFILLER_62_477 VPWR VGND VPWR VGND sky130_ef_sc_hd__decap_12
XFILLER_15_393 VGND VGND VPWR VPWR sky130_fd_sc_hd__fill_2
XFILLER_31_853 VPWR VGND VPWR VGND sky130_ef_sc_hd__decap_12
XTAP_TAPCELL_ROW_33_859 VGND VPWR sky130_fd_sc_hd__tapvpwrvgnd_1
X_06260_ reg_pc\[28\] _02694_ reg_pc\[29\] VGND VGND VPWR VPWR _02701_ sky130_fd_sc_hd__a21oi_1
XFILLER_30_352 VPWR VGND VPWR VGND sky130_ef_sc_hd__decap_12
XFILLER_31_897 VGND VGND VPWR VPWR sky130_fd_sc_hd__decap_6
XFILLER_129_741 VPWR VGND VPWR VGND sky130_ef_sc_hd__decap_12
X_05211_ reg_pc\[10\] decoded_imm\[10\] _01799_ VGND VGND VPWR VPWR _01814_ sky130_fd_sc_hd__and3_1
XFILLER_129_785 VPWR VGND VPWR VGND sky130_ef_sc_hd__decap_12
XFILLER_116_413 VGND VGND VPWR VPWR sky130_fd_sc_hd__decap_6
X_06191_ _02642_ _02645_ _02584_ VGND VGND VPWR VPWR _02646_ sky130_fd_sc_hd__mux2_8
XFILLER_144_733 VPWR VGND VPWR VGND sky130_ef_sc_hd__decap_12
X_05142_ instr_rdcycleh count_cycle\[38\] net257 _01750_ VGND VGND VPWR VPWR _01751_
+ sky130_fd_sc_hd__a211o_1
Xmax_cap267 _00012_ VGND VGND VPWR VPWR net267 sky130_fd_sc_hd__buf_12
Xmax_cap256 _01674_ VGND VGND VPWR VPWR net256 sky130_fd_sc_hd__clkbuf_8
X_09950_ clknet_leaf_132_clk _00080_ VGND VGND VPWR VPWR net173 sky130_fd_sc_hd__dfxtp_4
Xmax_cap278 net279 VGND VGND VPWR VPWR net278 sky130_fd_sc_hd__buf_12
Xmax_cap245 _03573_ VGND VGND VPWR VPWR net245 sky130_fd_sc_hd__buf_12
X_05073_ reg_pc\[1\] decoded_imm\[1\] VGND VGND VPWR VPWR _01687_ sky130_fd_sc_hd__nand2_1
XFILLER_143_298 VPWR VGND VPWR VGND sky130_ef_sc_hd__decap_12
XFILLER_131_438 VGND VGND VPWR VPWR sky130_fd_sc_hd__fill_1
X_08901_ cpuregs\[4\]\[23\] cpuregs\[5\]\[23\] cpuregs\[6\]\[23\] cpuregs\[7\]\[23\]
+ net277 net272 VGND VGND VPWR VPWR _04580_ sky130_fd_sc_hd__mux4_1
XFILLER_100_803 VGND VGND VPWR VPWR sky130_fd_sc_hd__decap_3
X_09881_ cpuregs\[0\]\[11\] VGND VGND VPWR VPWR _01489_ sky130_fd_sc_hd__clkbuf_1
X_08832_ cpuregs\[20\]\[19\] cpuregs\[21\]\[19\] cpuregs\[22\]\[19\] cpuregs\[23\]\[19\]
+ net280 net274 VGND VGND VPWR VPWR _04515_ sky130_fd_sc_hd__mux4_1
XFILLER_100_825 VGND VGND VPWR VPWR sky130_fd_sc_hd__fill_1
XFILLER_57_216 VGND VGND VPWR VPWR sky130_fd_sc_hd__decap_8
XPHY_EDGE_ROW_29_Left_183 VGND VGND VPWR VPWR sky130_fd_sc_hd__decap_3
XTAP_TAPCELL_ROW_142_2608 VGND VPWR sky130_fd_sc_hd__tapvpwrvgnd_1
X_08763_ _01558_ _04442_ net269 VGND VGND VPWR VPWR _04450_ sky130_fd_sc_hd__o21a_1
X_05975_ reg_out\[10\] reg_next_pc\[10\] net597 VGND VGND VPWR VPWR _02491_ sky130_fd_sc_hd__mux2_1
XFILLER_122_27 VGND VGND VPWR VPWR sky130_fd_sc_hd__fill_1
X_07714_ _03610_ count_instr\[22\] count_instr\[23\] _03614_ VGND VGND VPWR VPWR _03618_
+ sky130_fd_sc_hd__and4_1
X_04926_ _00010_ VGND VGND VPWR VPWR _01559_ sky130_fd_sc_hd__inv_16
XFILLER_66_772 VPWR VGND VPWR VGND sky130_ef_sc_hd__decap_12
XFILLER_54_901 VGND VGND VPWR VPWR sky130_fd_sc_hd__decap_8
XTAP_TAPCELL_ROW_49_1123 VGND VPWR sky130_fd_sc_hd__tapvpwrvgnd_1
XTAP_TAPCELL_ROW_49_1112 VGND VPWR sky130_fd_sc_hd__tapvpwrvgnd_1
X_08694_ decoded_imm\[11\] _01654_ _01586_ VGND VGND VPWR VPWR _04385_ sky130_fd_sc_hd__a21o_1
X_07645_ _02704_ cpuregs\[17\]\[29\] _03574_ VGND VGND VPWR VPWR _00577_ sky130_fd_sc_hd__mux2_1
X_07576_ cpuregs\[25\]\[27\] _02696_ _03571_ VGND VGND VPWR VPWR _00511_ sky130_fd_sc_hd__mux2_1
XFILLER_41_617 VGND VGND VPWR VPWR sky130_fd_sc_hd__fill_1
XTAP_TAPCELL_ROW_62_1323 VGND VPWR sky130_fd_sc_hd__tapvpwrvgnd_1
X_06527_ _02952_ _02955_ _01622_ VGND VGND VPWR VPWR _02957_ sky130_fd_sc_hd__o21a_1
XFILLER_15_69 VPWR VGND VPWR VGND sky130_ef_sc_hd__decap_12
XFILLER_33_190 VGND VGND VPWR VPWR sky130_fd_sc_hd__decap_8
X_09315_ latched_rd\[3\] _04815_ _04816_ decoded_rd\[3\] VGND VGND VPWR VPWR _00995_
+ sky130_fd_sc_hd__a22o_1
X_09246_ cpuregs\[1\]\[25\] _02688_ net244 VGND VGND VPWR VPWR _00943_ sky130_fd_sc_hd__mux2_1
XTAP_TAPCELL_ROW_11_509 VGND VPWR sky130_fd_sc_hd__tapvpwrvgnd_1
X_06458_ _02885_ _02886_ _02887_ _02888_ _01579_ _01580_ VGND VGND VPWR VPWR _02891_
+ sky130_fd_sc_hd__mux4_1
XPHY_EDGE_ROW_38_Left_192 VGND VGND VPWR VPWR sky130_fd_sc_hd__decap_3
X_05409_ count_instr\[27\] instr_rdinstr count_cycle\[59\] instr_rdcycleh VGND VGND
+ VPWR VPWR _01997_ sky130_fd_sc_hd__a22o_1
X_09177_ _04785_ _04787_ instr_rdinstrh _04747_ VGND VGND VPWR VPWR _00885_ sky130_fd_sc_hd__a2bb2o_1
XFILLER_5_529 VPWR VGND VPWR VGND sky130_ef_sc_hd__decap_12
X_06389_ _01578_ _02823_ VGND VGND VPWR VPWR _02824_ sky130_fd_sc_hd__or2_1
XFILLER_31_57 VGND VGND VPWR VPWR sky130_fd_sc_hd__decap_3
XFILLER_147_57 VPWR VGND VPWR VGND sky130_ef_sc_hd__decap_12
X_08128_ _03938_ _03939_ VGND VGND VPWR VPWR _03940_ sky130_fd_sc_hd__and2_1
XFILLER_107_479 VGND VGND VPWR VPWR sky130_fd_sc_hd__decap_3
X_08059_ _03873_ _03876_ _03576_ VGND VGND VPWR VPWR _03877_ sky130_fd_sc_hd__a21oi_1
Xpicorv32_290 VGND VGND VPWR VPWR picorv32_290/HI eoi[9] sky130_fd_sc_hd__conb_1
Xoutput57 net57 VGND VGND VPWR VPWR mem_addr[31] sky130_fd_sc_hd__buf_2
Xoutput46 net46 VGND VGND VPWR VPWR mem_addr[21] sky130_fd_sc_hd__buf_2
Xoutput35 net35 VGND VGND VPWR VPWR mem_addr[10] sky130_fd_sc_hd__buf_2
X_11070_ clknet_leaf_112_clk _01127_ VGND VGND VPWR VPWR cpuregs\[24\]\[1\] sky130_fd_sc_hd__dfxtp_1
Xoutput79 net79 VGND VGND VPWR VPWR mem_la_addr[23] sky130_fd_sc_hd__buf_2
XFILLER_150_769 VPWR VGND VPWR VGND sky130_ef_sc_hd__decap_12
X_10021_ clknet_leaf_64_clk _00151_ VGND VGND VPWR VPWR cpuregs\[30\]\[19\] sky130_fd_sc_hd__dfxtp_1
XFILLER_88_341 VGND VGND VPWR VPWR sky130_fd_sc_hd__fill_2
Xoutput68 net68 VGND VGND VPWR VPWR mem_la_addr[12] sky130_fd_sc_hd__buf_2
XFILLER_130_471 VGND VGND VPWR VPWR sky130_fd_sc_hd__decap_4
XFILLER_89_897 VGND VGND VPWR VPWR sky130_fd_sc_hd__decap_3
XFILLER_88_363 VGND VGND VPWR VPWR sky130_fd_sc_hd__fill_1
XTAP_TAPCELL_ROW_73_1496 VGND VPWR sky130_fd_sc_hd__tapvpwrvgnd_1
XFILLER_76_569 VGND VGND VPWR VPWR sky130_fd_sc_hd__decap_6
XFILLER_64_709 VGND VGND VPWR VPWR sky130_fd_sc_hd__decap_6
XFILLER_57_750 VGND VGND VPWR VPWR sky130_fd_sc_hd__fill_1
XFILLER_56_65 VPWR VGND VPWR VGND sky130_ef_sc_hd__decap_12
XFILLER_56_282 VPWR VGND VPWR VGND sky130_ef_sc_hd__decap_12
XFILLER_17_625 VGND VGND VPWR VPWR sky130_fd_sc_hd__decap_4
X_10923_ clknet_leaf_29_clk _00985_ VGND VGND VPWR VPWR net156 sky130_fd_sc_hd__dfxtp_1
XFILLER_71_241 VGND VGND VPWR VPWR sky130_fd_sc_hd__fill_1
XPHY_EDGE_ROW_19_Right_19 VGND VGND VPWR VPWR sky130_fd_sc_hd__decap_3
XFILLER_44_433 VGND VGND VPWR VPWR sky130_fd_sc_hd__decap_6
X_10854_ clknet_leaf_103_clk _00003_ VGND VGND VPWR VPWR is_sltiu_bltu_sltu sky130_fd_sc_hd__dfxtp_1
XFILLER_13_853 VPWR VGND VPWR VGND sky130_ef_sc_hd__decap_12
X_10785_ clknet_leaf_98_clk _00850_ VGND VGND VPWR VPWR instr_bge sky130_fd_sc_hd__dfxtp_1
XTAP_TAPCELL_ROW_30_807 VGND VPWR sky130_fd_sc_hd__tapvpwrvgnd_1
XTAP_TAPCELL_ROW_30_818 VGND VPWR sky130_fd_sc_hd__tapvpwrvgnd_1
XFILLER_13_897 VPWR VGND VPWR VGND sky130_ef_sc_hd__decap_12
XFILLER_153_530 VGND VGND VPWR VPWR sky130_fd_sc_hd__fill_2
XFILLER_138_582 VGND VGND VPWR VPWR sky130_fd_sc_hd__decap_6
XFILLER_126_755 VGND VGND VPWR VPWR sky130_fd_sc_hd__fill_1
XFILLER_126_722 VGND VGND VPWR VPWR sky130_fd_sc_hd__decap_3
XTAP_TAPCELL_ROW_93_1817 VGND VPWR sky130_fd_sc_hd__tapvpwrvgnd_1
X_11406_ clknet_leaf_138_clk _01450_ VGND VGND VPWR VPWR cpuregs\[8\]\[4\] sky130_fd_sc_hd__dfxtp_1
XFILLER_141_714 VGND VGND VPWR VPWR sky130_fd_sc_hd__fill_2
XFILLER_141_703 VGND VGND VPWR VPWR sky130_fd_sc_hd__fill_2
XFILLER_126_766 VPWR VGND VPWR VGND sky130_ef_sc_hd__decap_12
XFILLER_99_606 VGND VGND VPWR VPWR sky130_fd_sc_hd__fill_1
X_11337_ clknet_leaf_102_clk _00026_ VGND VGND VPWR VPWR mem_wordsize\[2\] sky130_fd_sc_hd__dfxtp_4
XPHY_EDGE_ROW_28_Right_28 VGND VGND VPWR VPWR sky130_fd_sc_hd__decap_3
XFILLER_141_725 VGND VGND VPWR VPWR sky130_fd_sc_hd__decap_3
XFILLER_140_224 VGND VGND VPWR VPWR sky130_fd_sc_hd__fill_1
XFILLER_125_276 VGND VGND VPWR VPWR sky130_fd_sc_hd__decap_4
XFILLER_140_246 VGND VGND VPWR VPWR sky130_fd_sc_hd__decap_6
XFILLER_113_449 VPWR VGND VPWR VGND sky130_ef_sc_hd__decap_12
X_11268_ clknet_leaf_32_clk _01315_ VGND VGND VPWR VPWR cpuregs\[22\]\[29\] sky130_fd_sc_hd__dfxtp_1
XFILLER_97_61 VGND VGND VPWR VPWR sky130_fd_sc_hd__fill_1
X_10219_ clknet_leaf_48_clk _00349_ VGND VGND VPWR VPWR cpuregs\[14\]\[25\] sky130_fd_sc_hd__dfxtp_1
X_11199_ clknet_leaf_67_clk _01246_ VGND VGND VPWR VPWR cpuregs\[29\]\[24\] sky130_fd_sc_hd__dfxtp_1
XFILLER_95_823 VGND VGND VPWR VPWR sky130_fd_sc_hd__fill_1
XFILLER_67_503 VGND VGND VPWR VPWR sky130_fd_sc_hd__fill_1
XFILLER_121_482 VGND VGND VPWR VPWR sky130_fd_sc_hd__decap_8
XFILLER_95_856 VGND VGND VPWR VPWR sky130_fd_sc_hd__decap_4
XFILLER_0_790 VGND VGND VPWR VPWR sky130_fd_sc_hd__decap_4
XFILLER_39_238 VGND VGND VPWR VPWR sky130_fd_sc_hd__fill_1
XTAP_TAPCELL_ROW_124_2316 VGND VPWR sky130_fd_sc_hd__tapvpwrvgnd_1
XFILLER_95_889 VGND VGND VPWR VPWR sky130_fd_sc_hd__decap_6
XFILLER_82_517 VGND VGND VPWR VPWR sky130_fd_sc_hd__fill_1
X_05760_ _02152_ _02328_ _02329_ VGND VGND VPWR VPWR _02330_ sky130_fd_sc_hd__a21oi_1
XFILLER_35_422 VGND VGND VPWR VPWR sky130_fd_sc_hd__decap_3
XPHY_EDGE_ROW_37_Right_37 VGND VGND VPWR VPWR sky130_fd_sc_hd__decap_3
XTAP_TAPCELL_ROW_18_620 VGND VPWR sky130_fd_sc_hd__tapvpwrvgnd_1
XFILLER_35_433 VGND VGND VPWR VPWR sky130_fd_sc_hd__fill_2
XFILLER_35_444 VGND VGND VPWR VPWR sky130_fd_sc_hd__decap_4
XFILLER_47_293 VGND VGND VPWR VPWR sky130_fd_sc_hd__decap_4
X_05691_ _02140_ _02263_ _02139_ VGND VGND VPWR VPWR _02269_ sky130_fd_sc_hd__o21bai_1
XFILLER_90_583 VGND VGND VPWR VPWR sky130_fd_sc_hd__decap_4
X_07430_ cpuregs\[27\]\[14\] _02641_ _03566_ VGND VGND VPWR VPWR _00370_ sky130_fd_sc_hd__mux2_1
XFILLER_63_797 VGND VGND VPWR VPWR sky130_fd_sc_hd__decap_6
XFILLER_35_499 VGND VGND VPWR VPWR sky130_fd_sc_hd__decap_4
XTAP_TAPCELL_ROW_102_1957 VGND VPWR sky130_fd_sc_hd__tapvpwrvgnd_1
XFILLER_62_285 VGND VGND VPWR VPWR sky130_fd_sc_hd__decap_3
X_07361_ _02633_ cpuregs\[9\]\[12\] _03563_ VGND VGND VPWR VPWR _00304_ sky130_fd_sc_hd__mux2_1
XTAP_TAPCELL_ROW_44_1031 VGND VPWR sky130_fd_sc_hd__tapvpwrvgnd_1
XTAP_TAPCELL_ROW_102_1968 VGND VPWR sky130_fd_sc_hd__tapvpwrvgnd_1
X_09100_ instr_bne _04748_ _04750_ _04752_ VGND VGND VPWR VPWR _00848_ sky130_fd_sc_hd__a22o_1
X_06312_ _02714_ _02733_ _02735_ _02743_ _02749_ VGND VGND VPWR VPWR _02750_ sky130_fd_sc_hd__a41o_1
XTAP_TAPCELL_ROW_44_1042 VGND VPWR sky130_fd_sc_hd__tapvpwrvgnd_1
X_09031_ net270 _04702_ VGND VGND VPWR VPWR _04703_ sky130_fd_sc_hd__or2_1
X_07292_ cpuregs\[28\]\[10\] _02624_ net249 VGND VGND VPWR VPWR _00238_ sky130_fd_sc_hd__mux2_1
X_06243_ _02684_ _02687_ _02584_ VGND VGND VPWR VPWR _02688_ sky130_fd_sc_hd__mux2_8
XPHY_EDGE_ROW_46_Right_46 VGND VGND VPWR VPWR sky130_fd_sc_hd__decap_3
XFILLER_30_193 VGND VGND VPWR VPWR sky130_fd_sc_hd__decap_3
XTAP_TAPCELL_ROW_152_2770 VGND VPWR sky130_fd_sc_hd__tapvpwrvgnd_1
XTAP_TAPCELL_ROW_135_2489 VGND VPWR sky130_fd_sc_hd__tapvpwrvgnd_1
XFILLER_117_733 VGND VGND VPWR VPWR sky130_fd_sc_hd__fill_1
X_06174_ reg_pc\[12\] _02627_ VGND VGND VPWR VPWR _02632_ sky130_fd_sc_hd__xor2_1
XFILLER_7_81 VPWR VGND VPWR VGND sky130_ef_sc_hd__decap_12
X_05125_ _01675_ _01734_ VGND VGND VPWR VPWR _01735_ sky130_fd_sc_hd__or2_1
XFILLER_144_585 VGND VGND VPWR VPWR sky130_fd_sc_hd__decap_3
XFILLER_131_202 VPWR VGND VPWR VGND sky130_ef_sc_hd__decap_12
XFILLER_116_298 VGND VGND VPWR VPWR sky130_fd_sc_hd__fill_1
X_05056_ mem_wordsize\[2\] mem_wordsize\[1\] VGND VGND VPWR VPWR _01672_ sky130_fd_sc_hd__nand2b_4
X_09933_ clknet_leaf_14_clk _00068_ VGND VGND VPWR VPWR cpuregs\[11\]\[31\] sky130_fd_sc_hd__dfxtp_1
X_09864_ decoded_imm_j\[17\] _01111_ _02513_ VGND VGND VPWR VPWR _00905_ sky130_fd_sc_hd__mux2_1
XFILLER_140_791 VPWR VGND VPWR VGND sky130_ef_sc_hd__decap_12
XFILLER_133_15 VPWR VGND VPWR VGND sky130_ef_sc_hd__decap_12
X_08815_ _01558_ _04498_ VGND VGND VPWR VPWR _04499_ sky130_fd_sc_hd__or2_1
XPHY_EDGE_ROW_55_Right_55 VGND VGND VPWR VPWR sky130_fd_sc_hd__decap_3
X_09795_ _02590_ cpuregs\[8\]\[2\] _04875_ VGND VGND VPWR VPWR _01448_ sky130_fd_sc_hd__mux2_1
X_08746_ _04427_ _04432_ _04433_ net269 _00010_ VGND VGND VPWR VPWR _04434_ sky130_fd_sc_hd__a221o_1
XFILLER_54_720 VPWR VGND VPWR VGND sky130_ef_sc_hd__decap_12
XFILLER_39_783 VGND VGND VPWR VPWR sky130_fd_sc_hd__fill_1
X_05958_ latched_store latched_branch VGND VGND VPWR VPWR _02482_ sky130_fd_sc_hd__nand2_8
X_05889_ net191 net223 _02238_ VGND VGND VPWR VPWR _02444_ sky130_fd_sc_hd__and3_1
XFILLER_54_764 VGND VGND VPWR VPWR sky130_fd_sc_hd__decap_8
X_08677_ _04367_ _04368_ _04266_ _04365_ VGND VGND VPWR VPWR _04369_ sky130_fd_sc_hd__o211a_1
X_07628_ _02633_ cpuregs\[17\]\[12\] _03574_ VGND VGND VPWR VPWR _00560_ sky130_fd_sc_hd__mux2_1
XFILLER_14_606 VGND VGND VPWR VPWR sky130_fd_sc_hd__fill_1
XFILLER_14_628 VGND VGND VPWR VPWR sky130_fd_sc_hd__decap_6
XFILLER_26_477 VPWR VGND VPWR VGND sky130_ef_sc_hd__decap_12
XFILLER_41_458 VPWR VGND VPWR VGND sky130_ef_sc_hd__decap_12
XPHY_EDGE_ROW_46_Left_200 VGND VGND VPWR VPWR sky130_fd_sc_hd__decap_3
X_07559_ cpuregs\[25\]\[10\] _02624_ _03571_ VGND VGND VPWR VPWR _00494_ sky130_fd_sc_hd__mux2_1
XFILLER_139_335 VGND VGND VPWR VPWR sky130_fd_sc_hd__fill_1
X_10570_ clknet_leaf_64_clk _00700_ VGND VGND VPWR VPWR reg_next_pc\[25\] sky130_fd_sc_hd__dfxtp_1
XPHY_EDGE_ROW_64_Right_64 VGND VGND VPWR VPWR sky130_fd_sc_hd__decap_3
XFILLER_10_867 VGND VGND VPWR VPWR sky130_fd_sc_hd__fill_1
XFILLER_6_805 VGND VGND VPWR VPWR sky130_fd_sc_hd__decap_6
X_09229_ cpuregs\[1\]\[8\] _02616_ net244 VGND VGND VPWR VPWR _00926_ sky130_fd_sc_hd__mux2_1
XFILLER_6_849 VPWR VGND VPWR VGND sky130_ef_sc_hd__decap_12
XFILLER_5_337 VPWR VGND VPWR VGND sky130_ef_sc_hd__decap_12
XFILLER_108_755 VGND VGND VPWR VPWR sky130_fd_sc_hd__fill_1
XTAP_TAPCELL_ROW_75_1536 VGND VPWR sky130_fd_sc_hd__tapvpwrvgnd_1
XTAP_TAPCELL_ROW_75_1525 VGND VPWR sky130_fd_sc_hd__tapvpwrvgnd_1
XFILLER_122_202 VGND VGND VPWR VPWR sky130_fd_sc_hd__fill_1
XFILLER_96_609 VGND VGND VPWR VPWR sky130_fd_sc_hd__decap_8
X_11122_ clknet_leaf_147_clk _01169_ VGND VGND VPWR VPWR cpuregs\[31\]\[11\] sky130_fd_sc_hd__dfxtp_1
XFILLER_95_108 VGND VGND VPWR VPWR sky130_fd_sc_hd__decap_4
X_11053_ clknet_leaf_87_clk _01110_ VGND VGND VPWR VPWR mem_rdata_q\[16\] sky130_fd_sc_hd__dfxtp_1
XFILLER_49_503 VGND VGND VPWR VPWR sky130_fd_sc_hd__fill_1
XFILLER_3_39 VPWR VGND VPWR VGND sky130_ef_sc_hd__decap_12
XFILLER_103_482 VGND VGND VPWR VPWR sky130_fd_sc_hd__fill_2
XPHY_EDGE_ROW_73_Right_73 VGND VGND VPWR VPWR sky130_fd_sc_hd__decap_3
X_10004_ clknet_leaf_120_clk _00134_ VGND VGND VPWR VPWR cpuregs\[30\]\[2\] sky130_fd_sc_hd__dfxtp_1
XTAP_TAPCELL_ROW_106_2035 VGND VPWR sky130_fd_sc_hd__tapvpwrvgnd_1
XTAP_TAPCELL_ROW_106_2024 VGND VPWR sky130_fd_sc_hd__tapvpwrvgnd_1
XFILLER_76_399 VGND VGND VPWR VPWR sky130_fd_sc_hd__fill_2
XFILLER_64_528 VGND VGND VPWR VPWR sky130_fd_sc_hd__fill_1
XTAP_TAPCELL_ROW_4_392 VGND VPWR sky130_fd_sc_hd__tapvpwrvgnd_1
XFILLER_123_81 VPWR VGND VPWR VGND sky130_ef_sc_hd__decap_12
XFILLER_91_369 VGND VGND VPWR VPWR sky130_fd_sc_hd__decap_4
XFILLER_83_63 VGND VGND VPWR VPWR sky130_fd_sc_hd__fill_1
X_10906_ clknet_leaf_7_clk _00968_ VGND VGND VPWR VPWR net138 sky130_fd_sc_hd__dfxtp_1
XFILLER_60_712 VGND VGND VPWR VPWR sky130_fd_sc_hd__fill_1
XFILLER_44_274 VGND VGND VPWR VPWR sky130_fd_sc_hd__decap_6
XPHY_EDGE_ROW_82_Right_82 VGND VGND VPWR VPWR sky130_fd_sc_hd__decap_3
X_10837_ clknet_leaf_111_clk _00902_ VGND VGND VPWR VPWR decoded_rd\[4\] sky130_fd_sc_hd__dfxtp_1
X_10768_ clknet_leaf_63_clk alu_out\[21\] VGND VGND VPWR VPWR alu_out_q\[21\] sky130_fd_sc_hd__dfxtp_1
XFILLER_80_7 VPWR VGND VPWR VGND sky130_ef_sc_hd__decap_12
X_10699_ clknet_leaf_68_clk _00797_ VGND VGND VPWR VPWR net52 sky130_fd_sc_hd__dfxtp_1
XFILLER_138_390 VGND VGND VPWR VPWR sky130_fd_sc_hd__decap_8
XTAP_TAPCELL_ROW_117_2197 VGND VPWR sky130_fd_sc_hd__tapvpwrvgnd_1
XFILLER_153_371 VGND VGND VPWR VPWR sky130_fd_sc_hd__decap_3
XFILLER_141_500 VGND VGND VPWR VPWR sky130_fd_sc_hd__decap_4
XFILLER_126_585 VGND VGND VPWR VPWR sky130_fd_sc_hd__decap_3
XFILLER_99_425 VGND VGND VPWR VPWR sky130_fd_sc_hd__decap_8
XFILLER_153_393 VGND VGND VPWR VPWR sky130_fd_sc_hd__fill_2
XFILLER_99_447 VGND VGND VPWR VPWR sky130_fd_sc_hd__fill_1
X_06930_ _01565_ net237 VGND VGND VPWR VPWR _03345_ sky130_fd_sc_hd__nor2_1
XPHY_EDGE_ROW_91_Right_91 VGND VGND VPWR VPWR sky130_fd_sc_hd__decap_3
XFILLER_68_867 VGND VGND VPWR VPWR sky130_fd_sc_hd__fill_1
X_06861_ _01622_ _03273_ _03274_ _03278_ VGND VGND VPWR VPWR _03279_ sky130_fd_sc_hd__a31o_1
XFILLER_67_366 VGND VGND VPWR VPWR sky130_fd_sc_hd__decap_6
XFILLER_67_355 VGND VGND VPWR VPWR sky130_fd_sc_hd__decap_4
XFILLER_55_517 VGND VGND VPWR VPWR sky130_fd_sc_hd__decap_4
X_08600_ net269 _04294_ _01559_ VGND VGND VPWR VPWR _04296_ sky130_fd_sc_hd__a21o_1
X_09580_ cpuregs\[29\]\[19\] _02662_ _04867_ VGND VGND VPWR VPWR _01241_ sky130_fd_sc_hd__mux2_1
X_05812_ _02099_ _02240_ _02237_ VGND VGND VPWR VPWR _02376_ sky130_fd_sc_hd__a21oi_1
X_06792_ net179 _02725_ _03212_ VGND VGND VPWR VPWR _00086_ sky130_fd_sc_hd__a21o_1
XFILLER_55_528 VGND VGND VPWR VPWR sky130_fd_sc_hd__decap_8
X_05743_ _02131_ _02135_ _02136_ VGND VGND VPWR VPWR _02314_ sky130_fd_sc_hd__a21oi_1
X_08531_ cpuregs\[24\]\[0\] cpuregs\[25\]\[0\] cpuregs\[26\]\[0\] cpuregs\[27\]\[0\]
+ net279 _00008_ VGND VGND VPWR VPWR _04233_ sky130_fd_sc_hd__mux4_1
XFILLER_63_561 VGND VGND VPWR VPWR sky130_fd_sc_hd__decap_8
X_08462_ cpuregs\[16\]\[31\] cpuregs\[17\]\[31\] cpuregs\[18\]\[31\] cpuregs\[19\]\[31\]
+ net264 net259 VGND VGND VPWR VPWR _04199_ sky130_fd_sc_hd__mux4_1
XFILLER_35_252 VGND VGND VPWR VPWR sky130_fd_sc_hd__fill_1
X_05674_ _02165_ _02239_ _02237_ VGND VGND VPWR VPWR _02255_ sky130_fd_sc_hd__o21ba_1
X_07413_ cpuregs\[14\]\[31\] _02712_ net247 VGND VGND VPWR VPWR _00355_ sky130_fd_sc_hd__mux2_1
XFILLER_51_745 VGND VGND VPWR VPWR sky130_fd_sc_hd__fill_1
XFILLER_149_611 VGND VGND VPWR VPWR sky130_fd_sc_hd__decap_4
X_08393_ count_cycle\[49\] _04143_ net34 VGND VGND VPWR VPWR _04145_ sky130_fd_sc_hd__o21ai_1
XFILLER_23_458 VGND VGND VPWR VPWR sky130_fd_sc_hd__fill_1
XFILLER_148_121 VPWR VGND VPWR VGND sky130_ef_sc_hd__decap_12
X_07344_ cpuregs\[21\]\[28\] _02699_ net248 VGND VGND VPWR VPWR _00288_ sky130_fd_sc_hd__mux2_1
XTAP_TAPCELL_ROW_137_2529 VGND VPWR sky130_fd_sc_hd__tapvpwrvgnd_1
XTAP_TAPCELL_ROW_137_2518 VGND VPWR sky130_fd_sc_hd__tapvpwrvgnd_1
X_07275_ cpuregs\[2\]\[26\] _02691_ net250 VGND VGND VPWR VPWR _00222_ sky130_fd_sc_hd__mux2_1
XFILLER_148_165 VPWR VGND VPWR VGND sky130_ef_sc_hd__decap_12
XFILLER_137_839 VGND VGND VPWR VPWR sky130_fd_sc_hd__fill_1
XFILLER_12_15 VPWR VGND VPWR VGND sky130_ef_sc_hd__decap_12
XTAP_TAPCELL_ROW_150_2729 VGND VPWR sky130_fd_sc_hd__tapvpwrvgnd_1
XFILLER_128_15 VPWR VGND VPWR VGND sky130_ef_sc_hd__decap_12
X_06226_ _02672_ _02673_ VGND VGND VPWR VPWR _02674_ sky130_fd_sc_hd__nor2_1
X_09014_ cpuregs\[12\]\[29\] cpuregs\[13\]\[29\] cpuregs\[14\]\[29\] cpuregs\[15\]\[29\]
+ net275 net271 VGND VGND VPWR VPWR _04687_ sky130_fd_sc_hd__mux4_1
XFILLER_129_390 VGND VGND VPWR VPWR sky130_fd_sc_hd__fill_2
XFILLER_117_530 VGND VGND VPWR VPWR sky130_fd_sc_hd__decap_4
XFILLER_105_703 VGND VGND VPWR VPWR sky130_fd_sc_hd__decap_6
XFILLER_117_585 VGND VGND VPWR VPWR sky130_fd_sc_hd__fill_1
XTAP_TAPCELL_ROW_57_1244 VGND VPWR sky130_fd_sc_hd__tapvpwrvgnd_1
X_06157_ reg_pc\[9\] _02614_ VGND VGND VPWR VPWR _02618_ sky130_fd_sc_hd__or2_1
XFILLER_2_307 VGND VGND VPWR VPWR sky130_fd_sc_hd__fill_1
XFILLER_132_533 VPWR VGND VPWR VGND sky130_ef_sc_hd__decap_12
X_06088_ reg_sh\[4\] _01638_ _01661_ VGND VGND VPWR VPWR _02559_ sky130_fd_sc_hd__a21oi_1
X_05108_ _01715_ _01717_ _01718_ VGND VGND VPWR VPWR _01719_ sky130_fd_sc_hd__and3_1
X_09916_ clknet_leaf_26_clk _00051_ VGND VGND VPWR VPWR cpuregs\[11\]\[14\] sky130_fd_sc_hd__dfxtp_1
X_05039_ instr_lhu instr_lh _01630_ VGND VGND VPWR VPWR _01659_ sky130_fd_sc_hd__o21a_1
XFILLER_86_620 VGND VGND VPWR VPWR sky130_fd_sc_hd__decap_4
XTAP_TAPCELL_ROW_70_1455 VGND VPWR sky130_fd_sc_hd__tapvpwrvgnd_1
XTAP_TAPCELL_ROW_70_1444 VGND VPWR sky130_fd_sc_hd__tapvpwrvgnd_1
XFILLER_59_834 VGND VGND VPWR VPWR sky130_fd_sc_hd__decap_6
X_09847_ _02670_ cpuregs\[10\]\[21\] _04876_ VGND VGND VPWR VPWR _01531_ sky130_fd_sc_hd__mux2_1
XFILLER_100_452 VGND VGND VPWR VPWR sky130_fd_sc_hd__decap_3
XFILLER_59_867 VGND VGND VPWR VPWR sky130_fd_sc_hd__fill_1
X_09778_ _02657_ cpuregs\[7\]\[18\] _04874_ VGND VGND VPWR VPWR _01432_ sky130_fd_sc_hd__mux2_1
XFILLER_100_496 VGND VGND VPWR VPWR sky130_fd_sc_hd__fill_2
XFILLER_100_474 VGND VGND VPWR VPWR sky130_fd_sc_hd__fill_2
X_08729_ _01558_ _04410_ _04409_ _01560_ VGND VGND VPWR VPWR _04418_ sky130_fd_sc_hd__o211a_1
XFILLER_73_369 VGND VGND VPWR VPWR sky130_fd_sc_hd__decap_4
XTAP_TAPCELL_ROW_1_340 VGND VPWR sky130_fd_sc_hd__tapvpwrvgnd_1
XTAP_TAPCELL_ROW_1_351 VGND VPWR sky130_fd_sc_hd__tapvpwrvgnd_1
XFILLER_26_230 VGND VGND VPWR VPWR sky130_fd_sc_hd__decap_3
XFILLER_14_403 VGND VGND VPWR VPWR sky130_fd_sc_hd__fill_1
XFILLER_27_797 VPWR VGND VPWR VGND sky130_ef_sc_hd__decap_12
XFILLER_81_391 VGND VGND VPWR VPWR sky130_fd_sc_hd__fill_1
XFILLER_53_55 VGND VGND VPWR VPWR sky130_fd_sc_hd__fill_1
X_10622_ clknet_leaf_85_clk _00752_ VGND VGND VPWR VPWR count_cycle\[45\] sky130_fd_sc_hd__dfxtp_1
X_10553_ clknet_leaf_131_clk _00683_ VGND VGND VPWR VPWR reg_next_pc\[8\] sky130_fd_sc_hd__dfxtp_1
XFILLER_10_642 VGND VGND VPWR VPWR sky130_fd_sc_hd__fill_2
XTAP_TAPCELL_ROW_40_968 VGND VPWR sky130_fd_sc_hd__tapvpwrvgnd_1
XTAP_TAPCELL_ROW_40_979 VGND VPWR sky130_fd_sc_hd__tapvpwrvgnd_1
XFILLER_136_861 VGND VGND VPWR VPWR sky130_fd_sc_hd__decap_6
XFILLER_108_530 VGND VGND VPWR VPWR sky130_fd_sc_hd__fill_2
X_10484_ clknet_leaf_107_clk _00614_ VGND VGND VPWR VPWR count_instr\[33\] sky130_fd_sc_hd__dfxtp_1
XFILLER_108_596 VGND VGND VPWR VPWR sky130_fd_sc_hd__decap_4
XFILLER_5_167 VGND VGND VPWR VPWR sky130_fd_sc_hd__fill_1
XFILLER_151_853 VPWR VGND VPWR VGND sky130_ef_sc_hd__decap_12
XFILLER_78_41 VGND VGND VPWR VPWR sky130_fd_sc_hd__fill_2
XFILLER_151_897 VGND VGND VPWR VPWR sky130_fd_sc_hd__decap_6
XFILLER_150_363 VGND VGND VPWR VPWR sky130_fd_sc_hd__fill_1
XFILLER_96_417 VGND VGND VPWR VPWR sky130_fd_sc_hd__decap_3
XFILLER_78_85 VGND VGND VPWR VPWR sky130_fd_sc_hd__decap_6
X_11105_ clknet_leaf_101_clk _00018_ VGND VGND VPWR VPWR cpu_state\[1\] sky130_fd_sc_hd__dfxtp_4
XTAP_TAPCELL_ROW_9_473 VGND VPWR sky130_fd_sc_hd__tapvpwrvgnd_1
X_11036_ clknet_leaf_88_clk _00036_ VGND VGND VPWR VPWR _00016_ sky130_fd_sc_hd__dfxtp_4
XFILLER_76_152 VGND VGND VPWR VPWR sky130_fd_sc_hd__decap_4
XFILLER_76_141 VGND VGND VPWR VPWR sky130_fd_sc_hd__fill_2
XFILLER_91_111 VGND VGND VPWR VPWR sky130_fd_sc_hd__fill_1
XTAP_TAPCELL_ROW_88_1738 VGND VPWR sky130_fd_sc_hd__tapvpwrvgnd_1
XFILLER_91_133 VGND VGND VPWR VPWR sky130_fd_sc_hd__decap_6
XFILLER_80_818 VGND VGND VPWR VPWR sky130_fd_sc_hd__fill_1
XFILLER_17_230 VGND VGND VPWR VPWR sky130_fd_sc_hd__fill_1
XFILLER_17_263 VGND VGND VPWR VPWR sky130_fd_sc_hd__fill_1
XFILLER_33_701 VGND VGND VPWR VPWR sky130_fd_sc_hd__fill_1
XFILLER_45_561 VGND VGND VPWR VPWR sky130_fd_sc_hd__decap_4
XFILLER_72_391 VGND VGND VPWR VPWR sky130_fd_sc_hd__decap_6
XTAP_TAPCELL_ROW_28_781 VGND VPWR sky130_fd_sc_hd__tapvpwrvgnd_1
XFILLER_33_745 VGND VGND VPWR VPWR sky130_fd_sc_hd__decap_4
XFILLER_45_583 VPWR VGND VPWR VGND sky130_ef_sc_hd__decap_12
XFILLER_33_778 VGND VGND VPWR VPWR sky130_fd_sc_hd__decap_6
X_05390_ cpu_state\[3\] _01972_ _01973_ _01979_ VGND VGND VPWR VPWR _04895_ sky130_fd_sc_hd__a31o_1
XTAP_TAPCELL_ROW_119_2237 VGND VPWR sky130_fd_sc_hd__tapvpwrvgnd_1
X_07060_ _03462_ _03469_ _03470_ _01581_ _01580_ VGND VGND VPWR VPWR _03471_ sky130_fd_sc_hd__a221o_1
XFILLER_119_839 VGND VGND VPWR VPWR sky130_fd_sc_hd__fill_1
XFILLER_146_669 VPWR VGND VPWR VGND sky130_ef_sc_hd__decap_12
XTAP_TAPCELL_ROW_132_2437 VGND VPWR sky130_fd_sc_hd__tapvpwrvgnd_1
X_06011_ reg_out\[28\] reg_next_pc\[28\] net596 VGND VGND VPWR VPWR _02509_ sky130_fd_sc_hd__mux2_1
XTAP_TAPCELL_ROW_132_2448 VGND VPWR sky130_fd_sc_hd__tapvpwrvgnd_1
Xoutput225 net225 VGND VGND VPWR VPWR pcpi_rs2[2] sky130_fd_sc_hd__buf_2
Xoutput214 net214 VGND VGND VPWR VPWR pcpi_rs2[1] sky130_fd_sc_hd__buf_2
Xoutput203 net203 VGND VGND VPWR VPWR pcpi_rs2[0] sky130_fd_sc_hd__buf_2
XFILLER_114_533 VGND VGND VPWR VPWR sky130_fd_sc_hd__fill_2
XFILLER_141_363 VGND VGND VPWR VPWR sky130_fd_sc_hd__decap_6
XFILLER_114_566 VPWR VGND VPWR VGND sky130_ef_sc_hd__decap_12
XFILLER_59_119 VGND VGND VPWR VPWR sky130_fd_sc_hd__decap_6
XFILLER_59_108 VGND VGND VPWR VPWR sky130_fd_sc_hd__decap_4
XFILLER_141_385 VGND VGND VPWR VPWR sky130_fd_sc_hd__decap_6
X_07962_ decoded_imm_j\[8\] _03695_ VGND VGND VPWR VPWR _03787_ sky130_fd_sc_hd__nand2_1
X_09701_ _02612_ cpuregs\[5\]\[7\] _04872_ VGND VGND VPWR VPWR _01357_ sky130_fd_sc_hd__mux2_1
X_06913_ cpuregs\[24\]\[22\] cpuregs\[25\]\[22\] cpuregs\[26\]\[22\] cpuregs\[27\]\[22\]
+ net266 net261 VGND VGND VPWR VPWR _03329_ sky130_fd_sc_hd__mux4_1
XTAP_TAPCELL_ROW_52_1163 VGND VPWR sky130_fd_sc_hd__tapvpwrvgnd_1
X_07893_ instr_jal _03688_ net405 VGND VGND VPWR VPWR _03724_ sky130_fd_sc_hd__o21ai_1
XTAP_TAPCELL_ROW_147_2691 VGND VPWR sky130_fd_sc_hd__tapvpwrvgnd_1
XTAP_TAPCELL_ROW_147_2680 VGND VPWR sky130_fd_sc_hd__tapvpwrvgnd_1
X_06844_ net237 _03247_ _03262_ _03237_ VGND VGND VPWR VPWR _00088_ sky130_fd_sc_hd__a31o_1
XFILLER_67_163 VGND VGND VPWR VPWR sky130_fd_sc_hd__decap_4
X_09632_ _02603_ cpuregs\[22\]\[5\] _04869_ VGND VGND VPWR VPWR _01291_ sky130_fd_sc_hd__mux2_1
XFILLER_56_859 VGND VGND VPWR VPWR sky130_fd_sc_hd__fill_1
X_09563_ cpuregs\[29\]\[2\] _02590_ net239 VGND VGND VPWR VPWR _01224_ sky130_fd_sc_hd__mux2_1
XFILLER_130_27 VGND VGND VPWR VPWR sky130_fd_sc_hd__fill_1
X_06775_ _03188_ _03191_ _03194_ _03195_ VGND VGND VPWR VPWR _03196_ sky130_fd_sc_hd__a2bb2o_1
X_08514_ mem_do_rdata net34 _01612_ _01630_ VGND VGND VPWR VPWR _00804_ sky130_fd_sc_hd__a31o_1
XFILLER_55_369 VPWR VGND VPWR VGND sky130_ef_sc_hd__decap_12
XFILLER_36_550 VGND VGND VPWR VPWR sky130_fd_sc_hd__fill_1
X_05726_ _02298_ _02299_ _02294_ VGND VGND VPWR VPWR alu_out\[9\] sky130_fd_sc_hd__a21o_1
X_09494_ _02581_ _03555_ VGND VGND VPWR VPWR _04865_ sky130_fd_sc_hd__nor2_8
X_05657_ instr_xor instr_xori VGND VGND VPWR VPWR _02240_ sky130_fd_sc_hd__or2_4
X_08445_ cpuregs\[4\]\[31\] cpuregs\[5\]\[31\] net264 VGND VGND VPWR VPWR _04182_
+ sky130_fd_sc_hd__mux2_1
X_08376_ count_cycle\[41\] _04129_ count_cycle\[43\] count_cycle\[42\] VGND VGND VPWR
+ VPWR _04134_ sky130_fd_sc_hd__and4_1
X_05588_ _02157_ _02124_ _02120_ VGND VGND VPWR VPWR _02171_ sky130_fd_sc_hd__and3b_1
XFILLER_51_575 VPWR VGND VPWR VGND sky130_ef_sc_hd__decap_12
XFILLER_23_266 VGND VGND VPWR VPWR sky130_fd_sc_hd__fill_2
XFILLER_23_277 VGND VGND VPWR VPWR sky130_fd_sc_hd__decap_3
X_07327_ cpuregs\[21\]\[11\] _02630_ net248 VGND VGND VPWR VPWR _00271_ sky130_fd_sc_hd__mux2_1
XFILLER_23_69 VGND VGND VPWR VPWR sky130_fd_sc_hd__decap_3
XFILLER_139_69 VGND VGND VPWR VPWR sky130_fd_sc_hd__decap_8
XFILLER_136_102 VGND VGND VPWR VPWR sky130_fd_sc_hd__fill_1
X_07258_ cpuregs\[2\]\[9\] _02621_ net250 VGND VGND VPWR VPWR _00205_ sky130_fd_sc_hd__mux2_1
XFILLER_151_105 VGND VGND VPWR VPWR sky130_fd_sc_hd__decap_6
X_06209_ reg_pc\[19\] reg_pc\[18\] _02652_ VGND VGND VPWR VPWR _02660_ sky130_fd_sc_hd__and3_1
X_07189_ cpuregs\[30\]\[7\] _02612_ net252 VGND VGND VPWR VPWR _00139_ sky130_fd_sc_hd__mux2_1
XFILLER_151_149 VPWR VGND VPWR VGND sky130_ef_sc_hd__decap_12
XFILLER_133_853 VPWR VGND VPWR VGND sky130_ef_sc_hd__decap_12
XFILLER_132_330 VGND VGND VPWR VPWR sky130_fd_sc_hd__decap_6
XFILLER_117_393 VPWR VGND VPWR VGND sky130_ef_sc_hd__decap_12
XFILLER_133_897 VPWR VGND VPWR VGND sky130_ef_sc_hd__decap_12
XFILLER_132_363 VGND VGND VPWR VPWR sky130_fd_sc_hd__fill_1
XTAP_TAPCELL_ROW_6_432 VGND VPWR sky130_fd_sc_hd__tapvpwrvgnd_1
XTAP_TAPCELL_ROW_6_421 VGND VPWR sky130_fd_sc_hd__tapvpwrvgnd_1
XFILLER_59_653 VGND VGND VPWR VPWR sky130_fd_sc_hd__decap_3
XFILLER_73_144 VGND VGND VPWR VPWR sky130_fd_sc_hd__fill_2
XFILLER_73_122 VGND VGND VPWR VPWR sky130_fd_sc_hd__decap_4
XFILLER_0_29 VPWR VGND VPWR VGND sky130_ef_sc_hd__decap_12
XFILLER_46_347 VGND VGND VPWR VPWR sky130_fd_sc_hd__decap_6
XFILLER_104_83 VGND VGND VPWR VPWR sky130_fd_sc_hd__fill_1
XFILLER_74_689 VGND VGND VPWR VPWR sky130_fd_sc_hd__decap_8
XTAP_TAPCELL_ROW_83_1657 VGND VPWR sky130_fd_sc_hd__tapvpwrvgnd_1
XFILLER_9_27 VPWR VGND VPWR VGND sky130_ef_sc_hd__decap_12
XFILLER_42_586 VGND VGND VPWR VPWR sky130_fd_sc_hd__fill_2
X_10605_ clknet_leaf_81_clk _00735_ VGND VGND VPWR VPWR count_cycle\[28\] sky130_fd_sc_hd__dfxtp_1
XFILLER_127_113 VGND VGND VPWR VPWR sky130_fd_sc_hd__decap_8
XFILLER_10_461 VGND VGND VPWR VPWR sky130_fd_sc_hd__fill_1
X_10536_ clknet_leaf_63_clk _00666_ VGND VGND VPWR VPWR reg_pc\[22\] sky130_fd_sc_hd__dfxtp_1
XFILLER_6_421 VGND VGND VPWR VPWR sky130_fd_sc_hd__fill_1
XFILLER_142_105 VPWR VGND VPWR VGND sky130_ef_sc_hd__decap_12
XTAP_TAPCELL_ROW_114_2156 VGND VPWR sky130_fd_sc_hd__tapvpwrvgnd_1
XPHY_EDGE_ROW_108_Right_108 VGND VGND VPWR VPWR sky130_fd_sc_hd__decap_3
XFILLER_89_51 VGND VGND VPWR VPWR sky130_fd_sc_hd__decap_4
X_10467_ clknet_leaf_86_clk _00597_ VGND VGND VPWR VPWR count_instr\[16\] sky130_fd_sc_hd__dfxtp_1
XFILLER_111_503 VGND VGND VPWR VPWR sky130_fd_sc_hd__fill_1
XFILLER_69_417 VGND VGND VPWR VPWR sky130_fd_sc_hd__decap_8
X_10398_ clknet_leaf_12_clk _00528_ VGND VGND VPWR VPWR cpuregs\[20\]\[12\] sky130_fd_sc_hd__dfxtp_1
XFILLER_151_694 VGND VGND VPWR VPWR sky130_fd_sc_hd__decap_8
XFILLER_111_514 VPWR VGND VPWR VGND sky130_ef_sc_hd__decap_12
XFILLER_97_737 VPWR VGND VPWR VGND sky130_ef_sc_hd__decap_12
XFILLER_2_693 VGND VGND VPWR VPWR sky130_fd_sc_hd__decap_6
XFILLER_96_269 VGND VGND VPWR VPWR sky130_fd_sc_hd__fill_2
XFILLER_49_130 VGND VGND VPWR VPWR sky130_fd_sc_hd__fill_1
XFILLER_1_181 VPWR VGND VPWR VGND sky130_ef_sc_hd__decap_12
X_11019_ clknet_leaf_71_clk _01081_ VGND VGND VPWR VPWR cpuregs\[19\]\[19\] sky130_fd_sc_hd__dfxtp_1
XFILLER_65_645 VGND VGND VPWR VPWR sky130_fd_sc_hd__decap_6
XFILLER_53_807 VPWR VGND VPWR VGND sky130_ef_sc_hd__decap_12
XFILLER_80_615 VGND VGND VPWR VPWR sky130_fd_sc_hd__fill_1
XFILLER_46_881 VPWR VGND VPWR VGND sky130_ef_sc_hd__decap_12
X_06560_ cpuregs\[28\]\[9\] cpuregs\[29\]\[9\] cpuregs\[30\]\[9\] cpuregs\[31\]\[9\]
+ net263 net259 VGND VGND VPWR VPWR _02989_ sky130_fd_sc_hd__mux4_1
X_05511_ net184 net216 VGND VGND VPWR VPWR _02094_ sky130_fd_sc_hd__or2_1
X_06491_ net199 _02725_ VGND VGND VPWR VPWR _02923_ sky130_fd_sc_hd__and2_1
X_08230_ decoded_imm_j\[20\] _03717_ VGND VGND VPWR VPWR _04034_ sky130_fd_sc_hd__nor2_1
X_05442_ reg_pc\[30\] decoded_imm\[30\] VGND VGND VPWR VPWR _02027_ sky130_fd_sc_hd__nand2_1
XFILLER_60_361 VGND VGND VPWR VPWR sky130_fd_sc_hd__decap_3
X_08161_ instr_jal _03969_ _03970_ _03965_ VGND VGND VPWR VPWR _03971_ sky130_fd_sc_hd__a31o_1
XFILLER_119_614 VGND VGND VPWR VPWR sky130_fd_sc_hd__fill_2
X_05373_ count_instr\[56\] instr_rdinstrh instr_rdinstr count_instr\[24\] VGND VGND
+ VPWR VPWR _01964_ sky130_fd_sc_hd__a22o_1
XFILLER_146_433 VPWR VGND VPWR VGND sky130_ef_sc_hd__decap_12
X_07112_ _03512_ _03519_ _03520_ _01581_ _01580_ VGND VGND VPWR VPWR _03521_ sky130_fd_sc_hd__a221o_1
X_08092_ decoded_imm_j\[18\] _03705_ VGND VGND VPWR VPWR _03907_ sky130_fd_sc_hd__nand2_1
XFILLER_146_477 VGND VGND VPWR VPWR sky130_fd_sc_hd__fill_2
Xclkload62 clknet_leaf_40_clk VGND VGND VPWR VPWR clkload62/Y sky130_fd_sc_hd__clkinvlp_4
XFILLER_118_179 VGND VGND VPWR VPWR sky130_fd_sc_hd__fill_1
X_07043_ net189 _02721_ _03378_ _01641_ VGND VGND VPWR VPWR _03454_ sky130_fd_sc_hd__o211a_1
Xclkload51 clknet_leaf_28_clk VGND VGND VPWR VPWR clkload51/Y sky130_fd_sc_hd__inv_6
Xclkload40 clknet_leaf_17_clk VGND VGND VPWR VPWR clkload40/Y sky130_fd_sc_hd__inv_12
Xclkload73 clknet_leaf_45_clk VGND VGND VPWR VPWR clkload73/Y sky130_fd_sc_hd__inv_12
XFILLER_133_149 VGND VGND VPWR VPWR sky130_fd_sc_hd__decap_3
XFILLER_115_853 VPWR VGND VPWR VGND sky130_ef_sc_hd__decap_12
Xclkload95 clknet_leaf_132_clk VGND VGND VPWR VPWR clkload95/Y sky130_fd_sc_hd__inv_6
XTAP_TAPCELL_ROW_54_1203 VGND VPWR sky130_fd_sc_hd__tapvpwrvgnd_1
Xclkload84 clknet_leaf_123_clk VGND VGND VPWR VPWR clkload84/Y sky130_fd_sc_hd__bufinv_16
XTAP_TAPCELL_ROW_149_2720 VGND VPWR sky130_fd_sc_hd__tapvpwrvgnd_1
XFILLER_0_608 VGND VGND VPWR VPWR sky130_fd_sc_hd__decap_4
X_08994_ cpuregs\[24\]\[28\] cpuregs\[25\]\[28\] cpuregs\[26\]\[28\] cpuregs\[27\]\[28\]
+ net275 net271 VGND VGND VPWR VPWR _04668_ sky130_fd_sc_hd__mux4_1
XFILLER_125_27 VPWR VGND VPWR VGND sky130_ef_sc_hd__decap_12
XFILLER_115_897 VGND VGND VPWR VPWR sky130_fd_sc_hd__decap_3
XPHY_EDGE_ROW_10_Left_164 VGND VGND VPWR VPWR sky130_fd_sc_hd__decap_3
XFILLER_130_867 VGND VGND VPWR VPWR sky130_fd_sc_hd__fill_1
XFILLER_68_450 VGND VGND VPWR VPWR sky130_fd_sc_hd__fill_1
X_07945_ _03768_ _03771_ _03576_ VGND VGND VPWR VPWR _03772_ sky130_fd_sc_hd__a21oi_1
XFILLER_28_303 VGND VGND VPWR VPWR sky130_fd_sc_hd__decap_4
XFILLER_141_15 VPWR VGND VPWR VGND sky130_ef_sc_hd__decap_12
X_09615_ _02670_ cpuregs\[3\]\[21\] _04868_ VGND VGND VPWR VPWR _01275_ sky130_fd_sc_hd__mux2_1
X_07876_ reg_pc\[26\] _01624_ _01628_ _03713_ VGND VGND VPWR VPWR _00670_ sky130_fd_sc_hd__a22o_1
XFILLER_55_122 VGND VGND VPWR VPWR sky130_fd_sc_hd__decap_8
X_06827_ _01641_ _03167_ _03245_ _03244_ VGND VGND VPWR VPWR _03246_ sky130_fd_sc_hd__a31o_1
XFILLER_71_615 VGND VGND VPWR VPWR sky130_fd_sc_hd__fill_1
XFILLER_55_155 VGND VGND VPWR VPWR sky130_fd_sc_hd__decap_4
X_09546_ cpuregs\[23\]\[18\] _02657_ _04866_ VGND VGND VPWR VPWR _01208_ sky130_fd_sc_hd__mux2_1
X_06758_ _03171_ _03172_ _03175_ _03176_ _01579_ _01581_ VGND VGND VPWR VPWR _03180_
+ sky130_fd_sc_hd__mux4_1
X_09477_ cpuregs\[24\]\[15\] _02646_ net242 VGND VGND VPWR VPWR _01141_ sky130_fd_sc_hd__mux2_1
XTAP_TAPCELL_ROW_65_1365 VGND VPWR sky130_fd_sc_hd__tapvpwrvgnd_1
X_05709_ net200 net126 _02238_ _02241_ _02283_ VGND VGND VPWR VPWR _02285_ sky130_fd_sc_hd__a32o_1
X_08428_ _04163_ count_cycle\[62\] count_cycle\[61\] VGND VGND VPWR VPWR _04167_ sky130_fd_sc_hd__and3_1
X_06689_ _01641_ _03111_ _03112_ _02744_ VGND VGND VPWR VPWR _03113_ sky130_fd_sc_hd__a22oi_1
XTAP_TAPCELL_ROW_65_1376 VGND VPWR sky130_fd_sc_hd__tapvpwrvgnd_1
XFILLER_51_361 VPWR VGND VPWR VGND sky130_ef_sc_hd__decap_12
X_08359_ _04123_ net34 _04122_ VGND VGND VPWR VPWR _00743_ sky130_fd_sc_hd__and3b_1
Xclkload1 clknet_4_2_0_clk VGND VGND VPWR VPWR clkload1/X sky130_fd_sc_hd__clkbuf_8
XFILLER_125_606 VGND VGND VPWR VPWR sky130_fd_sc_hd__fill_1
X_11370_ clknet_leaf_125_clk _01414_ VGND VGND VPWR VPWR cpuregs\[7\]\[0\] sky130_fd_sc_hd__dfxtp_1
XFILLER_125_617 VGND VGND VPWR VPWR sky130_fd_sc_hd__decap_4
X_10321_ clknet_leaf_16_clk _00451_ VGND VGND VPWR VPWR cpuregs\[26\]\[31\] sky130_fd_sc_hd__dfxtp_1
XFILLER_124_149 VGND VGND VPWR VPWR sky130_fd_sc_hd__decap_3
XFILLER_140_609 VGND VGND VPWR VPWR sky130_fd_sc_hd__fill_2
X_10252_ clknet_leaf_43_clk _00382_ VGND VGND VPWR VPWR cpuregs\[27\]\[26\] sky130_fd_sc_hd__dfxtp_1
XFILLER_79_726 VGND VGND VPWR VPWR sky130_fd_sc_hd__fill_2
XFILLER_1_3 VPWR VGND VPWR VGND sky130_ef_sc_hd__decap_12
XFILLER_120_300 VGND VGND VPWR VPWR sky130_fd_sc_hd__decap_8
X_10183_ clknet_leaf_80_clk _00313_ VGND VGND VPWR VPWR cpuregs\[9\]\[21\] sky130_fd_sc_hd__dfxtp_1
XFILLER_79_748 VGND VGND VPWR VPWR sky130_fd_sc_hd__decap_4
XFILLER_78_269 VGND VGND VPWR VPWR sky130_fd_sc_hd__decap_3
XFILLER_121_889 VGND VGND VPWR VPWR sky130_fd_sc_hd__decap_6
XFILLER_120_377 VGND VGND VPWR VPWR sky130_fd_sc_hd__decap_4
XFILLER_93_217 VGND VGND VPWR VPWR sky130_fd_sc_hd__decap_6
XFILLER_93_206 VGND VGND VPWR VPWR sky130_fd_sc_hd__fill_2
XFILLER_47_623 VGND VGND VPWR VPWR sky130_fd_sc_hd__fill_1
XFILLER_74_442 VGND VGND VPWR VPWR sky130_fd_sc_hd__fill_2
XFILLER_46_133 VGND VGND VPWR VPWR sky130_fd_sc_hd__decap_6
XFILLER_47_656 VGND VGND VPWR VPWR sky130_fd_sc_hd__decap_8
XFILLER_61_103 VGND VGND VPWR VPWR sky130_fd_sc_hd__fill_1
XFILLER_28_881 VPWR VGND VPWR VGND sky130_ef_sc_hd__decap_12
XFILLER_131_92 VGND VGND VPWR VPWR sky130_fd_sc_hd__decap_4
XFILLER_61_169 VPWR VGND VPWR VGND sky130_ef_sc_hd__decap_12
XFILLER_15_586 VPWR VGND VPWR VGND sky130_ef_sc_hd__decap_12
XFILLER_43_895 VGND VGND VPWR VPWR sky130_fd_sc_hd__fill_1
XFILLER_128_400 VPWR VGND VPWR VGND sky130_ef_sc_hd__decap_12
XFILLER_30_589 VPWR VGND VPWR VGND sky130_ef_sc_hd__decap_12
XFILLER_143_414 VGND VGND VPWR VPWR sky130_fd_sc_hd__decap_4
XFILLER_7_785 VPWR VGND VPWR VGND sky130_ef_sc_hd__decap_12
XFILLER_6_251 VGND VGND VPWR VPWR sky130_fd_sc_hd__fill_1
X_10519_ clknet_leaf_130_clk _00649_ VGND VGND VPWR VPWR reg_pc\[5\] sky130_fd_sc_hd__dfxtp_2
XFILLER_115_138 VPWR VGND VPWR VGND sky130_ef_sc_hd__decap_12
XFILLER_97_501 VGND VGND VPWR VPWR sky130_fd_sc_hd__decap_3
XFILLER_69_225 VGND VGND VPWR VPWR sky130_fd_sc_hd__fill_1
XFILLER_34_3 VPWR VGND VPWR VGND sky130_ef_sc_hd__decap_12
XFILLER_111_366 VGND VGND VPWR VPWR sky130_fd_sc_hd__decap_4
X_07730_ _03628_ net34 _03627_ VGND VGND VPWR VPWR _00609_ sky130_fd_sc_hd__and3b_1
X_05991_ reg_out\[18\] reg_next_pc\[18\] net596 VGND VGND VPWR VPWR _02499_ sky130_fd_sc_hd__mux2_1
XFILLER_38_601 VGND VGND VPWR VPWR sky130_fd_sc_hd__decap_8
XTAP_TAPCELL_ROW_127_2369 VGND VPWR sky130_fd_sc_hd__tapvpwrvgnd_1
XTAP_TAPCELL_ROW_127_2358 VGND VPWR sky130_fd_sc_hd__tapvpwrvgnd_1
X_04942_ net223 VGND VGND VPWR VPWR _01575_ sky130_fd_sc_hd__inv_2
XFILLER_38_689 VGND VGND VPWR VPWR sky130_fd_sc_hd__decap_3
X_07661_ _03583_ _03584_ VGND VGND VPWR VPWR _00584_ sky130_fd_sc_hd__nor2_1
X_06612_ net177 _02720_ _02744_ _02959_ VGND VGND VPWR VPWR _03039_ sky130_fd_sc_hd__o211a_1
XFILLER_53_626 VPWR VGND VPWR VGND sky130_ef_sc_hd__decap_12
X_07592_ cpuregs\[20\]\[9\] _02621_ net245 VGND VGND VPWR VPWR _00525_ sky130_fd_sc_hd__mux2_1
X_09400_ _02598_ cpuregs\[18\]\[4\] _04862_ VGND VGND VPWR VPWR _01034_ sky130_fd_sc_hd__mux2_1
XTAP_TAPCELL_ROW_140_2569 VGND VPWR sky130_fd_sc_hd__tapvpwrvgnd_1
X_09331_ decoded_imm\[30\] _04746_ _04825_ _04827_ VGND VGND VPWR VPWR _01000_ sky130_fd_sc_hd__o22a_1
X_06543_ net258 _02967_ _01581_ VGND VGND VPWR VPWR _02973_ sky130_fd_sc_hd__o21a_1
XFILLER_61_681 VGND VGND VPWR VPWR sky130_fd_sc_hd__decap_8
XFILLER_21_501 VGND VGND VPWR VPWR sky130_fd_sc_hd__decap_3
XFILLER_40_309 VGND VGND VPWR VPWR sky130_fd_sc_hd__fill_2
XTAP_TAPCELL_ROW_47_1084 VGND VPWR sky130_fd_sc_hd__tapvpwrvgnd_1
XTAP_TAPCELL_ROW_16_581 VGND VPWR sky130_fd_sc_hd__tapvpwrvgnd_1
XTAP_TAPCELL_ROW_16_592 VGND VPWR sky130_fd_sc_hd__tapvpwrvgnd_1
X_06474_ _02744_ _02903_ _02905_ _02714_ VGND VGND VPWR VPWR _02906_ sky130_fd_sc_hd__a211o_1
X_09262_ _04802_ _04804_ VGND VGND VPWR VPWR _04805_ sky130_fd_sc_hd__nand2_1
X_08213_ net34 _04018_ VGND VGND VPWR VPWR _00702_ sky130_fd_sc_hd__and2_1
X_05425_ count_instr\[60\] instr_rdinstrh _01587_ _02011_ VGND VGND VPWR VPWR _02012_
+ sky130_fd_sc_hd__a211o_1
X_09193_ mem_rdata_q\[31\] net25 _01609_ VGND VGND VPWR VPWR _01125_ sky130_fd_sc_hd__mux2_1
XFILLER_21_589 VGND VGND VPWR VPWR sky130_fd_sc_hd__decap_4
XFILLER_146_230 VPWR VGND VPWR VGND sky130_ef_sc_hd__decap_12
X_08144_ _03954_ VGND VGND VPWR VPWR _03955_ sky130_fd_sc_hd__inv_2
X_05356_ net16 _01665_ _01856_ VGND VGND VPWR VPWR _01948_ sky130_fd_sc_hd__a21o_1
XTAP_TAPCELL_ROW_60_1295 VGND VPWR sky130_fd_sc_hd__tapvpwrvgnd_1
XTAP_TAPCELL_ROW_60_1284 VGND VPWR sky130_fd_sc_hd__tapvpwrvgnd_1
XFILLER_147_797 VPWR VGND VPWR VGND sky130_ef_sc_hd__decap_12
Xclkload140 clknet_leaf_82_clk VGND VGND VPWR VPWR clkload140/Y sky130_fd_sc_hd__clkinv_4
XFILLER_20_15 VPWR VGND VPWR VGND sky130_ef_sc_hd__decap_12
XFILLER_136_15 VPWR VGND VPWR VGND sky130_ef_sc_hd__decap_12
XFILLER_106_127 VPWR VGND VPWR VGND sky130_ef_sc_hd__decap_12
X_05287_ cpu_state\[3\] _01877_ _01879_ _01884_ VGND VGND VPWR VPWR _01885_ sky130_fd_sc_hd__a31o_1
X_08075_ _03844_ _03858_ _03890_ VGND VGND VPWR VPWR _03891_ sky130_fd_sc_hd__nor3_1
X_07026_ _01579_ _03437_ VGND VGND VPWR VPWR _03438_ sky130_fd_sc_hd__or2_1
XFILLER_96_19 VGND VGND VPWR VPWR sky130_fd_sc_hd__decap_8
XFILLER_0_427 VGND VGND VPWR VPWR sky130_fd_sc_hd__decap_3
XFILLER_0_449 VGND VGND VPWR VPWR sky130_fd_sc_hd__fill_2
X_08977_ net270 _04651_ VGND VGND VPWR VPWR _04652_ sky130_fd_sc_hd__or2_1
XFILLER_88_589 VGND VGND VPWR VPWR sky130_fd_sc_hd__decap_4
X_07928_ _03753_ _03754_ _03755_ VGND VGND VPWR VPWR _03756_ sky130_fd_sc_hd__a21o_1
XFILLER_28_100 VGND VGND VPWR VPWR sky130_fd_sc_hd__decap_6
XFILLER_29_623 VGND VGND VPWR VPWR sky130_fd_sc_hd__fill_1
X_07859_ _02655_ reg_next_pc\[18\] net597 VGND VGND VPWR VPWR _03705_ sky130_fd_sc_hd__mux2_2
XTAP_TAPCELL_ROW_67_1405 VGND VPWR sky130_fd_sc_hd__tapvpwrvgnd_1
XFILLER_56_475 VGND VGND VPWR VPWR sky130_fd_sc_hd__fill_1
XFILLER_44_604 VGND VGND VPWR VPWR sky130_fd_sc_hd__fill_2
X_10870_ clknet_leaf_27_clk _00932_ VGND VGND VPWR VPWR cpuregs\[1\]\[14\] sky130_fd_sc_hd__dfxtp_1
XFILLER_71_456 VGND VGND VPWR VPWR sky130_fd_sc_hd__decap_3
X_09529_ cpuregs\[23\]\[1\] _02588_ _04866_ VGND VGND VPWR VPWR _01191_ sky130_fd_sc_hd__mux2_1
XTAP_TAPCELL_ROW_80_1616 VGND VPWR sky130_fd_sc_hd__tapvpwrvgnd_1
XTAP_TAPCELL_ROW_80_1605 VGND VPWR sky130_fd_sc_hd__tapvpwrvgnd_1
XFILLER_25_895 VGND VGND VPWR VPWR sky130_fd_sc_hd__fill_1
XFILLER_43_169 VPWR VGND VPWR VGND sky130_ef_sc_hd__decap_12
XTAP_TAPCELL_ROW_35_890 VGND VPWR sky130_fd_sc_hd__tapvpwrvgnd_1
XFILLER_61_55 VGND VGND VPWR VPWR sky130_fd_sc_hd__fill_1
XFILLER_12_589 VGND VGND VPWR VPWR sky130_fd_sc_hd__fill_1
X_11422_ clknet_leaf_76_clk _01466_ VGND VGND VPWR VPWR cpuregs\[8\]\[20\] sky130_fd_sc_hd__dfxtp_1
XFILLER_153_701 VPWR VGND VPWR VGND sky130_ef_sc_hd__decap_12
XFILLER_137_274 VGND VGND VPWR VPWR sky130_fd_sc_hd__decap_6
XFILLER_153_734 VGND VGND VPWR VPWR sky130_fd_sc_hd__decap_4
XFILLER_152_233 VPWR VGND VPWR VGND sky130_ef_sc_hd__decap_12
XTAP_TAPCELL_ROW_111_2104 VGND VPWR sky130_fd_sc_hd__tapvpwrvgnd_1
XTAP_TAPCELL_ROW_78_1578 VGND VPWR sky130_fd_sc_hd__tapvpwrvgnd_1
X_11353_ clknet_leaf_15_clk _01397_ VGND VGND VPWR VPWR cpuregs\[6\]\[15\] sky130_fd_sc_hd__dfxtp_1
XTAP_TAPCELL_ROW_111_2115 VGND VPWR sky130_fd_sc_hd__tapvpwrvgnd_1
XFILLER_98_309 VGND VGND VPWR VPWR sky130_fd_sc_hd__decap_6
X_10304_ clknet_leaf_26_clk _00434_ VGND VGND VPWR VPWR cpuregs\[26\]\[14\] sky130_fd_sc_hd__dfxtp_1
X_11284_ clknet_leaf_8_clk _01331_ VGND VGND VPWR VPWR cpuregs\[4\]\[13\] sky130_fd_sc_hd__dfxtp_1
XFILLER_4_755 VGND VGND VPWR VPWR sky130_fd_sc_hd__fill_1
XFILLER_152_277 VPWR VGND VPWR VGND sky130_ef_sc_hd__decap_12
XFILLER_133_480 VPWR VGND VPWR VGND sky130_ef_sc_hd__decap_12
X_10235_ clknet_leaf_146_clk _00365_ VGND VGND VPWR VPWR cpuregs\[27\]\[9\] sky130_fd_sc_hd__dfxtp_1
XTAP_TAPCELL_ROW_91_1789 VGND VPWR sky130_fd_sc_hd__tapvpwrvgnd_1
XFILLER_86_41 VGND VGND VPWR VPWR sky130_fd_sc_hd__decap_6
XFILLER_67_729 VGND VGND VPWR VPWR sky130_fd_sc_hd__decap_3
X_10166_ clknet_leaf_136_clk _00296_ VGND VGND VPWR VPWR cpuregs\[9\]\[4\] sky130_fd_sc_hd__dfxtp_1
XFILLER_86_85 VPWR VGND VPWR VGND sky130_ef_sc_hd__decap_12
X_10097_ clknet_leaf_14_clk _00227_ VGND VGND VPWR VPWR cpuregs\[2\]\[31\] sky130_fd_sc_hd__dfxtp_1
XFILLER_19_111 VGND VGND VPWR VPWR sky130_fd_sc_hd__fill_1
XTAP_TAPCELL_ROW_109_2077 VGND VPWR sky130_fd_sc_hd__tapvpwrvgnd_1
XFILLER_75_773 VGND VGND VPWR VPWR sky130_fd_sc_hd__fill_1
XFILLER_19_199 VGND VGND VPWR VPWR sky130_fd_sc_hd__decap_3
XTAP_TAPCELL_ROW_122_2277 VGND VPWR sky130_fd_sc_hd__tapvpwrvgnd_1
XFILLER_74_294 VGND VGND VPWR VPWR sky130_fd_sc_hd__decap_4
XFILLER_62_434 VGND VGND VPWR VPWR sky130_fd_sc_hd__decap_6
XTAP_TAPCELL_ROW_122_2288 VGND VPWR sky130_fd_sc_hd__tapvpwrvgnd_1
XFILLER_62_489 VPWR VGND VPWR VGND sky130_ef_sc_hd__decap_12
X_10999_ clknet_leaf_14_clk _01061_ VGND VGND VPWR VPWR cpuregs\[18\]\[31\] sky130_fd_sc_hd__dfxtp_1
XFILLER_50_618 VGND VGND VPWR VPWR sky130_fd_sc_hd__fill_2
XFILLER_31_821 VPWR VGND VPWR VGND sky130_ef_sc_hd__decap_12
XFILLER_30_331 VGND VGND VPWR VPWR sky130_fd_sc_hd__fill_1
XTAP_TAPCELL_ROW_13_540 VGND VPWR sky130_fd_sc_hd__tapvpwrvgnd_1
XFILLER_31_865 VPWR VGND VPWR VGND sky130_ef_sc_hd__decap_12
XFILLER_129_753 VGND VGND VPWR VPWR sky130_fd_sc_hd__decap_4
XFILLER_128_230 VPWR VGND VPWR VGND sky130_ef_sc_hd__decap_12
X_06190_ _02643_ _02644_ VGND VGND VPWR VPWR _02645_ sky130_fd_sc_hd__nor2_1
X_05210_ _01810_ _01811_ VGND VGND VPWR VPWR _01813_ sky130_fd_sc_hd__nand2_1
XFILLER_144_701 VGND VGND VPWR VPWR sky130_fd_sc_hd__fill_1
XFILLER_129_797 VPWR VGND VPWR VGND sky130_ef_sc_hd__decap_12
X_05141_ count_instr\[38\] instr_rdinstrh instr_rdinstr count_instr\[6\] VGND VGND
+ VPWR VPWR _01750_ sky130_fd_sc_hd__a22o_1
XFILLER_144_745 VGND VGND VPWR VPWR sky130_fd_sc_hd__decap_8
XFILLER_144_723 VGND VGND VPWR VPWR sky130_fd_sc_hd__fill_1
Xmax_cap257 _01587_ VGND VGND VPWR VPWR net257 sky130_fd_sc_hd__clkbuf_8
Xmax_cap268 _00012_ VGND VGND VPWR VPWR net268 sky130_fd_sc_hd__buf_12
X_05072_ net456 _01588_ net256 _01685_ VGND VGND VPWR VPWR _01686_ sky130_fd_sc_hd__o211a_1
X_08900_ cpuregs\[24\]\[23\] cpuregs\[25\]\[23\] cpuregs\[26\]\[23\] cpuregs\[27\]\[23\]
+ net276 net272 VGND VGND VPWR VPWR _04579_ sky130_fd_sc_hd__mux4_1
XFILLER_103_119 VGND VGND VPWR VPWR sky130_fd_sc_hd__fill_1
X_09880_ cpuregs\[0\]\[10\] VGND VGND VPWR VPWR _01488_ sky130_fd_sc_hd__clkbuf_1
Xmax_cap279 _00007_ VGND VGND VPWR VPWR net279 sky130_fd_sc_hd__buf_12
X_08831_ cpuregs\[16\]\[19\] cpuregs\[17\]\[19\] cpuregs\[18\]\[19\] cpuregs\[19\]\[19\]
+ net280 net274 VGND VGND VPWR VPWR _04514_ sky130_fd_sc_hd__mux4_1
XFILLER_112_631 VPWR VGND VPWR VGND sky130_ef_sc_hd__decap_12
XFILLER_106_29 VPWR VGND VPWR VGND sky130_ef_sc_hd__decap_12
XTAP_TAPCELL_ROW_142_2609 VGND VPWR sky130_fd_sc_hd__tapvpwrvgnd_1
XFILLER_112_697 VGND VGND VPWR VPWR sky130_fd_sc_hd__decap_3
XFILLER_100_859 VGND VGND VPWR VPWR sky130_fd_sc_hd__fill_2
XFILLER_85_559 VGND VGND VPWR VPWR sky130_fd_sc_hd__fill_1
XFILLER_66_740 VGND VGND VPWR VPWR sky130_fd_sc_hd__decap_8
X_08762_ cpuregs\[8\]\[15\] cpuregs\[9\]\[15\] cpuregs\[10\]\[15\] cpuregs\[11\]\[15\]
+ net275 net271 VGND VGND VPWR VPWR _04449_ sky130_fd_sc_hd__mux4_1
X_05974_ net202 _02490_ _01582_ VGND VGND VPWR VPWR net95 sky130_fd_sc_hd__mux2_2
X_07713_ _03616_ _03617_ VGND VGND VPWR VPWR _00603_ sky130_fd_sc_hd__nor2_1
X_04925_ net270 VGND VGND VPWR VPWR _01558_ sky130_fd_sc_hd__clkinv_16
XFILLER_72_209 VGND VGND VPWR VPWR sky130_fd_sc_hd__fill_1
X_08693_ net269 _04380_ _04383_ _04266_ VGND VGND VPWR VPWR _04384_ sky130_fd_sc_hd__o211a_1
X_07644_ _02699_ cpuregs\[17\]\[28\] _03574_ VGND VGND VPWR VPWR _00576_ sky130_fd_sc_hd__mux2_1
XFILLER_65_261 VGND VGND VPWR VPWR sky130_fd_sc_hd__decap_3
XTAP_TAPCELL_ROW_49_1113 VGND VPWR sky130_fd_sc_hd__tapvpwrvgnd_1
X_07575_ cpuregs\[25\]\[26\] _02691_ _03571_ VGND VGND VPWR VPWR _00510_ sky130_fd_sc_hd__mux2_1
XFILLER_15_15 VPWR VGND VPWR VGND sky130_ef_sc_hd__decap_12
XTAP_TAPCELL_ROW_62_1324 VGND VPWR sky130_fd_sc_hd__tapvpwrvgnd_1
X_06526_ _02952_ _02955_ VGND VGND VPWR VPWR _02956_ sky130_fd_sc_hd__nand2_1
X_09314_ latched_rd\[2\] _04815_ _04816_ decoded_rd\[2\] VGND VGND VPWR VPWR _00994_
+ sky130_fd_sc_hd__a22o_1
X_09245_ cpuregs\[1\]\[24\] _02683_ _04799_ VGND VGND VPWR VPWR _00942_ sky130_fd_sc_hd__mux2_1
X_06457_ cpuregs\[16\]\[5\] cpuregs\[17\]\[5\] cpuregs\[18\]\[5\] cpuregs\[19\]\[5\]
+ net268 net262 VGND VGND VPWR VPWR _02890_ sky130_fd_sc_hd__mux4_1
X_05408_ net20 _01665_ _01856_ VGND VGND VPWR VPWR _01996_ sky130_fd_sc_hd__a21o_1
X_09176_ instr_fence _04748_ _04760_ _04790_ VGND VGND VPWR VPWR _00884_ sky130_fd_sc_hd__a22o_1
X_06388_ cpuregs\[10\]\[3\] cpuregs\[11\]\[3\] net264 VGND VGND VPWR VPWR _02823_
+ sky130_fd_sc_hd__mux2_1
XFILLER_147_69 VPWR VGND VPWR VGND sky130_ef_sc_hd__decap_12
X_08127_ decoded_imm_j\[20\] _03708_ VGND VGND VPWR VPWR _03939_ sky130_fd_sc_hd__or2_1
X_05339_ cpu_state\[3\] _01925_ _01926_ _01932_ VGND VGND VPWR VPWR _04891_ sky130_fd_sc_hd__a31o_1
XFILLER_107_447 VGND VGND VPWR VPWR sky130_fd_sc_hd__fill_1
XFILLER_31_69 VGND VGND VPWR VPWR sky130_fd_sc_hd__fill_2
XFILLER_107_469 VGND VGND VPWR VPWR sky130_fd_sc_hd__fill_2
X_08058_ instr_jal _03874_ _03875_ VGND VGND VPWR VPWR _03876_ sky130_fd_sc_hd__or3_1
Xoutput47 net47 VGND VGND VPWR VPWR mem_addr[22] sky130_fd_sc_hd__buf_2
XFILLER_122_417 VGND VGND VPWR VPWR sky130_fd_sc_hd__decap_3
X_07009_ _02714_ _03403_ _03404_ _03406_ _03421_ VGND VGND VPWR VPWR _03422_ sky130_fd_sc_hd__o41a_1
Xoutput36 net36 VGND VGND VPWR VPWR mem_addr[11] sky130_fd_sc_hd__buf_2
Xoutput58 net58 VGND VGND VPWR VPWR mem_addr[3] sky130_fd_sc_hd__buf_2
X_10020_ clknet_leaf_53_clk _00150_ VGND VGND VPWR VPWR cpuregs\[30\]\[18\] sky130_fd_sc_hd__dfxtp_1
XFILLER_115_491 VPWR VGND VPWR VGND sky130_ef_sc_hd__decap_12
Xoutput69 net69 VGND VGND VPWR VPWR mem_la_addr[13] sky130_fd_sc_hd__buf_2
Xpicorv32_291 VGND VGND VPWR VPWR picorv32_291/HI eoi[10] sky130_fd_sc_hd__conb_1
XFILLER_102_141 VGND VGND VPWR VPWR sky130_fd_sc_hd__fill_2
XTAP_TAPCELL_ROW_73_1497 VGND VPWR sky130_fd_sc_hd__tapvpwrvgnd_1
XFILLER_49_729 VGND VGND VPWR VPWR sky130_fd_sc_hd__fill_2
XFILLER_29_464 VGND VGND VPWR VPWR sky130_fd_sc_hd__fill_1
X_10922_ clknet_leaf_30_clk _00984_ VGND VGND VPWR VPWR net155 sky130_fd_sc_hd__dfxtp_1
XFILLER_56_77 VGND VGND VPWR VPWR sky130_fd_sc_hd__decap_6
XFILLER_56_294 VGND VGND VPWR VPWR sky130_fd_sc_hd__decap_4
XFILLER_112_94 VGND VGND VPWR VPWR sky130_fd_sc_hd__decap_6
X_10853_ clknet_leaf_98_clk _00002_ VGND VGND VPWR VPWR is_slti_blt_slt sky130_fd_sc_hd__dfxtp_1
X_10784_ clknet_leaf_98_clk _00849_ VGND VGND VPWR VPWR instr_blt sky130_fd_sc_hd__dfxtp_1
XFILLER_13_821 VPWR VGND VPWR VGND sky130_ef_sc_hd__decap_12
XFILLER_31_117 VGND VGND VPWR VPWR sky130_fd_sc_hd__fill_1
XFILLER_31_139 VPWR VGND VPWR VGND sky130_ef_sc_hd__decap_12
XFILLER_8_302 VGND VGND VPWR VPWR sky130_fd_sc_hd__decap_6
XFILLER_13_865 VPWR VGND VPWR VGND sky130_ef_sc_hd__decap_12
XTAP_TAPCELL_ROW_30_808 VGND VPWR sky130_fd_sc_hd__tapvpwrvgnd_1
XTAP_TAPCELL_ROW_30_819 VGND VPWR sky130_fd_sc_hd__tapvpwrvgnd_1
XFILLER_8_357 VGND VGND VPWR VPWR sky130_fd_sc_hd__decap_6
X_11405_ clknet_leaf_125_clk _01449_ VGND VGND VPWR VPWR cpuregs\[8\]\[3\] sky130_fd_sc_hd__dfxtp_1
XFILLER_126_778 VGND VGND VPWR VPWR sky130_fd_sc_hd__fill_2
XTAP_TAPCELL_ROW_93_1818 VGND VPWR sky130_fd_sc_hd__tapvpwrvgnd_1
X_11336_ clknet_leaf_102_clk _00025_ VGND VGND VPWR VPWR mem_wordsize\[1\] sky130_fd_sc_hd__dfxtp_4
XFILLER_4_530 VGND VGND VPWR VPWR sky130_fd_sc_hd__fill_2
XFILLER_153_586 VGND VGND VPWR VPWR sky130_fd_sc_hd__fill_2
XFILLER_98_106 VGND VGND VPWR VPWR sky130_fd_sc_hd__decap_4
X_11267_ clknet_leaf_39_clk _01314_ VGND VGND VPWR VPWR cpuregs\[22\]\[28\] sky130_fd_sc_hd__dfxtp_1
XFILLER_98_139 VGND VGND VPWR VPWR sky130_fd_sc_hd__fill_1
X_10218_ clknet_leaf_67_clk _00348_ VGND VGND VPWR VPWR cpuregs\[14\]\[24\] sky130_fd_sc_hd__dfxtp_1
XFILLER_121_461 VGND VGND VPWR VPWR sky130_fd_sc_hd__decap_4
X_11198_ clknet_leaf_51_clk _01245_ VGND VGND VPWR VPWR cpuregs\[29\]\[23\] sky130_fd_sc_hd__dfxtp_1
X_10149_ clknet_leaf_72_clk _00279_ VGND VGND VPWR VPWR cpuregs\[21\]\[19\] sky130_fd_sc_hd__dfxtp_1
XFILLER_95_835 VGND VGND VPWR VPWR sky130_fd_sc_hd__decap_4
XFILLER_67_559 VGND VGND VPWR VPWR sky130_fd_sc_hd__fill_1
XTAP_TAPCELL_ROW_124_2317 VGND VPWR sky130_fd_sc_hd__tapvpwrvgnd_1
XFILLER_48_795 VGND VGND VPWR VPWR sky130_fd_sc_hd__decap_4
XFILLER_35_401 VGND VGND VPWR VPWR sky130_fd_sc_hd__fill_2
XFILLER_63_765 VGND VGND VPWR VPWR sky130_fd_sc_hd__fill_1
XFILLER_63_743 VGND VGND VPWR VPWR sky130_fd_sc_hd__decap_8
XTAP_TAPCELL_ROW_18_621 VGND VPWR sky130_fd_sc_hd__tapvpwrvgnd_1
X_05690_ _02139_ _02238_ _02266_ _02268_ VGND VGND VPWR VPWR alu_out\[4\] sky130_fd_sc_hd__a211o_1
XFILLER_62_253 VPWR VGND VPWR VGND sky130_ef_sc_hd__decap_12
XFILLER_22_106 VGND VGND VPWR VPWR sky130_fd_sc_hd__decap_3
XFILLER_90_595 VPWR VGND VPWR VGND sky130_ef_sc_hd__decap_12
XFILLER_62_297 VGND VGND VPWR VPWR sky130_fd_sc_hd__decap_8
X_07360_ _02630_ cpuregs\[9\]\[11\] _03563_ VGND VGND VPWR VPWR _00303_ sky130_fd_sc_hd__mux2_1
XTAP_TAPCELL_ROW_44_1032 VGND VPWR sky130_fd_sc_hd__tapvpwrvgnd_1
XTAP_TAPCELL_ROW_102_1969 VGND VPWR sky130_fd_sc_hd__tapvpwrvgnd_1
XTAP_TAPCELL_ROW_102_1958 VGND VPWR sky130_fd_sc_hd__tapvpwrvgnd_1
X_06311_ _01622_ _02747_ _02748_ _02721_ _02746_ VGND VGND VPWR VPWR _02749_ sky130_fd_sc_hd__a32o_1
XTAP_TAPCELL_ROW_44_1043 VGND VPWR sky130_fd_sc_hd__tapvpwrvgnd_1
XFILLER_148_325 VGND VGND VPWR VPWR sky130_fd_sc_hd__decap_6
XTAP_TAPCELL_ROW_139_2560 VGND VPWR sky130_fd_sc_hd__tapvpwrvgnd_1
X_09030_ cpuregs\[16\]\[30\] cpuregs\[17\]\[30\] cpuregs\[18\]\[30\] cpuregs\[19\]\[30\]
+ net277 net271 VGND VGND VPWR VPWR _04702_ sky130_fd_sc_hd__mux4_1
X_07291_ cpuregs\[28\]\[9\] _02621_ net249 VGND VGND VPWR VPWR _00237_ sky130_fd_sc_hd__mux2_1
XFILLER_31_673 VGND VGND VPWR VPWR sky130_fd_sc_hd__fill_2
X_06242_ _02685_ _02686_ VGND VGND VPWR VPWR _02687_ sky130_fd_sc_hd__nor2_1
XTAP_TAPCELL_ROW_152_2760 VGND VPWR sky130_fd_sc_hd__tapvpwrvgnd_1
X_06173_ reg_out\[12\] alu_out_q\[12\] net592 VGND VGND VPWR VPWR _02631_ sky130_fd_sc_hd__mux2_1
XTAP_TAPCELL_ROW_152_2771 VGND VPWR sky130_fd_sc_hd__tapvpwrvgnd_1
X_05124_ count_instr\[37\] instr_rdinstrh count_cycle\[5\] net257 _01733_ VGND VGND
+ VPWR VPWR _01734_ sky130_fd_sc_hd__a221o_1
XFILLER_7_93 VPWR VGND VPWR VGND sky130_ef_sc_hd__decap_12
XFILLER_131_214 VGND VGND VPWR VPWR sky130_fd_sc_hd__decap_8
XFILLER_104_428 VGND VGND VPWR VPWR sky130_fd_sc_hd__fill_1
XFILLER_104_417 VGND VGND VPWR VPWR sky130_fd_sc_hd__decap_3
X_09932_ clknet_leaf_33_clk _00067_ VGND VGND VPWR VPWR cpuregs\[11\]\[30\] sky130_fd_sc_hd__dfxtp_1
X_05055_ net171 mem_wordsize\[1\] _01670_ VGND VGND VPWR VPWR _01671_ sky130_fd_sc_hd__and3_1
XFILLER_100_601 VGND VGND VPWR VPWR sky130_fd_sc_hd__fill_2
XFILLER_97_161 VGND VGND VPWR VPWR sky130_fd_sc_hd__decap_6
XFILLER_86_813 VGND VGND VPWR VPWR sky130_fd_sc_hd__decap_8
XFILLER_85_301 VGND VGND VPWR VPWR sky130_fd_sc_hd__fill_2
X_09863_ decoded_imm_j\[16\] _01110_ _02513_ VGND VGND VPWR VPWR _00904_ sky130_fd_sc_hd__mux2_1
XFILLER_133_27 VPWR VGND VPWR VGND sky130_ef_sc_hd__decap_12
XFILLER_112_494 VGND VGND VPWR VPWR sky130_fd_sc_hd__decap_8
XFILLER_112_472 VGND VGND VPWR VPWR sky130_fd_sc_hd__fill_1
X_08814_ cpuregs\[12\]\[18\] cpuregs\[13\]\[18\] cpuregs\[14\]\[18\] cpuregs\[15\]\[18\]
+ net276 net272 VGND VGND VPWR VPWR _04498_ sky130_fd_sc_hd__mux4_1
XFILLER_85_312 VGND VGND VPWR VPWR sky130_fd_sc_hd__decap_3
X_09794_ _02588_ cpuregs\[8\]\[1\] _04875_ VGND VGND VPWR VPWR _01447_ sky130_fd_sc_hd__mux2_1
X_08745_ _04424_ _04425_ _01558_ VGND VGND VPWR VPWR _04433_ sky130_fd_sc_hd__mux2_1
X_05957_ net227 _01665_ _02481_ VGND VGND VPWR VPWR net121 sky130_fd_sc_hd__a21o_1
X_05888_ _02064_ _02438_ _02443_ VGND VGND VPWR VPWR alu_out\[27\] sky130_fd_sc_hd__o21ai_1
X_08676_ net269 _04366_ _01559_ VGND VGND VPWR VPWR _04368_ sky130_fd_sc_hd__a21o_1
XFILLER_54_732 VPWR VGND VPWR VGND sky130_ef_sc_hd__decap_12
XTAP_TAPCELL_ROW_37_930 VGND VPWR sky130_fd_sc_hd__tapvpwrvgnd_1
XFILLER_42_905 VGND VGND VPWR VPWR sky130_fd_sc_hd__decap_3
X_07627_ _02630_ cpuregs\[17\]\[11\] _03574_ VGND VGND VPWR VPWR _00559_ sky130_fd_sc_hd__mux2_1
XFILLER_26_489 VPWR VGND VPWR VGND sky130_ef_sc_hd__decap_12
X_07558_ cpuregs\[25\]\[9\] _02621_ _03571_ VGND VGND VPWR VPWR _00493_ sky130_fd_sc_hd__mux2_1
X_06509_ _01579_ _02939_ VGND VGND VPWR VPWR _02940_ sky130_fd_sc_hd__or2_1
XFILLER_22_651 VGND VGND VPWR VPWR sky130_fd_sc_hd__fill_1
XFILLER_10_813 VPWR VGND VPWR VGND sky130_ef_sc_hd__decap_12
X_07489_ cpuregs\[26\]\[7\] _02612_ _03568_ VGND VGND VPWR VPWR _00427_ sky130_fd_sc_hd__mux2_1
X_09228_ cpuregs\[1\]\[7\] _02612_ net244 VGND VGND VPWR VPWR _00925_ sky130_fd_sc_hd__mux2_1
XFILLER_148_881 VPWR VGND VPWR VGND sky130_ef_sc_hd__decap_12
X_09159_ mem_rdata_q\[27\] mem_rdata_q\[26\] mem_rdata_q\[25\] mem_rdata_q\[24\] VGND
+ VGND VPWR VPWR _04777_ sky130_fd_sc_hd__or4_1
XFILLER_5_305 VPWR VGND VPWR VGND sky130_ef_sc_hd__decap_12
XTAP_TAPCELL_ROW_75_1526 VGND VPWR sky130_fd_sc_hd__tapvpwrvgnd_1
XFILLER_5_349 VPWR VGND VPWR VGND sky130_ef_sc_hd__decap_12
XFILLER_150_501 VPWR VGND VPWR VGND sky130_ef_sc_hd__decap_12
XFILLER_123_715 VGND VGND VPWR VPWR sky130_fd_sc_hd__decap_3
XFILLER_101_3 VGND VGND VPWR VPWR sky130_fd_sc_hd__decap_3
XTAP_TAPCELL_ROW_75_1537 VGND VPWR sky130_fd_sc_hd__tapvpwrvgnd_1
X_11121_ clknet_leaf_14_clk _01168_ VGND VGND VPWR VPWR cpuregs\[31\]\[10\] sky130_fd_sc_hd__dfxtp_1
XPHY_EDGE_ROW_2_Left_156 VGND VGND VPWR VPWR sky130_fd_sc_hd__decap_3
XFILLER_150_589 VPWR VGND VPWR VGND sky130_ef_sc_hd__decap_12
XFILLER_122_269 VGND VGND VPWR VPWR sky130_fd_sc_hd__decap_4
XFILLER_103_461 VGND VGND VPWR VPWR sky130_fd_sc_hd__decap_6
XFILLER_89_673 VPWR VGND VPWR VGND sky130_ef_sc_hd__decap_12
X_11052_ clknet_leaf_87_clk _01109_ VGND VGND VPWR VPWR mem_rdata_q\[15\] sky130_fd_sc_hd__dfxtp_1
XFILLER_107_94 VGND VGND VPWR VPWR sky130_fd_sc_hd__fill_2
XFILLER_88_172 VGND VGND VPWR VPWR sky130_fd_sc_hd__decap_3
X_10003_ clknet_leaf_120_clk _00133_ VGND VGND VPWR VPWR cpuregs\[30\]\[1\] sky130_fd_sc_hd__dfxtp_1
XFILLER_92_805 VGND VGND VPWR VPWR sky130_fd_sc_hd__decap_6
XTAP_TAPCELL_ROW_106_2025 VGND VPWR sky130_fd_sc_hd__tapvpwrvgnd_1
XFILLER_92_838 VPWR VGND VPWR VGND sky130_ef_sc_hd__decap_12
XTAP_TAPCELL_ROW_4_393 VGND VPWR sky130_fd_sc_hd__tapvpwrvgnd_1
XFILLER_36_209 VGND VGND VPWR VPWR sky130_fd_sc_hd__decap_4
XFILLER_123_93 VGND VGND VPWR VPWR sky130_fd_sc_hd__decap_8
XFILLER_83_53 VGND VGND VPWR VPWR sky130_fd_sc_hd__decap_3
XFILLER_17_434 VGND VGND VPWR VPWR sky130_fd_sc_hd__decap_4
X_10905_ clknet_leaf_7_clk _00967_ VGND VGND VPWR VPWR net137 sky130_fd_sc_hd__dfxtp_1
XFILLER_60_724 VGND VGND VPWR VPWR sky130_fd_sc_hd__decap_6
XFILLER_72_584 VGND VGND VPWR VPWR sky130_fd_sc_hd__decap_4
X_10836_ clknet_leaf_111_clk _00901_ VGND VGND VPWR VPWR decoded_rd\[3\] sky130_fd_sc_hd__dfxtp_1
X_10767_ clknet_leaf_91_clk alu_out\[20\] VGND VGND VPWR VPWR alu_out_q\[20\] sky130_fd_sc_hd__dfxtp_1
XFILLER_8_121 VPWR VGND VPWR VGND sky130_ef_sc_hd__decap_12
XFILLER_12_161 VGND VGND VPWR VPWR sky130_fd_sc_hd__decap_3
X_10698_ clknet_leaf_69_clk _00796_ VGND VGND VPWR VPWR net51 sky130_fd_sc_hd__dfxtp_1
XFILLER_145_317 VPWR VGND VPWR VGND sky130_ef_sc_hd__decap_12
XTAP_TAPCELL_ROW_117_2198 VGND VPWR sky130_fd_sc_hd__tapvpwrvgnd_1
XFILLER_153_350 VGND VGND VPWR VPWR sky130_fd_sc_hd__decap_3
XFILLER_113_203 VGND VGND VPWR VPWR sky130_fd_sc_hd__decap_4
XFILLER_99_404 VPWR VGND VPWR VGND sky130_ef_sc_hd__decap_12
XFILLER_99_459 VGND VGND VPWR VPWR sky130_fd_sc_hd__decap_4
X_11319_ clknet_leaf_22_clk _01366_ VGND VGND VPWR VPWR cpuregs\[5\]\[16\] sky130_fd_sc_hd__dfxtp_1
XFILLER_86_109 VGND VGND VPWR VPWR sky130_fd_sc_hd__decap_6
X_06860_ _01641_ _03194_ _03275_ _03277_ VGND VGND VPWR VPWR _03278_ sky130_fd_sc_hd__a31o_1
XFILLER_68_846 VGND VGND VPWR VPWR sky130_fd_sc_hd__decap_4
X_05811_ _02102_ _02373_ VGND VGND VPWR VPWR _02375_ sky130_fd_sc_hd__or2_1
XFILLER_83_805 VPWR VGND VPWR VGND sky130_ef_sc_hd__decap_12
XFILLER_103_19 VPWR VGND VPWR VGND sky130_ef_sc_hd__decap_12
X_06791_ _02714_ _03193_ _03196_ _03211_ net237 VGND VGND VPWR VPWR _03212_ sky130_fd_sc_hd__o311a_1
XFILLER_36_710 VGND VGND VPWR VPWR sky130_fd_sc_hd__decap_6
XFILLER_94_197 VGND VGND VPWR VPWR sky130_fd_sc_hd__decap_8
X_05742_ _02120_ _02124_ VGND VGND VPWR VPWR _02313_ sky130_fd_sc_hd__nor2_1
X_08530_ cpuregs\[28\]\[0\] cpuregs\[29\]\[0\] cpuregs\[30\]\[0\] cpuregs\[31\]\[0\]
+ net279 _00008_ VGND VGND VPWR VPWR _04232_ sky130_fd_sc_hd__mux4_1
XFILLER_35_220 VGND VGND VPWR VPWR sky130_fd_sc_hd__decap_4
X_08461_ _01578_ _04197_ net258 VGND VGND VPWR VPWR _04198_ sky130_fd_sc_hd__o21ai_1
X_05673_ _02167_ _02253_ VGND VGND VPWR VPWR _02254_ sky130_fd_sc_hd__xor2_1
XFILLER_24_905 VGND VGND VPWR VPWR sky130_fd_sc_hd__decap_3
X_07412_ cpuregs\[14\]\[30\] _02709_ net247 VGND VGND VPWR VPWR _00354_ sky130_fd_sc_hd__mux2_1
X_08392_ count_cycle\[47\] _04139_ count_cycle\[49\] count_cycle\[48\] VGND VGND VPWR
+ VPWR _04144_ sky130_fd_sc_hd__and4_1
XFILLER_148_133 VGND VGND VPWR VPWR sky130_fd_sc_hd__decap_6
XTAP_TAPCELL_ROW_137_2519 VGND VPWR sky130_fd_sc_hd__tapvpwrvgnd_1
X_07343_ cpuregs\[21\]\[27\] _02696_ net248 VGND VGND VPWR VPWR _00287_ sky130_fd_sc_hd__mux2_1
XFILLER_10_109 VPWR VGND VPWR VGND sky130_ef_sc_hd__decap_12
XFILLER_31_470 VGND VGND VPWR VPWR sky130_fd_sc_hd__decap_8
XFILLER_149_689 VGND VGND VPWR VPWR sky130_fd_sc_hd__fill_2
X_07274_ cpuregs\[2\]\[25\] _02688_ net250 VGND VGND VPWR VPWR _00221_ sky130_fd_sc_hd__mux2_1
XFILLER_12_27 VGND VGND VPWR VPWR sky130_fd_sc_hd__fill_1
XFILLER_148_177 VPWR VGND VPWR VGND sky130_ef_sc_hd__decap_12
XFILLER_128_27 VGND VGND VPWR VPWR sky130_fd_sc_hd__fill_1
X_06225_ reg_pc\[22\] _02668_ VGND VGND VPWR VPWR _02673_ sky130_fd_sc_hd__and2_1
X_09013_ cpuregs\[0\]\[29\] cpuregs\[1\]\[29\] cpuregs\[2\]\[29\] cpuregs\[3\]\[29\]
+ net275 net271 VGND VGND VPWR VPWR _04686_ sky130_fd_sc_hd__mux4_1
XFILLER_3_809 VPWR VGND VPWR VGND sky130_ef_sc_hd__decap_12
XFILLER_145_895 VGND VGND VPWR VPWR sky130_fd_sc_hd__fill_1
X_06156_ reg_out\[9\] alu_out_q\[9\] net590 VGND VGND VPWR VPWR _02617_ sky130_fd_sc_hd__mux2_1
XTAP_TAPCELL_ROW_57_1245 VGND VPWR sky130_fd_sc_hd__tapvpwrvgnd_1
XFILLER_144_394 VGND VGND VPWR VPWR sky130_fd_sc_hd__fill_1
XFILLER_144_15 VPWR VGND VPWR VGND sky130_ef_sc_hd__decap_12
XFILLER_132_545 VGND VGND VPWR VPWR sky130_fd_sc_hd__decap_6
X_06087_ _01661_ _02539_ _02557_ _02558_ VGND VGND VPWR VPWR _00005_ sky130_fd_sc_hd__o22a_1
X_05107_ _01703_ _01705_ _01704_ VGND VGND VPWR VPWR _01718_ sky130_fd_sc_hd__a21bo_1
XFILLER_132_589 VGND VGND VPWR VPWR sky130_fd_sc_hd__fill_2
XFILLER_77_109 VGND VGND VPWR VPWR sky130_fd_sc_hd__decap_3
X_09915_ clknet_leaf_10_clk _00050_ VGND VGND VPWR VPWR cpuregs\[11\]\[13\] sky130_fd_sc_hd__dfxtp_1
X_05038_ _01612_ _01635_ _01648_ _01649_ _01658_ VGND VGND VPWR VPWR _00020_ sky130_fd_sc_hd__a32o_1
X_09846_ _02665_ cpuregs\[10\]\[20\] _04876_ VGND VGND VPWR VPWR _01530_ sky130_fd_sc_hd__mux2_1
XTAP_TAPCELL_ROW_70_1456 VGND VPWR sky130_fd_sc_hd__tapvpwrvgnd_1
XTAP_TAPCELL_ROW_70_1445 VGND VPWR sky130_fd_sc_hd__tapvpwrvgnd_1
XFILLER_58_323 VPWR VGND VPWR VGND sky130_ef_sc_hd__decap_12
XFILLER_86_643 VGND VGND VPWR VPWR sky130_fd_sc_hd__fill_1
X_09777_ _02654_ cpuregs\[7\]\[17\] _04874_ VGND VGND VPWR VPWR _01431_ sky130_fd_sc_hd__mux2_1
X_06989_ _03399_ _03400_ VGND VGND VPWR VPWR _03402_ sky130_fd_sc_hd__xor2_1
XFILLER_85_164 VGND VGND VPWR VPWR sky130_fd_sc_hd__decap_4
XFILLER_37_57 VPWR VGND VPWR VGND sky130_ef_sc_hd__decap_12
X_08728_ _04406_ _04407_ _01558_ VGND VGND VPWR VPWR _04417_ sky130_fd_sc_hd__mux2_1
XFILLER_73_337 VGND VGND VPWR VPWR sky130_fd_sc_hd__decap_4
XTAP_TAPCELL_ROW_1_341 VGND VPWR sky130_fd_sc_hd__tapvpwrvgnd_1
XTAP_TAPCELL_ROW_1_352 VGND VPWR sky130_fd_sc_hd__tapvpwrvgnd_1
X_08659_ decoded_imm\[9\] _01654_ _01586_ VGND VGND VPWR VPWR _04352_ sky130_fd_sc_hd__a21o_1
XFILLER_26_242 VGND VGND VPWR VPWR sky130_fd_sc_hd__decap_8
XFILLER_41_201 VPWR VGND VPWR VGND sky130_ef_sc_hd__decap_12
XFILLER_149_3 VPWR VGND VPWR VGND sky130_ef_sc_hd__decap_12
XFILLER_41_234 VGND VGND VPWR VPWR sky130_fd_sc_hd__decap_4
X_10621_ clknet_leaf_105_clk _00751_ VGND VGND VPWR VPWR count_cycle\[44\] sky130_fd_sc_hd__dfxtp_1
X_10552_ clknet_leaf_131_clk _00682_ VGND VGND VPWR VPWR reg_next_pc\[7\] sky130_fd_sc_hd__dfxtp_1
XTAP_TAPCELL_ROW_40_969 VGND VPWR sky130_fd_sc_hd__tapvpwrvgnd_1
XFILLER_6_625 VPWR VGND VPWR VGND sky130_ef_sc_hd__decap_12
XFILLER_5_113 VPWR VGND VPWR VGND sky130_ef_sc_hd__decap_12
X_10483_ clknet_leaf_84_clk _00613_ VGND VGND VPWR VPWR count_instr\[32\] sky130_fd_sc_hd__dfxtp_1
XFILLER_151_821 VPWR VGND VPWR VGND sky130_ef_sc_hd__decap_12
XFILLER_142_309 VGND VGND VPWR VPWR sky130_fd_sc_hd__decap_4
XFILLER_135_372 VPWR VGND VPWR VGND sky130_ef_sc_hd__decap_12
XFILLER_151_865 VPWR VGND VPWR VGND sky130_ef_sc_hd__decap_12
XFILLER_111_729 VPWR VGND VPWR VGND sky130_ef_sc_hd__decap_12
XFILLER_96_407 VGND VGND VPWR VPWR sky130_fd_sc_hd__fill_2
XTAP_TAPCELL_ROW_9_474 VGND VPWR sky130_fd_sc_hd__tapvpwrvgnd_1
X_11104_ clknet_leaf_101_clk _00017_ VGND VGND VPWR VPWR cpu_state\[0\] sky130_fd_sc_hd__dfxtp_1
X_11035_ clknet_leaf_87_clk _00035_ VGND VGND VPWR VPWR _00015_ sky130_fd_sc_hd__dfxtp_4
XFILLER_89_492 VGND VGND VPWR VPWR sky130_fd_sc_hd__decap_4
XFILLER_77_610 VGND VGND VPWR VPWR sky130_fd_sc_hd__decap_6
XFILLER_77_643 VPWR VGND VPWR VGND sky130_ef_sc_hd__decap_12
XFILLER_65_805 VGND VGND VPWR VPWR sky130_fd_sc_hd__fill_1
XFILLER_94_41 VGND VGND VPWR VPWR sky130_fd_sc_hd__decap_8
XTAP_TAPCELL_ROW_88_1739 VGND VPWR sky130_fd_sc_hd__tapvpwrvgnd_1
XFILLER_94_85 VGND VGND VPWR VPWR sky130_fd_sc_hd__decap_8
XFILLER_76_197 VGND VGND VPWR VPWR sky130_fd_sc_hd__decap_4
XFILLER_72_381 VGND VGND VPWR VPWR sky130_fd_sc_hd__fill_1
XFILLER_60_521 VGND VGND VPWR VPWR sky130_fd_sc_hd__decap_4
XTAP_TAPCELL_ROW_28_782 VGND VPWR sky130_fd_sc_hd__tapvpwrvgnd_1
XFILLER_32_212 VPWR VGND VPWR VGND sky130_ef_sc_hd__decap_12
XFILLER_45_595 VGND VGND VPWR VPWR sky130_fd_sc_hd__fill_2
X_10819_ clknet_leaf_103_clk _00884_ VGND VGND VPWR VPWR instr_fence sky130_fd_sc_hd__dfxtp_1
XTAP_TAPCELL_ROW_119_2238 VGND VPWR sky130_fd_sc_hd__tapvpwrvgnd_1
XFILLER_9_430 VGND VGND VPWR VPWR sky130_fd_sc_hd__decap_6
XFILLER_41_790 VGND VGND VPWR VPWR sky130_fd_sc_hd__decap_8
XPHY_EDGE_ROW_65_Left_219 VGND VGND VPWR VPWR sky130_fd_sc_hd__decap_3
X_06010_ net190 _02508_ _01582_ VGND VGND VPWR VPWR net83 sky130_fd_sc_hd__mux2_1
XTAP_TAPCELL_ROW_132_2438 VGND VPWR sky130_fd_sc_hd__tapvpwrvgnd_1
Xoutput215 net215 VGND VGND VPWR VPWR pcpi_rs2[20] sky130_fd_sc_hd__buf_2
XFILLER_145_169 VPWR VGND VPWR VGND sky130_ef_sc_hd__decap_12
XTAP_TAPCELL_ROW_132_2449 VGND VPWR sky130_fd_sc_hd__tapvpwrvgnd_1
XFILLER_127_895 VGND VGND VPWR VPWR sky130_fd_sc_hd__fill_1
XFILLER_114_501 VGND VGND VPWR VPWR sky130_fd_sc_hd__fill_1
Xoutput226 net226 VGND VGND VPWR VPWR pcpi_rs2[30] sky130_fd_sc_hd__buf_2
Xoutput204 net204 VGND VGND VPWR VPWR pcpi_rs2[10] sky130_fd_sc_hd__buf_2
XFILLER_114_578 VGND VGND VPWR VPWR sky130_fd_sc_hd__decap_4
X_07961_ _03694_ _03695_ _03769_ VGND VGND VPWR VPWR _03786_ sky130_fd_sc_hd__and3_1
XFILLER_114_589 VPWR VGND VPWR VGND sky130_ef_sc_hd__decap_12
X_06912_ _02744_ _03245_ _03327_ _02714_ VGND VGND VPWR VPWR _03328_ sky130_fd_sc_hd__a31o_1
XFILLER_4_83 VGND VGND VPWR VPWR sky130_fd_sc_hd__fill_1
X_09700_ _02607_ cpuregs\[5\]\[6\] _04872_ VGND VGND VPWR VPWR _01356_ sky130_fd_sc_hd__mux2_1
XFILLER_114_29 VPWR VGND VPWR VGND sky130_ef_sc_hd__decap_12
XPHY_EDGE_ROW_74_Left_228 VGND VGND VPWR VPWR sky130_fd_sc_hd__decap_3
XFILLER_68_643 VGND VGND VPWR VPWR sky130_fd_sc_hd__fill_1
XTAP_TAPCELL_ROW_52_1164 VGND VPWR sky130_fd_sc_hd__tapvpwrvgnd_1
X_07892_ _01628_ _03722_ _03723_ _01624_ reg_next_pc\[1\] VGND VGND VPWR VPWR _00676_
+ sky130_fd_sc_hd__a32o_1
XTAP_TAPCELL_ROW_147_2681 VGND VPWR sky130_fd_sc_hd__tapvpwrvgnd_1
XFILLER_110_784 VPWR VGND VPWR VGND sky130_ef_sc_hd__decap_12
X_06843_ reg_pc\[19\] _02751_ _03261_ _02715_ VGND VGND VPWR VPWR _03262_ sky130_fd_sc_hd__a211o_1
XFILLER_95_484 VGND VGND VPWR VPWR sky130_fd_sc_hd__fill_1
XFILLER_83_602 VPWR VGND VPWR VGND sky130_ef_sc_hd__decap_12
X_09631_ _02598_ cpuregs\[22\]\[4\] _04869_ VGND VGND VPWR VPWR _01290_ sky130_fd_sc_hd__mux2_1
X_06774_ net175 _02721_ _02744_ VGND VGND VPWR VPWR _03195_ sky130_fd_sc_hd__o21a_1
X_09562_ cpuregs\[29\]\[1\] _02588_ net239 VGND VGND VPWR VPWR _01223_ sky130_fd_sc_hd__mux2_1
X_05725_ _02137_ _02297_ _02242_ VGND VGND VPWR VPWR _02299_ sky130_fd_sc_hd__a21oi_1
X_08513_ is_beq_bne_blt_bge_bltu_bgeu _02236_ _02717_ _04217_ _04216_ VGND VGND VPWR
+ VPWR _00803_ sky130_fd_sc_hd__a41o_1
X_09493_ cpuregs\[24\]\[31\] _02712_ net242 VGND VGND VPWR VPWR _01157_ sky130_fd_sc_hd__mux2_1
XFILLER_51_521 VPWR VGND VPWR VGND sky130_ef_sc_hd__decap_12
X_05656_ instr_xor instr_xori VGND VGND VPWR VPWR _02239_ sky130_fd_sc_hd__nor2_4
X_08444_ net258 _04176_ _04178_ _04180_ VGND VGND VPWR VPWR _04181_ sky130_fd_sc_hd__a22o_1
X_08375_ _04133_ net34 _04132_ VGND VGND VPWR VPWR _00749_ sky130_fd_sc_hd__and3b_1
XFILLER_51_587 VGND VGND VPWR VPWR sky130_fd_sc_hd__decap_3
XFILLER_23_15 VPWR VGND VPWR VGND sky130_ef_sc_hd__decap_12
X_05587_ _02168_ _02169_ VGND VGND VPWR VPWR _02170_ sky130_fd_sc_hd__nor2_1
XFILLER_139_15 VPWR VGND VPWR VGND sky130_ef_sc_hd__decap_12
XPHY_EDGE_ROW_83_Left_237 VGND VGND VPWR VPWR sky130_fd_sc_hd__decap_3
X_07326_ cpuregs\[21\]\[10\] _02624_ net248 VGND VGND VPWR VPWR _00270_ sky130_fd_sc_hd__mux2_1
XFILLER_137_626 VPWR VGND VPWR VGND sky130_ef_sc_hd__decap_12
XFILLER_137_615 VGND VGND VPWR VPWR sky130_fd_sc_hd__fill_1
XFILLER_109_317 VGND VGND VPWR VPWR sky130_fd_sc_hd__fill_2
X_07257_ cpuregs\[2\]\[8\] _02616_ net250 VGND VGND VPWR VPWR _00204_ sky130_fd_sc_hd__mux2_1
XFILLER_133_821 VPWR VGND VPWR VGND sky130_ef_sc_hd__decap_12
XFILLER_124_309 VGND VGND VPWR VPWR sky130_fd_sc_hd__decap_4
X_06208_ reg_pc\[18\] _02652_ reg_pc\[19\] VGND VGND VPWR VPWR _02659_ sky130_fd_sc_hd__a21oi_1
XFILLER_3_617 VPWR VGND VPWR VGND sky130_ef_sc_hd__decap_12
X_07188_ cpuregs\[30\]\[6\] _02607_ net252 VGND VGND VPWR VPWR _00138_ sky130_fd_sc_hd__mux2_1
XFILLER_105_523 VGND VGND VPWR VPWR sky130_fd_sc_hd__fill_1
X_06139_ _02603_ cpuregs\[11\]\[5\] _02582_ VGND VGND VPWR VPWR _00042_ sky130_fd_sc_hd__mux2_1
XFILLER_133_865 VPWR VGND VPWR VGND sky130_ef_sc_hd__decap_12
XFILLER_120_504 VGND VGND VPWR VPWR sky130_fd_sc_hd__decap_8
XPHY_EDGE_ROW_92_Left_246 VGND VGND VPWR VPWR sky130_fd_sc_hd__decap_3
XTAP_TAPCELL_ROW_6_433 VGND VPWR sky130_fd_sc_hd__tapvpwrvgnd_1
XTAP_TAPCELL_ROW_6_422 VGND VPWR sky130_fd_sc_hd__tapvpwrvgnd_1
XFILLER_101_762 VGND VGND VPWR VPWR sky130_fd_sc_hd__decap_8
XFILLER_86_462 VPWR VGND VPWR VGND sky130_ef_sc_hd__decap_12
X_09829_ _02593_ cpuregs\[10\]\[3\] _04876_ VGND VGND VPWR VPWR _01513_ sky130_fd_sc_hd__mux2_1
XFILLER_58_197 VGND VGND VPWR VPWR sky130_fd_sc_hd__decap_6
XFILLER_73_167 VGND VGND VPWR VPWR sky130_fd_sc_hd__fill_1
Xclkbuf_leaf_147_clk clknet_4_0_0_clk VGND VGND VPWR VPWR clknet_leaf_147_clk sky130_fd_sc_hd__clkbuf_8
XTAP_TAPCELL_ROW_83_1658 VGND VPWR sky130_fd_sc_hd__tapvpwrvgnd_1
XFILLER_14_223 VGND VGND VPWR VPWR sky130_fd_sc_hd__decap_8
XTAP_TAPCELL_ROW_25_730 VGND VPWR sky130_fd_sc_hd__tapvpwrvgnd_1
XFILLER_42_543 VGND VGND VPWR VPWR sky130_fd_sc_hd__fill_1
XFILLER_9_39 VPWR VGND VPWR VGND sky130_ef_sc_hd__decap_12
X_10604_ clknet_leaf_80_clk _00734_ VGND VGND VPWR VPWR count_cycle\[27\] sky130_fd_sc_hd__dfxtp_1
X_10535_ clknet_leaf_63_clk _00665_ VGND VGND VPWR VPWR reg_pc\[21\] sky130_fd_sc_hd__dfxtp_1
XFILLER_13_81 VGND VGND VPWR VPWR sky130_fd_sc_hd__decap_8
XTAP_TAPCELL_ROW_114_2157 VGND VPWR sky130_fd_sc_hd__tapvpwrvgnd_1
XFILLER_108_350 VPWR VGND VPWR VGND sky130_ef_sc_hd__decap_12
X_10466_ clknet_leaf_86_clk _00596_ VGND VGND VPWR VPWR count_instr\[15\] sky130_fd_sc_hd__dfxtp_1
XFILLER_50_9 VPWR VGND VPWR VGND sky130_ef_sc_hd__decap_12
XFILLER_142_139 VGND VGND VPWR VPWR sky130_fd_sc_hd__fill_1
XFILLER_151_662 VGND VGND VPWR VPWR sky130_fd_sc_hd__decap_8
XFILLER_151_651 VGND VGND VPWR VPWR sky130_fd_sc_hd__fill_2
XFILLER_97_727 VGND VGND VPWR VPWR sky130_fd_sc_hd__fill_1
X_10397_ clknet_leaf_148_clk _00527_ VGND VGND VPWR VPWR cpuregs\[20\]\[11\] sky130_fd_sc_hd__dfxtp_1
XFILLER_111_526 VGND VGND VPWR VPWR sky130_fd_sc_hd__decap_3
XFILLER_97_749 VPWR VGND VPWR VGND sky130_ef_sc_hd__decap_12
XFILLER_1_193 VPWR VGND VPWR VGND sky130_ef_sc_hd__decap_12
X_11018_ clknet_leaf_42_clk _01080_ VGND VGND VPWR VPWR cpuregs\[19\]\[18\] sky130_fd_sc_hd__dfxtp_1
XFILLER_92_421 VGND VGND VPWR VPWR sky130_fd_sc_hd__decap_6
XFILLER_37_337 VGND VGND VPWR VPWR sky130_fd_sc_hd__fill_2
XFILLER_53_819 VGND VGND VPWR VPWR sky130_fd_sc_hd__decap_4
XFILLER_46_893 VGND VGND VPWR VPWR sky130_fd_sc_hd__decap_8
XFILLER_18_584 VGND VGND VPWR VPWR sky130_fd_sc_hd__decap_4
Xclkbuf_leaf_138_clk clknet_4_3_0_clk VGND VGND VPWR VPWR clknet_leaf_138_clk sky130_fd_sc_hd__clkbuf_8
XFILLER_45_381 VGND VGND VPWR VPWR sky130_fd_sc_hd__fill_1
X_05510_ net184 net216 VGND VGND VPWR VPWR _02093_ sky130_fd_sc_hd__nor2_1
X_06490_ reg_pc\[6\] _02751_ _02921_ _02715_ VGND VGND VPWR VPWR _02922_ sky130_fd_sc_hd__a211o_1
X_05441_ _02024_ _02026_ VGND VGND VPWR VPWR _04899_ sky130_fd_sc_hd__or2_1
X_08160_ _03966_ _03967_ _03968_ VGND VGND VPWR VPWR _03970_ sky130_fd_sc_hd__or3_1
XFILLER_14_790 VPWR VGND VPWR VGND sky130_ef_sc_hd__decap_12
X_07111_ _03516_ _03517_ _01579_ VGND VGND VPWR VPWR _03520_ sky130_fd_sc_hd__mux2_1
X_05372_ net17 _01665_ _01856_ VGND VGND VPWR VPWR _01963_ sky130_fd_sc_hd__a21o_1
X_08091_ _03905_ _03906_ net34 VGND VGND VPWR VPWR _00692_ sky130_fd_sc_hd__o21a_1
XFILLER_106_309 VGND VGND VPWR VPWR sky130_fd_sc_hd__fill_2
X_07042_ _03448_ _03450_ _03451_ VGND VGND VPWR VPWR _03453_ sky130_fd_sc_hd__nand3_1
Xclkload52 clknet_leaf_29_clk VGND VGND VPWR VPWR clkload52/Y sky130_fd_sc_hd__inv_6
Xclkload41 clknet_leaf_18_clk VGND VGND VPWR VPWR clkload41/Y sky130_fd_sc_hd__clkinv_8
Xclkload30 clknet_leaf_139_clk VGND VGND VPWR VPWR clkload30/Y sky130_fd_sc_hd__bufinv_16
Xclkload74 clknet_leaf_46_clk VGND VGND VPWR VPWR clkload74/X sky130_fd_sc_hd__clkbuf_8
Xclkload63 clknet_leaf_41_clk VGND VGND VPWR VPWR clkload63/Y sky130_fd_sc_hd__inv_6
Xclkload85 clknet_leaf_125_clk VGND VGND VPWR VPWR clkload85/Y sky130_fd_sc_hd__inv_6
Xclkload96 clknet_leaf_112_clk VGND VGND VPWR VPWR clkload96/Y sky130_fd_sc_hd__clkinv_8
XTAP_TAPCELL_ROW_149_2710 VGND VPWR sky130_fd_sc_hd__tapvpwrvgnd_1
XFILLER_142_640 VGND VGND VPWR VPWR sky130_fd_sc_hd__decap_4
XFILLER_130_813 VPWR VGND VPWR VGND sky130_ef_sc_hd__decap_12
XFILLER_115_865 VPWR VGND VPWR VGND sky130_ef_sc_hd__decap_12
XFILLER_102_504 VGND VGND VPWR VPWR sky130_fd_sc_hd__fill_1
XTAP_TAPCELL_ROW_149_2721 VGND VPWR sky130_fd_sc_hd__tapvpwrvgnd_1
X_08993_ cpuregs\[28\]\[28\] cpuregs\[29\]\[28\] cpuregs\[30\]\[28\] cpuregs\[31\]\[28\]
+ net275 net271 VGND VGND VPWR VPWR _04667_ sky130_fd_sc_hd__mux4_1
XFILLER_125_39 VPWR VGND VPWR VGND sky130_ef_sc_hd__decap_12
XFILLER_87_248 VGND VGND VPWR VPWR sky130_fd_sc_hd__decap_6
X_07944_ instr_jal _03769_ _03770_ VGND VGND VPWR VPWR _03771_ sky130_fd_sc_hd__or3_1
X_07875_ _02689_ reg_next_pc\[26\] net596 VGND VGND VPWR VPWR _03713_ sky130_fd_sc_hd__mux2_2
XFILLER_18_15 VPWR VGND VPWR VGND sky130_ef_sc_hd__decap_12
XFILLER_29_838 VGND VGND VPWR VPWR sky130_fd_sc_hd__fill_2
X_09614_ _02665_ cpuregs\[3\]\[20\] _04868_ VGND VGND VPWR VPWR _01274_ sky130_fd_sc_hd__mux2_1
XFILLER_141_27 VPWR VGND VPWR VGND sky130_ef_sc_hd__decap_12
X_06826_ net180 _02721_ VGND VGND VPWR VPWR _03245_ sky130_fd_sc_hd__or2_1
XFILLER_95_270 VGND VGND VPWR VPWR sky130_fd_sc_hd__fill_2
XFILLER_55_101 VGND VGND VPWR VPWR sky130_fd_sc_hd__decap_8
XFILLER_56_668 VGND VGND VPWR VPWR sky130_fd_sc_hd__decap_8
XFILLER_44_808 VGND VGND VPWR VPWR sky130_fd_sc_hd__decap_4
X_09545_ cpuregs\[23\]\[17\] _02654_ _04866_ VGND VGND VPWR VPWR _01207_ sky130_fd_sc_hd__mux2_1
X_06757_ cpuregs\[8\]\[16\] cpuregs\[9\]\[16\] cpuregs\[10\]\[16\] cpuregs\[11\]\[16\]
+ net265 net260 VGND VGND VPWR VPWR _03179_ sky130_fd_sc_hd__mux4_1
Xclkbuf_leaf_129_clk clknet_4_9_0_clk VGND VGND VPWR VPWR clknet_leaf_129_clk sky130_fd_sc_hd__clkbuf_8
X_09476_ cpuregs\[24\]\[14\] _02641_ net242 VGND VGND VPWR VPWR _01140_ sky130_fd_sc_hd__mux2_1
X_06688_ net172 net180 _02721_ VGND VGND VPWR VPWR _03112_ sky130_fd_sc_hd__mux2_1
XFILLER_52_841 VGND VGND VPWR VPWR sky130_fd_sc_hd__fill_1
X_05708_ _02158_ _02240_ _02237_ VGND VGND VPWR VPWR _02284_ sky130_fd_sc_hd__a21o_1
X_08427_ count_cycle\[61\] _04163_ _04166_ VGND VGND VPWR VPWR _00768_ sky130_fd_sc_hd__o21a_1
X_05639_ _01565_ net218 _02219_ _02221_ VGND VGND VPWR VPWR _02222_ sky130_fd_sc_hd__o211a_1
XTAP_TAPCELL_ROW_65_1377 VGND VPWR sky130_fd_sc_hd__tapvpwrvgnd_1
XTAP_TAPCELL_ROW_65_1366 VGND VPWR sky130_fd_sc_hd__tapvpwrvgnd_1
XFILLER_51_373 VGND VGND VPWR VPWR sky130_fd_sc_hd__decap_4
X_08358_ count_cycle\[35\] count_cycle\[36\] net395 VGND VGND VPWR VPWR _04123_ sky130_fd_sc_hd__and3_1
Xclkload2 clknet_4_3_0_clk VGND VGND VPWR VPWR clkload2/Y sky130_fd_sc_hd__clkinvlp_4
X_07309_ cpuregs\[28\]\[27\] _02696_ net249 VGND VGND VPWR VPWR _00255_ sky130_fd_sc_hd__mux2_1
X_08289_ count_cycle\[10\] _04073_ count_cycle\[12\] count_cycle\[11\] VGND VGND VPWR
+ VPWR _04078_ sky130_fd_sc_hd__and4_1
XFILLER_109_169 VGND VGND VPWR VPWR sky130_fd_sc_hd__decap_6
X_10320_ clknet_leaf_24_clk _00450_ VGND VGND VPWR VPWR cpuregs\[26\]\[30\] sky130_fd_sc_hd__dfxtp_1
X_10251_ clknet_leaf_66_clk _00381_ VGND VGND VPWR VPWR cpuregs\[27\]\[25\] sky130_fd_sc_hd__dfxtp_1
XFILLER_124_139 VGND VGND VPWR VPWR sky130_fd_sc_hd__fill_1
XFILLER_117_180 VGND VGND VPWR VPWR sky130_fd_sc_hd__fill_1
XFILLER_105_331 VGND VGND VPWR VPWR sky130_fd_sc_hd__decap_4
XFILLER_3_447 VGND VGND VPWR VPWR sky130_fd_sc_hd__fill_1
X_10182_ clknet_leaf_76_clk _00312_ VGND VGND VPWR VPWR cpuregs\[9\]\[20\] sky130_fd_sc_hd__dfxtp_1
XFILLER_78_259 VGND VGND VPWR VPWR sky130_fd_sc_hd__fill_1
XFILLER_74_421 VGND VGND VPWR VPWR sky130_fd_sc_hd__decap_4
XFILLER_34_307 VGND VGND VPWR VPWR sky130_fd_sc_hd__fill_1
XFILLER_28_893 VPWR VGND VPWR VGND sky130_ef_sc_hd__decap_12
XPHY_EDGE_ROW_141_Right_141 VGND VGND VPWR VPWR sky130_fd_sc_hd__decap_3
XFILLER_43_841 VGND VGND VPWR VPWR sky130_fd_sc_hd__decap_6
XFILLER_43_863 VPWR VGND VPWR VGND sky130_ef_sc_hd__decap_12
XFILLER_91_86 VGND VGND VPWR VPWR sky130_fd_sc_hd__decap_3
XFILLER_15_598 VGND VGND VPWR VPWR sky130_fd_sc_hd__decap_8
XFILLER_128_412 VGND VGND VPWR VPWR sky130_fd_sc_hd__decap_8
XFILLER_144_905 VGND VGND VPWR VPWR sky130_fd_sc_hd__decap_4
XFILLER_7_742 VGND VGND VPWR VPWR sky130_fd_sc_hd__fill_1
XFILLER_10_281 VGND VGND VPWR VPWR sky130_fd_sc_hd__fill_1
X_10518_ clknet_leaf_130_clk _00648_ VGND VGND VPWR VPWR reg_pc\[4\] sky130_fd_sc_hd__dfxtp_1
XFILLER_7_797 VPWR VGND VPWR VGND sky130_ef_sc_hd__decap_12
X_11498_ clknet_leaf_109_clk _01542_ VGND VGND VPWR VPWR net134 sky130_fd_sc_hd__dfxtp_1
XFILLER_124_662 VPWR VGND VPWR VGND sky130_ef_sc_hd__decap_12
X_10449_ clknet_leaf_16_clk _00579_ VGND VGND VPWR VPWR cpuregs\[17\]\[31\] sky130_fd_sc_hd__dfxtp_1
XFILLER_151_481 VGND VGND VPWR VPWR sky130_fd_sc_hd__decap_3
XFILLER_112_813 VPWR VGND VPWR VGND sky130_ef_sc_hd__decap_12
XFILLER_111_345 VGND VGND VPWR VPWR sky130_fd_sc_hd__decap_6
X_05990_ net179 _02498_ _01582_ VGND VGND VPWR VPWR net73 sky130_fd_sc_hd__mux2_1
XFILLER_84_218 VGND VGND VPWR VPWR sky130_fd_sc_hd__fill_1
X_04941_ net234 VGND VGND VPWR VPWR _01574_ sky130_fd_sc_hd__inv_2
XFILLER_27_3 VPWR VGND VPWR VGND sky130_ef_sc_hd__decap_12
XTAP_TAPCELL_ROW_144_2640 VGND VPWR sky130_fd_sc_hd__tapvpwrvgnd_1
XTAP_TAPCELL_ROW_127_2359 VGND VPWR sky130_fd_sc_hd__tapvpwrvgnd_1
XFILLER_93_741 VGND VGND VPWR VPWR sky130_fd_sc_hd__decap_4
XFILLER_77_281 VPWR VGND VPWR VGND sky130_ef_sc_hd__decap_12
XPHY_EDGE_ROW_148_Left_302 VGND VGND VPWR VPWR sky130_fd_sc_hd__decap_3
XFILLER_93_763 VGND VGND VPWR VPWR sky130_fd_sc_hd__decap_4
XFILLER_93_752 VGND VGND VPWR VPWR sky130_fd_sc_hd__decap_6
XFILLER_65_454 VPWR VGND VPWR VGND sky130_ef_sc_hd__decap_12
X_07660_ count_instr\[3\] _03581_ net34 VGND VGND VPWR VPWR _03584_ sky130_fd_sc_hd__o21ai_1
XFILLER_1_51 VGND VGND VPWR VPWR sky130_fd_sc_hd__decap_4
XFILLER_93_785 VGND VGND VPWR VPWR sky130_fd_sc_hd__decap_6
X_06611_ net172 _02721_ _02958_ _01641_ VGND VGND VPWR VPWR _03038_ sky130_fd_sc_hd__o211a_1
XFILLER_53_638 VGND VGND VPWR VPWR sky130_fd_sc_hd__decap_3
X_07591_ cpuregs\[20\]\[8\] _02616_ net245 VGND VGND VPWR VPWR _00524_ sky130_fd_sc_hd__mux2_1
X_09330_ mem_rdata_q\[30\] _01589_ VGND VGND VPWR VPWR _04827_ sky130_fd_sc_hd__and2_1
X_06542_ _02963_ _02964_ _02968_ _02969_ _01579_ _00016_ VGND VGND VPWR VPWR _02972_
+ sky130_fd_sc_hd__mux4_1
XFILLER_61_671 VGND VGND VPWR VPWR sky130_fd_sc_hd__fill_1
X_09261_ _01546_ _01608_ net235 VGND VGND VPWR VPWR _04804_ sky130_fd_sc_hd__a21oi_1
X_08212_ _03575_ _04016_ _04017_ VGND VGND VPWR VPWR _04018_ sky130_fd_sc_hd__a21o_1
XTAP_TAPCELL_ROW_16_582 VGND VPWR sky130_fd_sc_hd__tapvpwrvgnd_1
XTAP_TAPCELL_ROW_16_593 VGND VPWR sky130_fd_sc_hd__tapvpwrvgnd_1
X_06473_ net200 _02720_ _02904_ _01641_ VGND VGND VPWR VPWR _02905_ sky130_fd_sc_hd__o211a_1
XTAP_TAPCELL_ROW_47_1085 VGND VPWR sky130_fd_sc_hd__tapvpwrvgnd_1
X_05424_ count_instr\[28\] instr_rdinstr count_cycle\[60\] instr_rdcycleh VGND VGND
+ VPWR VPWR _02011_ sky130_fd_sc_hd__a22o_1
X_09192_ decoded_imm_j\[14\] _01108_ _02513_ VGND VGND VPWR VPWR _00895_ sky130_fd_sc_hd__mux2_1
X_08143_ decoded_imm_j\[20\] _03709_ VGND VGND VPWR VPWR _03954_ sky130_fd_sc_hd__xnor2_2
X_05355_ _01945_ _01946_ VGND VGND VPWR VPWR _01947_ sky130_fd_sc_hd__xnor2_1
XTAP_TAPCELL_ROW_60_1285 VGND VPWR sky130_fd_sc_hd__tapvpwrvgnd_1
XFILLER_146_253 VPWR VGND VPWR VGND sky130_ef_sc_hd__decap_12
XFILLER_146_242 VGND VGND VPWR VPWR sky130_fd_sc_hd__decap_8
Xclkload130 clknet_leaf_86_clk VGND VGND VPWR VPWR clkload130/Y sky130_fd_sc_hd__inv_6
X_08074_ _03867_ _03881_ _03868_ VGND VGND VPWR VPWR _03890_ sky130_fd_sc_hd__or3b_1
XTAP_TAPCELL_ROW_60_1296 VGND VPWR sky130_fd_sc_hd__tapvpwrvgnd_1
X_07025_ cpuregs\[12\]\[26\] cpuregs\[13\]\[26\] cpuregs\[14\]\[26\] cpuregs\[15\]\[26\]
+ net266 net261 VGND VGND VPWR VPWR _03437_ sky130_fd_sc_hd__mux4_1
Xclkload141 clknet_leaf_91_clk VGND VGND VPWR VPWR clkload141/Y sky130_fd_sc_hd__clkinv_8
XFILLER_106_139 VGND VGND VPWR VPWR sky130_fd_sc_hd__fill_1
X_05286_ net256 _01882_ _01883_ net179 cpu_state\[4\] VGND VGND VPWR VPWR _01884_
+ sky130_fd_sc_hd__a32o_1
XFILLER_20_27 VGND VGND VPWR VPWR sky130_fd_sc_hd__fill_1
XFILLER_136_27 VGND VGND VPWR VPWR sky130_fd_sc_hd__fill_1
XFILLER_121_109 VGND VGND VPWR VPWR sky130_fd_sc_hd__decap_3
XFILLER_115_673 VPWR VGND VPWR VGND sky130_ef_sc_hd__decap_12
XFILLER_0_406 VGND VGND VPWR VPWR sky130_fd_sc_hd__decap_8
XFILLER_130_643 VGND VGND VPWR VPWR sky130_fd_sc_hd__fill_1
XFILLER_103_857 VPWR VGND VPWR VGND sky130_ef_sc_hd__decap_12
XFILLER_88_557 VPWR VGND VPWR VGND sky130_ef_sc_hd__decap_12
XFILLER_152_15 VPWR VGND VPWR VGND sky130_ef_sc_hd__decap_12
X_08976_ cpuregs\[8\]\[27\] cpuregs\[9\]\[27\] cpuregs\[10\]\[27\] cpuregs\[11\]\[27\]
+ net275 net271 VGND VGND VPWR VPWR _04651_ sky130_fd_sc_hd__mux4_1
XFILLER_56_421 VGND VGND VPWR VPWR sky130_fd_sc_hd__decap_8
X_07927_ _03753_ _03754_ instr_jal VGND VGND VPWR VPWR _03755_ sky130_fd_sc_hd__o21ai_1
X_07858_ reg_pc\[17\] _01624_ _01628_ _03704_ VGND VGND VPWR VPWR _00661_ sky130_fd_sc_hd__a22o_1
XTAP_TAPCELL_ROW_67_1406 VGND VPWR sky130_fd_sc_hd__tapvpwrvgnd_1
X_06809_ cpuregs\[8\]\[18\] cpuregs\[9\]\[18\] cpuregs\[10\]\[18\] cpuregs\[11\]\[18\]
+ net265 net260 VGND VGND VPWR VPWR _03229_ sky130_fd_sc_hd__mux4_1
X_07789_ _03665_ _03664_ VGND VGND VPWR VPWR _00631_ sky130_fd_sc_hd__nor2_1
XFILLER_44_649 VGND VGND VPWR VPWR sky130_fd_sc_hd__fill_1
XFILLER_25_841 VPWR VGND VPWR VGND sky130_ef_sc_hd__decap_12
X_09528_ cpuregs\[23\]\[0\] _02586_ _04866_ VGND VGND VPWR VPWR _01190_ sky130_fd_sc_hd__mux2_1
XFILLER_45_57 VGND VGND VPWR VPWR sky130_fd_sc_hd__fill_1
XTAP_TAPCELL_ROW_80_1617 VGND VPWR sky130_fd_sc_hd__tapvpwrvgnd_1
XTAP_TAPCELL_ROW_80_1606 VGND VPWR sky130_fd_sc_hd__tapvpwrvgnd_1
XFILLER_40_811 VGND VGND VPWR VPWR sky130_fd_sc_hd__fill_1
X_09459_ _02709_ cpuregs\[19\]\[30\] _04863_ VGND VGND VPWR VPWR _01092_ sky130_fd_sc_hd__mux2_1
XFILLER_52_682 VGND VGND VPWR VPWR sky130_fd_sc_hd__fill_1
XFILLER_51_181 VGND VGND VPWR VPWR sky130_fd_sc_hd__decap_6
XTAP_TAPCELL_ROW_35_891 VGND VPWR sky130_fd_sc_hd__tapvpwrvgnd_1
XFILLER_138_710 VGND VGND VPWR VPWR sky130_fd_sc_hd__decap_6
XFILLER_131_3 VPWR VGND VPWR VGND sky130_ef_sc_hd__decap_12
X_11421_ clknet_leaf_72_clk _01465_ VGND VGND VPWR VPWR cpuregs\[8\]\[19\] sky130_fd_sc_hd__dfxtp_1
XFILLER_153_713 VGND VGND VPWR VPWR sky130_fd_sc_hd__decap_4
XFILLER_126_905 VGND VGND VPWR VPWR sky130_fd_sc_hd__decap_4
X_11352_ clknet_leaf_28_clk _01396_ VGND VGND VPWR VPWR cpuregs\[6\]\[14\] sky130_fd_sc_hd__dfxtp_1
XFILLER_6_29 VPWR VGND VPWR VGND sky130_ef_sc_hd__decap_12
XFILLER_4_701 VPWR VGND VPWR VGND sky130_ef_sc_hd__decap_12
XFILLER_153_757 VGND VGND VPWR VPWR sky130_fd_sc_hd__decap_8
XFILLER_125_437 VGND VGND VPWR VPWR sky130_fd_sc_hd__decap_8
XTAP_TAPCELL_ROW_111_2105 VGND VPWR sky130_fd_sc_hd__tapvpwrvgnd_1
XTAP_TAPCELL_ROW_78_1579 VGND VPWR sky130_fd_sc_hd__tapvpwrvgnd_1
X_10303_ clknet_leaf_10_clk _00433_ VGND VGND VPWR VPWR cpuregs\[26\]\[13\] sky130_fd_sc_hd__dfxtp_1
XFILLER_152_245 VGND VGND VPWR VPWR sky130_fd_sc_hd__decap_6
X_11283_ clknet_leaf_6_clk _01330_ VGND VGND VPWR VPWR cpuregs\[4\]\[12\] sky130_fd_sc_hd__dfxtp_1
XFILLER_152_289 VPWR VGND VPWR VGND sky130_ef_sc_hd__decap_12
XFILLER_140_418 VGND VGND VPWR VPWR sky130_fd_sc_hd__fill_2
X_10234_ clknet_leaf_136_clk _00364_ VGND VGND VPWR VPWR cpuregs\[27\]\[8\] sky130_fd_sc_hd__dfxtp_1
XFILLER_133_492 VGND VGND VPWR VPWR sky130_fd_sc_hd__fill_2
XFILLER_79_568 VGND VGND VPWR VPWR sky130_fd_sc_hd__decap_4
X_10165_ clknet_leaf_126_clk _00295_ VGND VGND VPWR VPWR cpuregs\[9\]\[3\] sky130_fd_sc_hd__dfxtp_1
XFILLER_48_900 VPWR VGND VPWR VGND sky130_ef_sc_hd__decap_12
X_10096_ clknet_leaf_29_clk _00226_ VGND VGND VPWR VPWR cpuregs\[2\]\[30\] sky130_fd_sc_hd__dfxtp_1
XFILLER_87_590 VGND VGND VPWR VPWR sky130_fd_sc_hd__fill_1
XFILLER_86_97 VPWR VGND VPWR VGND sky130_ef_sc_hd__decap_12
XFILLER_59_281 VGND VGND VPWR VPWR sky130_fd_sc_hd__decap_4
XTAP_TAPCELL_ROW_109_2078 VGND VPWR sky130_fd_sc_hd__tapvpwrvgnd_1
XFILLER_59_292 VPWR VGND VPWR VGND sky130_ef_sc_hd__decap_12
XFILLER_47_476 VGND VGND VPWR VPWR sky130_fd_sc_hd__decap_3
XFILLER_47_498 VGND VGND VPWR VPWR sky130_fd_sc_hd__decap_6
XTAP_TAPCELL_ROW_122_2289 VGND VPWR sky130_fd_sc_hd__tapvpwrvgnd_1
XTAP_TAPCELL_ROW_122_2278 VGND VPWR sky130_fd_sc_hd__tapvpwrvgnd_1
X_10998_ clknet_leaf_30_clk _01060_ VGND VGND VPWR VPWR cpuregs\[18\]\[30\] sky130_fd_sc_hd__dfxtp_1
XFILLER_43_671 VGND VGND VPWR VPWR sky130_fd_sc_hd__fill_1
XFILLER_15_384 VGND VGND VPWR VPWR sky130_fd_sc_hd__decap_8
XFILLER_31_833 VGND VGND VPWR VPWR sky130_fd_sc_hd__decap_6
XTAP_TAPCELL_ROW_13_541 VGND VPWR sky130_fd_sc_hd__tapvpwrvgnd_1
XFILLER_31_877 VPWR VGND VPWR VGND sky130_ef_sc_hd__decap_12
XFILLER_30_365 VGND VGND VPWR VPWR sky130_fd_sc_hd__decap_6
XFILLER_128_253 VPWR VGND VPWR VGND sky130_ef_sc_hd__decap_12
XFILLER_128_242 VGND VGND VPWR VPWR sky130_fd_sc_hd__decap_8
X_05140_ net15 _01669_ net130 net29 _01748_ VGND VGND VPWR VPWR _01749_ sky130_fd_sc_hd__a221o_1
XFILLER_116_437 VGND VGND VPWR VPWR sky130_fd_sc_hd__decap_8
XFILLER_144_757 VPWR VGND VPWR VGND sky130_ef_sc_hd__decap_12
XFILLER_143_256 VGND VGND VPWR VPWR sky130_fd_sc_hd__decap_3
Xmax_cap258 _00014_ VGND VGND VPWR VPWR net258 sky130_fd_sc_hd__buf_12
X_05071_ instr_rdcycleh count_cycle\[33\] net257 _01684_ VGND VGND VPWR VPWR _01685_
+ sky130_fd_sc_hd__a211o_1
Xmax_cap269 _00011_ VGND VGND VPWR VPWR net269 sky130_fd_sc_hd__buf_12
Xmax_cap247 _03564_ VGND VGND VPWR VPWR net247 sky130_fd_sc_hd__buf_12
Xmax_cap236 _02724_ VGND VGND VPWR VPWR net236 sky130_fd_sc_hd__buf_4
XFILLER_98_811 VGND VGND VPWR VPWR sky130_fd_sc_hd__fill_1
X_08830_ net270 _04512_ VGND VGND VPWR VPWR _04513_ sky130_fd_sc_hd__or2_1
XFILLER_112_643 VGND VGND VPWR VPWR sky130_fd_sc_hd__fill_1
X_08761_ _01558_ _04447_ VGND VGND VPWR VPWR _04448_ sky130_fd_sc_hd__or2_1
X_05973_ reg_out\[9\] reg_next_pc\[9\] net596 VGND VGND VPWR VPWR _02490_ sky130_fd_sc_hd__mux2_1
XFILLER_38_421 VGND VGND VPWR VPWR sky130_fd_sc_hd__decap_8
XFILLER_122_29 VGND VGND VPWR VPWR sky130_fd_sc_hd__decap_3
X_07712_ count_instr\[22\] _03615_ net34 VGND VGND VPWR VPWR _03617_ sky130_fd_sc_hd__o21ai_1
X_04924_ mem_rdata_q\[12\] VGND VGND VPWR VPWR _01557_ sky130_fd_sc_hd__inv_2
X_08692_ _01559_ _04381_ _04382_ _04375_ _01560_ VGND VGND VPWR VPWR _04383_ sky130_fd_sc_hd__a221o_1
XFILLER_38_454 VPWR VGND VPWR VGND sky130_ef_sc_hd__decap_12
X_07643_ _02696_ cpuregs\[17\]\[27\] _03574_ VGND VGND VPWR VPWR _00575_ sky130_fd_sc_hd__mux2_1
XTAP_TAPCELL_ROW_49_1114 VGND VPWR sky130_fd_sc_hd__tapvpwrvgnd_1
X_07574_ cpuregs\[25\]\[25\] _02688_ _03571_ VGND VGND VPWR VPWR _00509_ sky130_fd_sc_hd__mux2_1
XFILLER_15_27 VPWR VGND VPWR VGND sky130_ef_sc_hd__decap_12
X_09313_ latched_rd\[1\] _04815_ _04816_ decoded_rd\[1\] VGND VGND VPWR VPWR _00993_
+ sky130_fd_sc_hd__a22o_1
XTAP_TAPCELL_ROW_62_1325 VGND VPWR sky130_fd_sc_hd__tapvpwrvgnd_1
X_06525_ _02953_ _02954_ VGND VGND VPWR VPWR _02955_ sky130_fd_sc_hd__or2_1
XFILLER_34_682 VGND VGND VPWR VPWR sky130_fd_sc_hd__fill_1
X_09244_ cpuregs\[1\]\[23\] _02678_ net244 VGND VGND VPWR VPWR _00941_ sky130_fd_sc_hd__mux2_1
X_06456_ cpuregs\[20\]\[5\] cpuregs\[21\]\[5\] cpuregs\[22\]\[5\] cpuregs\[23\]\[5\]
+ net264 net262 VGND VGND VPWR VPWR _02889_ sky130_fd_sc_hd__mux4_1
XTAP_TAPCELL_ROW_32_850 VGND VPWR sky130_fd_sc_hd__tapvpwrvgnd_1
X_05407_ _01981_ _01984_ _01993_ _01543_ VGND VGND VPWR VPWR _01995_ sky130_fd_sc_hd__a31oi_1
X_09175_ mem_rdata_q\[4\] _04788_ _04789_ mem_rdata_q\[3\] VGND VGND VPWR VPWR _04790_
+ sky130_fd_sc_hd__and4b_1
XFILLER_31_15 VPWR VGND VPWR VGND sky130_ef_sc_hd__decap_12
XFILLER_147_15 VPWR VGND VPWR VGND sky130_ef_sc_hd__decap_12
XFILLER_135_713 VPWR VGND VPWR VGND sky130_ef_sc_hd__decap_12
X_08126_ decoded_imm_j\[20\] _03708_ VGND VGND VPWR VPWR _03938_ sky130_fd_sc_hd__nand2_1
X_06387_ cpuregs\[8\]\[3\] cpuregs\[9\]\[3\] net264 VGND VGND VPWR VPWR _02822_ sky130_fd_sc_hd__mux2_1
X_05338_ cpu_state\[6\] _01860_ _01927_ _01931_ VGND VGND VPWR VPWR _01932_ sky130_fd_sc_hd__a31o_1
X_05269_ _01866_ _01867_ VGND VGND VPWR VPWR _01868_ sky130_fd_sc_hd__and2_1
X_08057_ _03702_ _03862_ VGND VGND VPWR VPWR _03875_ sky130_fd_sc_hd__nor2_1
XPHY_EDGE_ROW_1_Right_1 VGND VGND VPWR VPWR sky130_fd_sc_hd__decap_3
Xoutput48 net48 VGND VGND VPWR VPWR mem_addr[23] sky130_fd_sc_hd__buf_2
X_07008_ reg_pc\[25\] _02751_ _03420_ _02715_ VGND VGND VPWR VPWR _03421_ sky130_fd_sc_hd__a211o_1
Xoutput37 net37 VGND VGND VPWR VPWR mem_addr[12] sky130_fd_sc_hd__buf_2
Xpicorv32_281 VGND VGND VPWR VPWR picorv32_281/HI eoi[0] sky130_fd_sc_hd__conb_1
XFILLER_0_225 VPWR VGND VPWR VGND sky130_ef_sc_hd__decap_12
Xoutput59 net59 VGND VGND VPWR VPWR mem_addr[4] sky130_fd_sc_hd__buf_2
Xpicorv32_292 VGND VGND VPWR VPWR picorv32_292/HI eoi[11] sky130_fd_sc_hd__conb_1
XTAP_TAPCELL_ROW_73_1498 VGND VPWR sky130_fd_sc_hd__tapvpwrvgnd_1
X_08959_ cpuregs\[0\]\[26\] cpuregs\[1\]\[26\] cpuregs\[2\]\[26\] cpuregs\[3\]\[26\]
+ net280 net274 VGND VGND VPWR VPWR _04635_ sky130_fd_sc_hd__mux4_1
X_10921_ clknet_leaf_31_clk _00983_ VGND VGND VPWR VPWR net154 sky130_fd_sc_hd__dfxtp_1
XFILLER_57_796 VPWR VGND VPWR VGND sky130_ef_sc_hd__decap_12
XFILLER_57_785 VGND VGND VPWR VPWR sky130_fd_sc_hd__fill_1
XFILLER_72_755 VGND VGND VPWR VPWR sky130_fd_sc_hd__fill_1
X_10852_ clknet_leaf_100_clk _00916_ VGND VGND VPWR VPWR is_sll_srl_sra sky130_fd_sc_hd__dfxtp_1
XFILLER_25_671 VGND VGND VPWR VPWR sky130_fd_sc_hd__fill_1
X_10783_ clknet_leaf_98_clk _00848_ VGND VGND VPWR VPWR instr_bne sky130_fd_sc_hd__dfxtp_1
XFILLER_13_833 VGND VGND VPWR VPWR sky130_fd_sc_hd__decap_6
Xclkbuf_leaf_51_clk clknet_4_7_0_clk VGND VGND VPWR VPWR clknet_leaf_51_clk sky130_fd_sc_hd__clkbuf_8
XFILLER_13_877 VPWR VGND VPWR VGND sky130_ef_sc_hd__decap_12
XTAP_TAPCELL_ROW_30_809 VGND VPWR sky130_fd_sc_hd__tapvpwrvgnd_1
X_11404_ clknet_leaf_119_clk _01448_ VGND VGND VPWR VPWR cpuregs\[8\]\[2\] sky130_fd_sc_hd__dfxtp_1
XFILLER_125_223 VGND VGND VPWR VPWR sky130_fd_sc_hd__fill_1
XTAP_TAPCELL_ROW_93_1819 VGND VPWR sky130_fd_sc_hd__tapvpwrvgnd_1
X_11335_ clknet_leaf_102_clk _00024_ VGND VGND VPWR VPWR mem_wordsize\[0\] sky130_fd_sc_hd__dfxtp_1
XFILLER_21_81 VGND VGND VPWR VPWR sky130_fd_sc_hd__decap_4
XFILLER_137_81 VGND VGND VPWR VPWR sky130_fd_sc_hd__decap_6
X_11266_ clknet_leaf_36_clk _01313_ VGND VGND VPWR VPWR cpuregs\[22\]\[27\] sky130_fd_sc_hd__dfxtp_1
X_10217_ clknet_leaf_51_clk _00347_ VGND VGND VPWR VPWR cpuregs\[14\]\[23\] sky130_fd_sc_hd__dfxtp_1
XFILLER_79_343 VGND VGND VPWR VPWR sky130_fd_sc_hd__fill_1
XFILLER_79_332 VGND VGND VPWR VPWR sky130_fd_sc_hd__decap_4
X_11197_ clknet_leaf_49_clk _01244_ VGND VGND VPWR VPWR cpuregs\[29\]\[22\] sky130_fd_sc_hd__dfxtp_1
Xsplit201 net588 VGND VGND VPWR VPWR net587 sky130_fd_sc_hd__buf_8
X_10148_ clknet_leaf_34_clk _00278_ VGND VGND VPWR VPWR cpuregs\[21\]\[18\] sky130_fd_sc_hd__dfxtp_1
XTAP_TAPCELL_ROW_124_2318 VGND VPWR sky130_fd_sc_hd__tapvpwrvgnd_1
X_10079_ clknet_leaf_8_clk _00209_ VGND VGND VPWR VPWR cpuregs\[2\]\[13\] sky130_fd_sc_hd__dfxtp_1
XFILLER_62_232 VGND VGND VPWR VPWR sky130_fd_sc_hd__decap_3
XTAP_TAPCELL_ROW_18_622 VGND VPWR sky130_fd_sc_hd__tapvpwrvgnd_1
XFILLER_90_563 VGND VGND VPWR VPWR sky130_fd_sc_hd__decap_3
XFILLER_62_265 VPWR VGND VPWR VGND sky130_ef_sc_hd__decap_12
XFILLER_35_457 VGND VGND VPWR VPWR sky130_fd_sc_hd__fill_1
XFILLER_35_468 VGND VGND VPWR VPWR sky130_fd_sc_hd__decap_4
Xclkbuf_leaf_42_clk clknet_4_7_0_clk VGND VGND VPWR VPWR clknet_leaf_42_clk sky130_fd_sc_hd__clkbuf_8
XTAP_TAPCELL_ROW_102_1959 VGND VPWR sky130_fd_sc_hd__tapvpwrvgnd_1
XFILLER_94_3 VGND VGND VPWR VPWR sky130_fd_sc_hd__fill_2
X_06310_ net171 decoded_imm\[0\] VGND VGND VPWR VPWR _02748_ sky130_fd_sc_hd__nand2_1
XTAP_TAPCELL_ROW_44_1033 VGND VPWR sky130_fd_sc_hd__tapvpwrvgnd_1
X_07290_ cpuregs\[28\]\[8\] _02616_ net249 VGND VGND VPWR VPWR _00236_ sky130_fd_sc_hd__mux2_1
XTAP_TAPCELL_ROW_139_2561 VGND VPWR sky130_fd_sc_hd__tapvpwrvgnd_1
XTAP_TAPCELL_ROW_139_2550 VGND VPWR sky130_fd_sc_hd__tapvpwrvgnd_1
X_06241_ reg_pc\[25\] _02681_ VGND VGND VPWR VPWR _02686_ sky130_fd_sc_hd__and2_1
XFILLER_30_173 VGND VGND VPWR VPWR sky130_fd_sc_hd__decap_3
XTAP_TAPCELL_ROW_152_2761 VGND VPWR sky130_fd_sc_hd__tapvpwrvgnd_1
XFILLER_8_881 VPWR VGND VPWR VGND sky130_ef_sc_hd__decap_12
X_06172_ _02630_ cpuregs\[11\]\[11\] _02582_ VGND VGND VPWR VPWR _00048_ sky130_fd_sc_hd__mux2_1
XFILLER_116_234 VGND VGND VPWR VPWR sky130_fd_sc_hd__fill_2
X_05123_ count_instr\[5\] instr_rdinstr count_cycle\[37\] instr_rdcycleh VGND VGND
+ VPWR VPWR _01733_ sky130_fd_sc_hd__a22o_1
X_09931_ clknet_leaf_34_clk _00066_ VGND VGND VPWR VPWR cpuregs\[11\]\[29\] sky130_fd_sc_hd__dfxtp_1
XFILLER_89_107 VGND VGND VPWR VPWR sky130_fd_sc_hd__decap_4
X_05054_ net31 net17 net606 VGND VGND VPWR VPWR _01670_ sky130_fd_sc_hd__mux2_1
XFILLER_98_641 VGND VGND VPWR VPWR sky130_fd_sc_hd__decap_3
XFILLER_98_652 VPWR VGND VPWR VGND sky130_ef_sc_hd__decap_12
X_09862_ decoded_imm_j\[15\] _01109_ _02513_ VGND VGND VPWR VPWR _00903_ sky130_fd_sc_hd__mux2_1
XFILLER_133_39 VPWR VGND VPWR VGND sky130_ef_sc_hd__decap_12
XFILLER_112_484 VGND VGND VPWR VPWR sky130_fd_sc_hd__fill_1
X_08813_ cpuregs\[0\]\[18\] cpuregs\[1\]\[18\] cpuregs\[2\]\[18\] cpuregs\[3\]\[18\]
+ net277 net272 VGND VGND VPWR VPWR _04497_ sky130_fd_sc_hd__mux4_1
X_09793_ _02586_ cpuregs\[8\]\[0\] _04875_ VGND VGND VPWR VPWR _01446_ sky130_fd_sc_hd__mux2_1
X_05956_ net226 _01665_ _02480_ VGND VGND VPWR VPWR net120 sky130_fd_sc_hd__a21o_1
XFILLER_86_869 VGND VGND VPWR VPWR sky130_fd_sc_hd__decap_8
XFILLER_85_346 VGND VGND VPWR VPWR sky130_fd_sc_hd__decap_6
X_08744_ net270 _04428_ _01560_ VGND VGND VPWR VPWR _04432_ sky130_fd_sc_hd__o21a_1
XFILLER_39_741 VGND VGND VPWR VPWR sky130_fd_sc_hd__decap_4
XFILLER_100_679 VPWR VGND VPWR VGND sky130_ef_sc_hd__decap_12
XFILLER_26_15 VPWR VGND VPWR VGND sky130_ef_sc_hd__decap_12
XFILLER_26_402 VGND VGND VPWR VPWR sky130_fd_sc_hd__fill_2
XFILLER_38_251 VGND VGND VPWR VPWR sky130_fd_sc_hd__fill_1
X_05887_ _02062_ _02238_ _02242_ _02442_ VGND VGND VPWR VPWR _02443_ sky130_fd_sc_hd__o2bb2a_1
XFILLER_81_541 VPWR VGND VPWR VGND sky130_ef_sc_hd__decap_12
XFILLER_54_744 VPWR VGND VPWR VGND sky130_ef_sc_hd__decap_12
X_08675_ net270 _04362_ _04361_ _01560_ VGND VGND VPWR VPWR _04367_ sky130_fd_sc_hd__o211a_1
XFILLER_53_221 VGND VGND VPWR VPWR sky130_fd_sc_hd__decap_3
XTAP_TAPCELL_ROW_37_920 VGND VPWR sky130_fd_sc_hd__tapvpwrvgnd_1
XTAP_TAPCELL_ROW_37_931 VGND VPWR sky130_fd_sc_hd__tapvpwrvgnd_1
X_07626_ _02624_ cpuregs\[17\]\[10\] _03574_ VGND VGND VPWR VPWR _00558_ sky130_fd_sc_hd__mux2_1
X_07557_ cpuregs\[25\]\[8\] _02616_ _03571_ VGND VGND VPWR VPWR _00492_ sky130_fd_sc_hd__mux2_1
XFILLER_41_449 VGND VGND VPWR VPWR sky130_fd_sc_hd__fill_1
Xclkbuf_leaf_33_clk clknet_4_4_0_clk VGND VGND VPWR VPWR clknet_leaf_33_clk sky130_fd_sc_hd__clkbuf_8
X_06508_ cpuregs\[12\]\[7\] cpuregs\[13\]\[7\] cpuregs\[14\]\[7\] cpuregs\[15\]\[7\]
+ net264 net259 VGND VGND VPWR VPWR _02939_ sky130_fd_sc_hd__mux4_1
XFILLER_139_337 VPWR VGND VPWR VGND sky130_ef_sc_hd__decap_12
XFILLER_10_825 VPWR VGND VPWR VGND sky130_ef_sc_hd__decap_12
X_07488_ cpuregs\[26\]\[6\] _02607_ _03568_ VGND VGND VPWR VPWR _00426_ sky130_fd_sc_hd__mux2_1
XFILLER_10_869 VPWR VGND VPWR VGND sky130_ef_sc_hd__decap_12
X_06439_ decoded_imm\[5\] net198 VGND VGND VPWR VPWR _02872_ sky130_fd_sc_hd__nand2_2
X_09227_ cpuregs\[1\]\[6\] _02607_ net244 VGND VGND VPWR VPWR _00924_ sky130_fd_sc_hd__mux2_1
XFILLER_148_893 VPWR VGND VPWR VGND sky130_ef_sc_hd__decap_12
X_09158_ mem_rdata_q\[29\] mem_rdata_q\[28\] mem_rdata_q\[30\] VGND VGND VPWR VPWR
+ _04776_ sky130_fd_sc_hd__or3b_1
XFILLER_5_317 VPWR VGND VPWR VGND sky130_ef_sc_hd__decap_12
XFILLER_108_757 VGND VGND VPWR VPWR sky130_fd_sc_hd__fill_2
X_08109_ _03706_ _03912_ VGND VGND VPWR VPWR _03923_ sky130_fd_sc_hd__xor2_1
XTAP_TAPCELL_ROW_75_1527 VGND VPWR sky130_fd_sc_hd__tapvpwrvgnd_1
X_09089_ _01094_ _01095_ _01097_ _01096_ VGND VGND VPWR VPWR _04745_ sky130_fd_sc_hd__and4_1
XFILLER_150_513 VPWR VGND VPWR VGND sky130_ef_sc_hd__decap_12
XFILLER_123_727 VGND VGND VPWR VPWR sky130_fd_sc_hd__fill_1
XTAP_TAPCELL_ROW_75_1538 VGND VPWR sky130_fd_sc_hd__tapvpwrvgnd_1
X_11120_ clknet_leaf_147_clk _01167_ VGND VGND VPWR VPWR cpuregs\[31\]\[9\] sky130_fd_sc_hd__dfxtp_1
XFILLER_107_40 VPWR VGND VPWR VGND sky130_ef_sc_hd__decap_12
XFILLER_150_579 VGND VGND VPWR VPWR sky130_fd_sc_hd__decap_8
X_11051_ clknet_leaf_88_clk _01108_ VGND VGND VPWR VPWR mem_rdata_q\[14\] sky130_fd_sc_hd__dfxtp_2
XFILLER_67_55 VGND VGND VPWR VPWR sky130_fd_sc_hd__fill_1
XFILLER_49_527 VGND VGND VPWR VPWR sky130_fd_sc_hd__fill_1
X_10002_ clknet_leaf_119_clk _00132_ VGND VGND VPWR VPWR cpuregs\[30\]\[0\] sky130_fd_sc_hd__dfxtp_1
XFILLER_76_357 VGND VGND VPWR VPWR sky130_fd_sc_hd__decap_6
XTAP_TAPCELL_ROW_106_2026 VGND VPWR sky130_fd_sc_hd__tapvpwrvgnd_1
XTAP_TAPCELL_ROW_4_394 VGND VPWR sky130_fd_sc_hd__tapvpwrvgnd_1
XFILLER_83_21 VPWR VGND VPWR VGND sky130_ef_sc_hd__decap_12
XPHY_EDGE_ROW_103_Left_257 VGND VGND VPWR VPWR sky130_fd_sc_hd__decap_3
X_10904_ clknet_leaf_7_clk _00966_ VGND VGND VPWR VPWR net136 sky130_fd_sc_hd__dfxtp_1
XFILLER_32_405 VPWR VGND VPWR VGND sky130_ef_sc_hd__decap_12
X_10835_ clknet_leaf_111_clk _00900_ VGND VGND VPWR VPWR decoded_rd\[2\] sky130_fd_sc_hd__dfxtp_1
XFILLER_44_287 VGND VGND VPWR VPWR sky130_fd_sc_hd__fill_1
Xclkbuf_leaf_24_clk clknet_4_4_0_clk VGND VGND VPWR VPWR clknet_leaf_24_clk sky130_fd_sc_hd__clkbuf_8
X_10766_ clknet_leaf_91_clk alu_out\[19\] VGND VGND VPWR VPWR alu_out_q\[19\] sky130_fd_sc_hd__dfxtp_1
X_10697_ clknet_leaf_69_clk _00795_ VGND VGND VPWR VPWR net50 sky130_fd_sc_hd__dfxtp_1
XFILLER_8_133 VGND VGND VPWR VPWR sky130_fd_sc_hd__decap_6
XFILLER_145_329 VGND VGND VPWR VPWR sky130_fd_sc_hd__decap_6
XTAP_TAPCELL_ROW_134_2480 VGND VPWR sky130_fd_sc_hd__tapvpwrvgnd_1
XTAP_TAPCELL_ROW_117_2199 VGND VPWR sky130_fd_sc_hd__tapvpwrvgnd_1
XFILLER_114_716 VGND VGND VPWR VPWR sky130_fd_sc_hd__fill_1
XPHY_EDGE_ROW_112_Left_266 VGND VGND VPWR VPWR sky130_fd_sc_hd__decap_3
XFILLER_99_416 VGND VGND VPWR VPWR sky130_fd_sc_hd__decap_6
XFILLER_126_598 VPWR VGND VPWR VGND sky130_ef_sc_hd__decap_12
XFILLER_99_449 VGND VGND VPWR VPWR sky130_fd_sc_hd__decap_6
X_11318_ clknet_leaf_20_clk _01365_ VGND VGND VPWR VPWR cpuregs\[5\]\[15\] sky130_fd_sc_hd__dfxtp_1
XFILLER_5_895 VGND VGND VPWR VPWR sky130_fd_sc_hd__fill_1
XFILLER_79_151 VGND VGND VPWR VPWR sky130_fd_sc_hd__fill_1
X_11249_ clknet_leaf_3_clk _01296_ VGND VGND VPWR VPWR cpuregs\[22\]\[10\] sky130_fd_sc_hd__dfxtp_1
XFILLER_94_110 VGND VGND VPWR VPWR sky130_fd_sc_hd__decap_4
XFILLER_79_184 VPWR VGND VPWR VGND sky130_ef_sc_hd__decap_12
XFILLER_121_281 VGND VGND VPWR VPWR sky130_fd_sc_hd__decap_6
X_05810_ _02102_ _02373_ VGND VGND VPWR VPWR _02374_ sky130_fd_sc_hd__nand2_1
XFILLER_83_817 VGND VGND VPWR VPWR sky130_fd_sc_hd__decap_6
XFILLER_67_335 VGND VGND VPWR VPWR sky130_fd_sc_hd__fill_1
X_06790_ reg_pc\[17\] _02751_ _03210_ _02715_ VGND VGND VPWR VPWR _03211_ sky130_fd_sc_hd__a211o_1
XPHY_EDGE_ROW_121_Left_275 VGND VGND VPWR VPWR sky130_fd_sc_hd__decap_3
X_05741_ _02119_ _02193_ _02195_ VGND VGND VPWR VPWR _02312_ sky130_fd_sc_hd__o21a_1
XFILLER_36_755 VGND VGND VPWR VPWR sky130_fd_sc_hd__fill_1
X_08460_ cpuregs\[22\]\[31\] cpuregs\[23\]\[31\] net264 VGND VGND VPWR VPWR _04197_
+ sky130_fd_sc_hd__mux2_1
X_05672_ _02252_ _02181_ instr_sub VGND VGND VPWR VPWR _02253_ sky130_fd_sc_hd__mux2_1
XFILLER_36_766 VGND VGND VPWR VPWR sky130_fd_sc_hd__fill_1
X_07411_ cpuregs\[14\]\[29\] _02704_ net247 VGND VGND VPWR VPWR _00353_ sky130_fd_sc_hd__mux2_1
X_08391_ _04143_ net34 _04142_ VGND VGND VPWR VPWR _00755_ sky130_fd_sc_hd__and3b_1
X_07342_ cpuregs\[21\]\[26\] _02691_ net248 VGND VGND VPWR VPWR _00286_ sky130_fd_sc_hd__mux2_1
Xclkbuf_leaf_15_clk clknet_4_1_0_clk VGND VGND VPWR VPWR clknet_leaf_15_clk sky130_fd_sc_hd__clkbuf_8
X_07273_ cpuregs\[2\]\[24\] _02683_ net250 VGND VGND VPWR VPWR _00220_ sky130_fd_sc_hd__mux2_1
XFILLER_148_189 VGND VGND VPWR VPWR sky130_fd_sc_hd__decap_6
X_06224_ reg_pc\[22\] _02668_ VGND VGND VPWR VPWR _02672_ sky130_fd_sc_hd__nor2_1
X_09012_ cpuregs\[4\]\[29\] cpuregs\[5\]\[29\] cpuregs\[6\]\[29\] cpuregs\[7\]\[29\]
+ net275 net271 VGND VGND VPWR VPWR _04685_ sky130_fd_sc_hd__mux4_1
XFILLER_145_841 VPWR VGND VPWR VGND sky130_ef_sc_hd__decap_12
XPHY_EDGE_ROW_130_Left_284 VGND VGND VPWR VPWR sky130_fd_sc_hd__decap_3
XFILLER_117_543 VPWR VGND VPWR VGND sky130_ef_sc_hd__decap_12
XFILLER_117_521 VGND VGND VPWR VPWR sky130_fd_sc_hd__fill_1
X_06155_ _02616_ cpuregs\[11\]\[8\] _02582_ VGND VGND VPWR VPWR _00045_ sky130_fd_sc_hd__mux2_1
XFILLER_117_565 VGND VGND VPWR VPWR sky130_fd_sc_hd__fill_1
XFILLER_105_727 VGND VGND VPWR VPWR sky130_fd_sc_hd__fill_1
XTAP_TAPCELL_ROW_57_1246 VGND VPWR sky130_fd_sc_hd__tapvpwrvgnd_1
XFILLER_2_309 VGND VGND VPWR VPWR sky130_fd_sc_hd__decap_3
X_05106_ reg_pc\[4\] decoded_imm\[4\] VGND VGND VPWR VPWR _01717_ sky130_fd_sc_hd__or2_1
XFILLER_104_215 VGND VGND VPWR VPWR sky130_fd_sc_hd__decap_4
X_06086_ is_slli_srli_srai decoded_imm_j\[3\] cpu_state\[4\] VGND VGND VPWR VPWR _02558_
+ sky130_fd_sc_hd__a21o_1
XFILLER_144_27 VGND VGND VPWR VPWR sky130_fd_sc_hd__fill_1
X_09914_ clknet_leaf_9_clk _00049_ VGND VGND VPWR VPWR cpuregs\[11\]\[12\] sky130_fd_sc_hd__dfxtp_1
X_05037_ _01656_ _01657_ _01654_ VGND VGND VPWR VPWR _01658_ sky130_fd_sc_hd__a21o_1
X_09845_ _02662_ cpuregs\[10\]\[19\] _04876_ VGND VGND VPWR VPWR _01529_ sky130_fd_sc_hd__mux2_1
XFILLER_98_460 VGND VGND VPWR VPWR sky130_fd_sc_hd__fill_1
XTAP_TAPCELL_ROW_70_1457 VGND VPWR sky130_fd_sc_hd__tapvpwrvgnd_1
XTAP_TAPCELL_ROW_70_1446 VGND VPWR sky130_fd_sc_hd__tapvpwrvgnd_1
XFILLER_58_313 VGND VGND VPWR VPWR sky130_fd_sc_hd__fill_1
XFILLER_100_421 VGND VGND VPWR VPWR sky130_fd_sc_hd__decap_4
XFILLER_85_121 VGND VGND VPWR VPWR sky130_fd_sc_hd__decap_3
XFILLER_58_335 VGND VGND VPWR VPWR sky130_fd_sc_hd__decap_6
X_06988_ _03399_ _03400_ VGND VGND VPWR VPWR _03401_ sky130_fd_sc_hd__nand2b_1
X_09776_ _02649_ cpuregs\[7\]\[16\] _04874_ VGND VGND VPWR VPWR _01430_ sky130_fd_sc_hd__mux2_1
XFILLER_86_699 VGND VGND VPWR VPWR sky130_fd_sc_hd__fill_1
X_05939_ mem_wordsize\[1\] net125 net208 _01672_ VGND VGND VPWR VPWR net102 sky130_fd_sc_hd__a22o_1
X_08727_ _04413_ _04414_ _04415_ net269 _00010_ VGND VGND VPWR VPWR _04416_ sky130_fd_sc_hd__a221o_1
XTAP_TAPCELL_ROW_1_342 VGND VPWR sky130_fd_sc_hd__tapvpwrvgnd_1
XFILLER_37_69 VGND VGND VPWR VPWR sky130_fd_sc_hd__fill_1
XTAP_TAPCELL_ROW_1_353 VGND VPWR sky130_fd_sc_hd__tapvpwrvgnd_1
XFILLER_27_755 VGND VGND VPWR VPWR sky130_fd_sc_hd__decap_4
XFILLER_27_777 VGND VGND VPWR VPWR sky130_fd_sc_hd__decap_6
X_08658_ _04349_ _04350_ _04266_ _04347_ VGND VGND VPWR VPWR _04351_ sky130_fd_sc_hd__o211a_1
X_07609_ cpuregs\[20\]\[26\] _02691_ net245 VGND VGND VPWR VPWR _00542_ sky130_fd_sc_hd__mux2_1
XFILLER_81_360 VGND VGND VPWR VPWR sky130_fd_sc_hd__fill_1
XFILLER_41_213 VGND VGND VPWR VPWR sky130_fd_sc_hd__decap_8
XFILLER_81_393 VGND VGND VPWR VPWR sky130_fd_sc_hd__decap_8
XFILLER_53_57 VGND VGND VPWR VPWR sky130_fd_sc_hd__fill_2
X_08589_ cpuregs\[24\]\[6\] cpuregs\[25\]\[6\] cpuregs\[26\]\[6\] cpuregs\[27\]\[6\]
+ net278 net273 VGND VGND VPWR VPWR _04285_ sky130_fd_sc_hd__mux4_1
X_10620_ clknet_leaf_105_clk _00750_ VGND VGND VPWR VPWR count_cycle\[43\] sky130_fd_sc_hd__dfxtp_1
X_10551_ clknet_leaf_129_clk _00681_ VGND VGND VPWR VPWR reg_next_pc\[6\] sky130_fd_sc_hd__dfxtp_1
XFILLER_139_167 VGND VGND VPWR VPWR sky130_fd_sc_hd__fill_1
X_10482_ clknet_leaf_81_clk _00612_ VGND VGND VPWR VPWR count_instr\[31\] sky130_fd_sc_hd__dfxtp_1
XTAP_TAPCELL_ROW_20_650 VGND VPWR sky130_fd_sc_hd__tapvpwrvgnd_1
XFILLER_6_637 VGND VGND VPWR VPWR sky130_fd_sc_hd__decap_6
XFILLER_5_125 VPWR VGND VPWR VGND sky130_ef_sc_hd__decap_12
XFILLER_108_587 VGND VGND VPWR VPWR sky130_fd_sc_hd__fill_1
XFILLER_5_169 VPWR VGND VPWR VGND sky130_ef_sc_hd__decap_12
XFILLER_151_833 VGND VGND VPWR VPWR sky130_fd_sc_hd__decap_6
XFILLER_150_321 VPWR VGND VPWR VGND sky130_ef_sc_hd__decap_12
XFILLER_135_384 VGND VGND VPWR VPWR sky130_fd_sc_hd__decap_8
XFILLER_97_909 VGND VGND VPWR VPWR sky130_fd_sc_hd__decap_3
XFILLER_151_877 VPWR VGND VPWR VGND sky130_ef_sc_hd__decap_12
XFILLER_150_365 VGND VGND VPWR VPWR sky130_fd_sc_hd__decap_4
XTAP_TAPCELL_ROW_9_475 VGND VPWR sky130_fd_sc_hd__tapvpwrvgnd_1
XFILLER_1_353 VGND VGND VPWR VPWR sky130_fd_sc_hd__decap_4
X_11103_ clknet_leaf_127_clk _00006_ VGND VGND VPWR VPWR reg_sh\[4\] sky130_fd_sc_hd__dfxtp_1
XFILLER_89_460 VGND VGND VPWR VPWR sky130_fd_sc_hd__fill_1
X_11034_ clknet_leaf_88_clk _00034_ VGND VGND VPWR VPWR _00014_ sky130_fd_sc_hd__dfxtp_4
XFILLER_1_364 VGND VGND VPWR VPWR sky130_fd_sc_hd__fill_1
XFILLER_1_375 VPWR VGND VPWR VGND sky130_ef_sc_hd__decap_12
XFILLER_103_292 VPWR VGND VPWR VGND sky130_ef_sc_hd__decap_12
XFILLER_103_281 VGND VGND VPWR VPWR sky130_fd_sc_hd__fill_2
XFILLER_77_655 VPWR VGND VPWR VGND sky130_ef_sc_hd__decap_12
XFILLER_91_113 VGND VGND VPWR VPWR sky130_fd_sc_hd__decap_8
XFILLER_18_733 VGND VGND VPWR VPWR sky130_fd_sc_hd__decap_6
XTAP_TAPCELL_ROW_28_772 VGND VPWR sky130_fd_sc_hd__tapvpwrvgnd_1
XTAP_TAPCELL_ROW_28_783 VGND VPWR sky130_fd_sc_hd__tapvpwrvgnd_1
XFILLER_60_544 VGND VGND VPWR VPWR sky130_fd_sc_hd__fill_1
XFILLER_21_909 VGND VGND VPWR VPWR sky130_fd_sc_hd__decap_3
XFILLER_32_224 VGND VGND VPWR VPWR sky130_fd_sc_hd__decap_4
XFILLER_32_257 VGND VGND VPWR VPWR sky130_fd_sc_hd__fill_1
X_10818_ clknet_leaf_88_clk _00883_ VGND VGND VPWR VPWR instr_rdinstr sky130_fd_sc_hd__dfxtp_4
XFILLER_20_419 VGND VGND VPWR VPWR sky130_fd_sc_hd__fill_1
XTAP_TAPCELL_ROW_119_2239 VGND VPWR sky130_fd_sc_hd__tapvpwrvgnd_1
XTAP_TAPCELL_ROW_119_2228 VGND VPWR sky130_fd_sc_hd__tapvpwrvgnd_1
X_10749_ clknet_leaf_129_clk alu_out\[2\] VGND VGND VPWR VPWR alu_out_q\[2\] sky130_fd_sc_hd__dfxtp_1
XFILLER_127_841 VPWR VGND VPWR VGND sky130_ef_sc_hd__decap_12
Xoutput216 net216 VGND VGND VPWR VPWR pcpi_rs2[21] sky130_fd_sc_hd__buf_2
XFILLER_142_811 VGND VGND VPWR VPWR sky130_fd_sc_hd__fill_1
XTAP_TAPCELL_ROW_132_2439 VGND VPWR sky130_fd_sc_hd__tapvpwrvgnd_1
XFILLER_57_3 VGND VGND VPWR VPWR sky130_fd_sc_hd__decap_3
Xoutput205 net205 VGND VGND VPWR VPWR pcpi_rs2[11] sky130_fd_sc_hd__buf_2
Xoutput227 net227 VGND VGND VPWR VPWR pcpi_rs2[31] sky130_fd_sc_hd__buf_2
XFILLER_153_181 VPWR VGND VPWR VGND sky130_ef_sc_hd__decap_12
XFILLER_99_246 VGND VGND VPWR VPWR sky130_fd_sc_hd__decap_4
X_07960_ _03695_ _03780_ VGND VGND VPWR VPWR _03785_ sky130_fd_sc_hd__nor2_1
X_06911_ net189 net254 VGND VGND VPWR VPWR _03327_ sky130_fd_sc_hd__or2_1
Xclkbuf_leaf_4_clk clknet_4_0_0_clk VGND VGND VPWR VPWR clknet_leaf_4_clk sky130_fd_sc_hd__clkbuf_8
XTAP_TAPCELL_ROW_52_1165 VGND VPWR sky130_fd_sc_hd__tapvpwrvgnd_1
X_07891_ instr_jal net407 decoded_imm_j\[1\] _03687_ VGND VGND VPWR VPWR _03723_ sky130_fd_sc_hd__a31o_1
XTAP_TAPCELL_ROW_147_2682 VGND VPWR sky130_fd_sc_hd__tapvpwrvgnd_1
X_06842_ _00015_ _03257_ _03260_ _02735_ VGND VGND VPWR VPWR _03261_ sky130_fd_sc_hd__o211a_1
XFILLER_83_614 VGND VGND VPWR VPWR sky130_fd_sc_hd__fill_2
XFILLER_55_316 VGND VGND VPWR VPWR sky130_fd_sc_hd__decap_3
X_09630_ _02593_ cpuregs\[22\]\[3\] _04869_ VGND VGND VPWR VPWR _01289_ sky130_fd_sc_hd__mux2_1
X_06773_ net184 net254 VGND VGND VPWR VPWR _03194_ sky130_fd_sc_hd__or2_1
X_09561_ cpuregs\[29\]\[0\] _02586_ net239 VGND VGND VPWR VPWR _01222_ sky130_fd_sc_hd__mux2_1
X_05724_ _02137_ _02297_ VGND VGND VPWR VPWR _02298_ sky130_fd_sc_hd__or2_1
X_08512_ cpu_state\[0\] _01624_ VGND VGND VPWR VPWR _04217_ sky130_fd_sc_hd__and2b_1
XFILLER_130_29 VPWR VGND VPWR VGND sky130_ef_sc_hd__decap_12
X_09492_ cpuregs\[24\]\[30\] _02709_ net241 VGND VGND VPWR VPWR _01156_ sky130_fd_sc_hd__mux2_1
XFILLER_23_202 VGND VGND VPWR VPWR sky130_fd_sc_hd__decap_6
X_05655_ instr_and instr_andi VGND VGND VPWR VPWR _02238_ sky130_fd_sc_hd__or2_4
X_08443_ _01578_ _04179_ _01579_ VGND VGND VPWR VPWR _04180_ sky130_fd_sc_hd__o21a_1
XFILLER_51_533 VGND VGND VPWR VPWR sky130_fd_sc_hd__decap_8
X_08374_ count_cycle\[41\] count_cycle\[42\] _04129_ VGND VGND VPWR VPWR _04133_ sky130_fd_sc_hd__and3_1
XFILLER_23_27 VPWR VGND VPWR VGND sky130_ef_sc_hd__decap_12
X_05586_ net198 net124 VGND VGND VPWR VPWR _02169_ sky130_fd_sc_hd__nor2_1
XFILLER_139_27 VPWR VGND VPWR VGND sky130_ef_sc_hd__decap_12
X_07325_ cpuregs\[21\]\[9\] _02621_ net248 VGND VGND VPWR VPWR _00269_ sky130_fd_sc_hd__mux2_1
XFILLER_137_638 VPWR VGND VPWR VGND sky130_ef_sc_hd__decap_12
X_07256_ cpuregs\[2\]\[7\] _02612_ net250 VGND VGND VPWR VPWR _00203_ sky130_fd_sc_hd__mux2_1
X_06207_ reg_out\[19\] alu_out_q\[19\] net587 VGND VGND VPWR VPWR _02658_ sky130_fd_sc_hd__mux2_1
XFILLER_136_159 VPWR VGND VPWR VGND sky130_ef_sc_hd__decap_12
X_07187_ cpuregs\[30\]\[5\] _02603_ net252 VGND VGND VPWR VPWR _00137_ sky130_fd_sc_hd__mux2_1
XFILLER_145_682 VGND VGND VPWR VPWR sky130_fd_sc_hd__decap_3
XFILLER_133_833 VGND VGND VPWR VPWR sky130_fd_sc_hd__decap_6
XFILLER_3_629 VPWR VGND VPWR VGND sky130_ef_sc_hd__decap_12
X_06138_ _02583_ _02599_ _02602_ VGND VGND VPWR VPWR _02603_ sky130_fd_sc_hd__a21bo_4
XFILLER_133_877 VPWR VGND VPWR VGND sky130_ef_sc_hd__decap_12
X_06069_ cpuregs\[0\]\[3\] cpuregs\[1\]\[3\] cpuregs\[2\]\[3\] cpuregs\[3\]\[3\] net279
+ _00008_ VGND VGND VPWR VPWR _02541_ sky130_fd_sc_hd__mux4_1
XFILLER_2_139 VGND VGND VPWR VPWR sky130_fd_sc_hd__fill_1
XFILLER_132_365 VGND VGND VPWR VPWR sky130_fd_sc_hd__decap_6
XTAP_TAPCELL_ROW_6_434 VGND VPWR sky130_fd_sc_hd__tapvpwrvgnd_1
XTAP_TAPCELL_ROW_6_423 VGND VPWR sky130_fd_sc_hd__tapvpwrvgnd_1
XFILLER_98_290 VGND VGND VPWR VPWR sky130_fd_sc_hd__fill_2
XPHY_EDGE_ROW_122_Right_122 VGND VGND VPWR VPWR sky130_fd_sc_hd__decap_3
XFILLER_100_251 VGND VGND VPWR VPWR sky130_fd_sc_hd__fill_1
XFILLER_86_474 VGND VGND VPWR VPWR sky130_fd_sc_hd__fill_2
X_09828_ _02590_ cpuregs\[10\]\[2\] _04876_ VGND VGND VPWR VPWR _01512_ sky130_fd_sc_hd__mux2_1
XFILLER_104_41 VPWR VGND VPWR VGND sky130_ef_sc_hd__decap_12
XFILLER_86_485 VGND VGND VPWR VPWR sky130_fd_sc_hd__fill_1
XFILLER_74_636 VGND VGND VPWR VPWR sky130_fd_sc_hd__decap_8
X_09759_ _02581_ _04870_ VGND VGND VPWR VPWR _04874_ sky130_fd_sc_hd__or2_4
XFILLER_70_820 VPWR VGND VPWR VGND sky130_ef_sc_hd__decap_12
XFILLER_64_78 VGND VGND VPWR VPWR sky130_fd_sc_hd__decap_6
XFILLER_15_725 VGND VGND VPWR VPWR sky130_fd_sc_hd__decap_3
XTAP_TAPCELL_ROW_83_1659 VGND VPWR sky130_fd_sc_hd__tapvpwrvgnd_1
XTAP_TAPCELL_ROW_25_731 VGND VPWR sky130_fd_sc_hd__tapvpwrvgnd_1
XFILLER_42_533 VGND VGND VPWR VPWR sky130_fd_sc_hd__decap_6
X_10603_ clknet_leaf_80_clk _00733_ VGND VGND VPWR VPWR count_cycle\[26\] sky130_fd_sc_hd__dfxtp_1
XFILLER_128_627 VGND VGND VPWR VPWR sky130_fd_sc_hd__fill_1
XFILLER_80_77 VGND VGND VPWR VPWR sky130_fd_sc_hd__decap_6
XFILLER_10_430 VGND VGND VPWR VPWR sky130_fd_sc_hd__decap_4
XFILLER_127_137 VGND VGND VPWR VPWR sky130_fd_sc_hd__decap_4
XFILLER_109_841 VGND VGND VPWR VPWR sky130_fd_sc_hd__decap_8
X_10534_ clknet_leaf_91_clk _00664_ VGND VGND VPWR VPWR reg_pc\[20\] sky130_fd_sc_hd__dfxtp_1
XFILLER_10_474 VGND VGND VPWR VPWR sky130_fd_sc_hd__fill_2
XFILLER_124_811 VGND VGND VPWR VPWR sky130_fd_sc_hd__fill_1
XFILLER_108_362 VGND VGND VPWR VPWR sky130_fd_sc_hd__fill_2
XFILLER_89_31 VGND VGND VPWR VPWR sky130_fd_sc_hd__fill_1
X_10465_ clknet_leaf_86_clk _00595_ VGND VGND VPWR VPWR count_instr\[14\] sky130_fd_sc_hd__dfxtp_1
XTAP_TAPCELL_ROW_114_2158 VGND VPWR sky130_fd_sc_hd__tapvpwrvgnd_1
XFILLER_89_75 VPWR VGND VPWR VGND sky130_ef_sc_hd__decap_12
X_10396_ clknet_leaf_12_clk _00526_ VGND VGND VPWR VPWR cpuregs\[20\]\[10\] sky130_fd_sc_hd__dfxtp_1
XFILLER_145_81 VPWR VGND VPWR VGND sky130_ef_sc_hd__decap_12
XFILLER_1_161 VGND VGND VPWR VPWR sky130_fd_sc_hd__decap_6
XFILLER_150_195 VGND VGND VPWR VPWR sky130_fd_sc_hd__fill_1
XFILLER_96_249 VGND VGND VPWR VPWR sky130_fd_sc_hd__decap_3
X_11017_ clknet_leaf_23_clk _01079_ VGND VGND VPWR VPWR cpuregs\[19\]\[17\] sky130_fd_sc_hd__dfxtp_1
XFILLER_65_614 VGND VGND VPWR VPWR sky130_fd_sc_hd__fill_2
XTAP_TAPCELL_ROW_129_2390 VGND VPWR sky130_fd_sc_hd__tapvpwrvgnd_1
XFILLER_65_625 VGND VGND VPWR VPWR sky130_fd_sc_hd__decap_4
XFILLER_92_477 VGND VGND VPWR VPWR sky130_fd_sc_hd__decap_8
XFILLER_92_444 VPWR VGND VPWR VGND sky130_ef_sc_hd__decap_12
XFILLER_80_606 VGND VGND VPWR VPWR sky130_fd_sc_hd__fill_1
XFILLER_61_820 VGND VGND VPWR VPWR sky130_fd_sc_hd__fill_2
XFILLER_60_330 VGND VGND VPWR VPWR sky130_fd_sc_hd__fill_1
X_05440_ cpu_state\[3\] _02019_ _02020_ _02025_ VGND VGND VPWR VPWR _02026_ sky130_fd_sc_hd__a31o_1
X_05371_ _01957_ _01960_ VGND VGND VPWR VPWR _01962_ sky130_fd_sc_hd__xor2_1
X_07110_ _00014_ _03513_ _00016_ VGND VGND VPWR VPWR _03519_ sky130_fd_sc_hd__o21a_1
XFILLER_20_249 VGND VGND VPWR VPWR sky130_fd_sc_hd__decap_3
XFILLER_119_649 VGND VGND VPWR VPWR sky130_fd_sc_hd__fill_2
X_08090_ _01547_ reg_next_pc\[17\] _01645_ _03704_ VGND VGND VPWR VPWR _03906_ sky130_fd_sc_hd__a22o_1
Xclkload20 clknet_leaf_5_clk VGND VGND VPWR VPWR clkload20/Y sky130_fd_sc_hd__inv_8
X_07041_ _03448_ _03450_ _03451_ VGND VGND VPWR VPWR _03452_ sky130_fd_sc_hd__a21o_1
Xclkload53 clknet_leaf_30_clk VGND VGND VPWR VPWR clkload53/Y sky130_fd_sc_hd__inv_6
Xclkload42 clknet_leaf_133_clk VGND VGND VPWR VPWR clkload42/Y sky130_fd_sc_hd__inv_12
Xclkload31 clknet_leaf_140_clk VGND VGND VPWR VPWR clkload31/Y sky130_fd_sc_hd__inv_8
Xclkload75 clknet_leaf_47_clk VGND VGND VPWR VPWR clkload75/Y sky130_fd_sc_hd__inv_6
XFILLER_133_129 VPWR VGND VPWR VGND sky130_ef_sc_hd__decap_12
Xclkload64 clknet_leaf_19_clk VGND VGND VPWR VPWR clkload64/X sky130_fd_sc_hd__clkbuf_4
Xclkload86 clknet_leaf_126_clk VGND VGND VPWR VPWR clkload86/X sky130_fd_sc_hd__clkbuf_4
XTAP_TAPCELL_ROW_149_2711 VGND VPWR sky130_fd_sc_hd__tapvpwrvgnd_1
XFILLER_115_877 VPWR VGND VPWR VGND sky130_ef_sc_hd__decap_12
Xclkload97 clknet_leaf_113_clk VGND VGND VPWR VPWR clkload97/Y sky130_fd_sc_hd__inv_16
XTAP_TAPCELL_ROW_149_2722 VGND VPWR sky130_fd_sc_hd__tapvpwrvgnd_1
X_08992_ cpuregs\[8\]\[28\] cpuregs\[9\]\[28\] cpuregs\[10\]\[28\] cpuregs\[11\]\[28\]
+ net280 net271 VGND VGND VPWR VPWR _04666_ sky130_fd_sc_hd__mux4_1
XFILLER_130_825 VPWR VGND VPWR VGND sky130_ef_sc_hd__decap_12
XFILLER_114_365 VGND VGND VPWR VPWR sky130_fd_sc_hd__fill_2
XFILLER_130_869 VPWR VGND VPWR VGND sky130_ef_sc_hd__decap_12
X_07943_ _03693_ _03758_ VGND VGND VPWR VPWR _03770_ sky130_fd_sc_hd__nor2_1
X_07874_ reg_pc\[25\] _01624_ _01628_ _03712_ VGND VGND VPWR VPWR _00669_ sky130_fd_sc_hd__a22o_1
XFILLER_96_772 VGND VGND VPWR VPWR sky130_fd_sc_hd__decap_8
XFILLER_29_806 VPWR VGND VPWR VGND sky130_ef_sc_hd__decap_12
X_09613_ _02662_ cpuregs\[3\]\[19\] _04868_ VGND VGND VPWR VPWR _01273_ sky130_fd_sc_hd__mux2_1
X_06825_ net177 _02721_ _02744_ _03243_ VGND VGND VPWR VPWR _03244_ sky130_fd_sc_hd__o211a_1
XFILLER_18_27 VGND VGND VPWR VPWR sky130_fd_sc_hd__fill_1
XFILLER_141_39 VPWR VGND VPWR VGND sky130_ef_sc_hd__decap_12
XFILLER_71_617 VPWR VGND VPWR VGND sky130_ef_sc_hd__decap_12
X_09544_ cpuregs\[23\]\[16\] _02649_ _04866_ VGND VGND VPWR VPWR _01206_ sky130_fd_sc_hd__mux2_1
X_06756_ _01579_ _03177_ VGND VGND VPWR VPWR _03178_ sky130_fd_sc_hd__or2_1
XFILLER_55_179 VGND VGND VPWR VPWR sky130_fd_sc_hd__decap_3
X_06687_ net175 net177 _02721_ VGND VGND VPWR VPWR _03111_ sky130_fd_sc_hd__mux2_1
X_09475_ cpuregs\[24\]\[13\] _02638_ net242 VGND VGND VPWR VPWR _01139_ sky130_fd_sc_hd__mux2_1
XFILLER_70_138 VGND VGND VPWR VPWR sky130_fd_sc_hd__fill_2
XFILLER_64_691 VGND VGND VPWR VPWR sky130_fd_sc_hd__fill_1
X_05707_ _02160_ _02282_ VGND VGND VPWR VPWR _02283_ sky130_fd_sc_hd__xor2_1
XFILLER_24_533 VGND VGND VPWR VPWR sky130_fd_sc_hd__decap_3
XFILLER_34_15 VPWR VGND VPWR VGND sky130_ef_sc_hd__decap_12
X_08426_ _01549_ _04165_ VGND VGND VPWR VPWR _04166_ sky130_fd_sc_hd__nor2_1
X_05638_ _02082_ _02083_ _02220_ VGND VGND VPWR VPWR _02221_ sky130_fd_sc_hd__o21ai_1
XTAP_TAPCELL_ROW_65_1378 VGND VPWR sky130_fd_sc_hd__tapvpwrvgnd_1
XTAP_TAPCELL_ROW_65_1367 VGND VPWR sky130_fd_sc_hd__tapvpwrvgnd_1
XFILLER_137_402 VGND VGND VPWR VPWR sky130_fd_sc_hd__decap_6
Xclkload3 clknet_4_4_0_clk VGND VGND VPWR VPWR clkload3/X sky130_fd_sc_hd__clkbuf_8
X_05569_ _02150_ _02151_ VGND VGND VPWR VPWR _02152_ sky130_fd_sc_hd__nor2_1
X_08357_ count_cycle\[35\] net395 count_cycle\[36\] VGND VGND VPWR VPWR _04122_ sky130_fd_sc_hd__a21o_1
X_07308_ cpuregs\[28\]\[26\] _02691_ net249 VGND VGND VPWR VPWR _00254_ sky130_fd_sc_hd__mux2_1
X_08288_ _04077_ net34 _04076_ VGND VGND VPWR VPWR _00718_ sky130_fd_sc_hd__and3b_1
XFILLER_20_794 VPWR VGND VPWR VGND sky130_ef_sc_hd__decap_12
X_07239_ cpuregs\[13\]\[23\] _02678_ net251 VGND VGND VPWR VPWR _00187_ sky130_fd_sc_hd__mux2_1
XFILLER_4_905 VGND VGND VPWR VPWR sky130_fd_sc_hd__decap_4
X_10250_ clknet_leaf_64_clk _00380_ VGND VGND VPWR VPWR cpuregs\[27\]\[24\] sky130_fd_sc_hd__dfxtp_1
XFILLER_106_833 VPWR VGND VPWR VGND sky130_ef_sc_hd__decap_12
XFILLER_59_23 VPWR VGND VPWR VGND sky130_ef_sc_hd__decap_12
X_10181_ clknet_leaf_72_clk _00311_ VGND VGND VPWR VPWR cpuregs\[9\]\[19\] sky130_fd_sc_hd__dfxtp_1
XFILLER_132_195 VGND VGND VPWR VPWR sky130_fd_sc_hd__fill_1
XFILLER_120_335 VGND VGND VPWR VPWR sky130_fd_sc_hd__decap_8
XFILLER_87_783 VGND VGND VPWR VPWR sky130_fd_sc_hd__fill_1
XFILLER_59_452 VPWR VGND VPWR VGND sky130_ef_sc_hd__decap_12
XFILLER_115_95 VGND VGND VPWR VPWR sky130_fd_sc_hd__fill_1
XFILLER_75_55 VGND VGND VPWR VPWR sky130_fd_sc_hd__fill_1
XFILLER_75_77 VPWR VGND VPWR VGND sky130_ef_sc_hd__decap_12
XFILLER_75_66 VGND VGND VPWR VPWR sky130_fd_sc_hd__decap_8
XFILLER_28_861 VGND VGND VPWR VPWR sky130_fd_sc_hd__decap_6
XFILLER_35_809 VPWR VGND VPWR VGND sky130_ef_sc_hd__decap_12
XFILLER_15_500 VGND VGND VPWR VPWR sky130_fd_sc_hd__decap_4
XFILLER_46_179 VPWR VGND VPWR VGND sky130_ef_sc_hd__decap_12
XFILLER_27_393 VGND VGND VPWR VPWR sky130_fd_sc_hd__decap_4
XFILLER_70_661 VPWR VGND VPWR VGND sky130_ef_sc_hd__decap_12
XFILLER_43_875 VPWR VGND VPWR VGND sky130_ef_sc_hd__decap_12
XFILLER_43_897 VPWR VGND VPWR VGND sky130_ef_sc_hd__decap_12
XFILLER_11_783 VGND VGND VPWR VPWR sky130_fd_sc_hd__fill_1
XFILLER_6_253 VPWR VGND VPWR VGND sky130_ef_sc_hd__decap_12
X_10517_ clknet_leaf_129_clk _00647_ VGND VGND VPWR VPWR reg_pc\[3\] sky130_fd_sc_hd__dfxtp_1
XFILLER_143_449 VPWR VGND VPWR VGND sky130_ef_sc_hd__decap_12
X_11497_ clknet_leaf_135_clk _01541_ VGND VGND VPWR VPWR cpuregs\[10\]\[31\] sky130_fd_sc_hd__dfxtp_1
X_10448_ clknet_leaf_33_clk _00578_ VGND VGND VPWR VPWR cpuregs\[17\]\[30\] sky130_fd_sc_hd__dfxtp_1
XFILLER_151_471 VGND VGND VPWR VPWR sky130_fd_sc_hd__fill_1
X_10379_ clknet_leaf_67_clk _00509_ VGND VGND VPWR VPWR cpuregs\[25\]\[25\] sky130_fd_sc_hd__dfxtp_1
XFILLER_124_674 VGND VGND VPWR VPWR sky130_fd_sc_hd__decap_6
XFILLER_112_836 VGND VGND VPWR VPWR sky130_fd_sc_hd__decap_3
XFILLER_151_493 VGND VGND VPWR VPWR sky130_fd_sc_hd__decap_8
XFILLER_111_335 VGND VGND VPWR VPWR sky130_fd_sc_hd__fill_1
X_04940_ net124 VGND VGND VPWR VPWR _01573_ sky130_fd_sc_hd__inv_2
XTAP_TAPCELL_ROW_144_2641 VGND VPWR sky130_fd_sc_hd__tapvpwrvgnd_1
XTAP_TAPCELL_ROW_144_2630 VGND VPWR sky130_fd_sc_hd__tapvpwrvgnd_1
XFILLER_92_230 VPWR VGND VPWR VGND sky130_ef_sc_hd__decap_12
XFILLER_77_293 VPWR VGND VPWR VGND sky130_ef_sc_hd__decap_12
XFILLER_65_466 VGND VGND VPWR VPWR sky130_fd_sc_hd__decap_8
X_06610_ _03035_ _03036_ VGND VGND VPWR VPWR _03037_ sky130_fd_sc_hd__xor2_1
X_07590_ cpuregs\[20\]\[7\] _02612_ net245 VGND VGND VPWR VPWR _00523_ sky130_fd_sc_hd__mux2_1
X_06541_ cpuregs\[24\]\[8\] cpuregs\[25\]\[8\] cpuregs\[26\]\[8\] cpuregs\[27\]\[8\]
+ net263 net259 VGND VGND VPWR VPWR _02971_ sky130_fd_sc_hd__mux4_1
X_06472_ net198 _02721_ VGND VGND VPWR VPWR _02904_ sky130_fd_sc_hd__or2_1
X_09260_ net235 _01608_ _04802_ VGND VGND VPWR VPWR _04803_ sky130_fd_sc_hd__or3b_1
X_08211_ _01547_ reg_next_pc\[27\] _01645_ _03714_ VGND VGND VPWR VPWR _04017_ sky130_fd_sc_hd__a22o_1
X_05423_ net21 _01665_ _01856_ VGND VGND VPWR VPWR _02010_ sky130_fd_sc_hd__a21o_1
XFILLER_60_160 VPWR VGND VPWR VGND sky130_ef_sc_hd__decap_12
XTAP_TAPCELL_ROW_16_583 VGND VPWR sky130_fd_sc_hd__tapvpwrvgnd_1
XTAP_TAPCELL_ROW_16_594 VGND VPWR sky130_fd_sc_hd__tapvpwrvgnd_1
XFILLER_21_514 VGND VGND VPWR VPWR sky130_fd_sc_hd__fill_2
XTAP_TAPCELL_ROW_47_1086 VGND VPWR sky130_fd_sc_hd__tapvpwrvgnd_1
XFILLER_147_700 VPWR VGND VPWR VGND sky130_ef_sc_hd__decap_12
XFILLER_119_402 VGND VGND VPWR VPWR sky130_fd_sc_hd__decap_6
X_09191_ decoded_imm_j\[13\] _01107_ _02513_ VGND VGND VPWR VPWR _00894_ sky130_fd_sc_hd__mux2_1
XFILLER_21_558 VGND VGND VPWR VPWR sky130_fd_sc_hd__fill_2
X_08142_ net34 _03953_ VGND VGND VPWR VPWR _00696_ sky130_fd_sc_hd__and2_1
X_05354_ reg_pc\[22\] decoded_imm\[22\] _01934_ VGND VGND VPWR VPWR _01946_ sky130_fd_sc_hd__a21o_1
XTAP_TAPCELL_ROW_60_1286 VGND VPWR sky130_fd_sc_hd__tapvpwrvgnd_1
Xclkload120 clknet_leaf_69_clk VGND VGND VPWR VPWR clkload120/X sky130_fd_sc_hd__clkbuf_4
XFILLER_146_265 VGND VGND VPWR VPWR sky130_fd_sc_hd__decap_4
X_08073_ _03888_ _03889_ net34 VGND VGND VPWR VPWR _00691_ sky130_fd_sc_hd__o21a_1
X_05285_ count_cycle\[17\] _01588_ VGND VGND VPWR VPWR _01883_ sky130_fd_sc_hd__or2_1
Xclkload131 clknet_leaf_87_clk VGND VGND VPWR VPWR clkload131/Y sky130_fd_sc_hd__clkinv_4
XTAP_TAPCELL_ROW_60_1297 VGND VPWR sky130_fd_sc_hd__tapvpwrvgnd_1
X_07024_ cpuregs\[8\]\[26\] cpuregs\[9\]\[26\] cpuregs\[10\]\[26\] cpuregs\[11\]\[26\]
+ net266 net261 VGND VGND VPWR VPWR _03436_ sky130_fd_sc_hd__mux4_1
XFILLER_115_641 VGND VGND VPWR VPWR sky130_fd_sc_hd__decap_8
XFILLER_115_685 VGND VGND VPWR VPWR sky130_fd_sc_hd__fill_1
XFILLER_114_162 VGND VGND VPWR VPWR sky130_fd_sc_hd__decap_4
XFILLER_88_525 VGND VGND VPWR VPWR sky130_fd_sc_hd__decap_6
X_08975_ cpuregs\[24\]\[27\] cpuregs\[25\]\[27\] cpuregs\[26\]\[27\] cpuregs\[27\]\[27\]
+ net275 net271 VGND VGND VPWR VPWR _04650_ sky130_fd_sc_hd__mux4_1
XFILLER_103_869 VPWR VGND VPWR VGND sky130_ef_sc_hd__decap_12
XFILLER_29_15 VPWR VGND VPWR VGND sky130_ef_sc_hd__decap_12
XFILLER_152_27 VGND VGND VPWR VPWR sky130_fd_sc_hd__fill_1
XFILLER_88_569 VGND VGND VPWR VPWR sky130_fd_sc_hd__fill_1
X_07926_ _03742_ _03743_ _03744_ VGND VGND VPWR VPWR _03754_ sky130_fd_sc_hd__a21bo_1
XFILLER_75_219 VGND VGND VPWR VPWR sky130_fd_sc_hd__decap_4
XFILLER_69_794 VGND VGND VPWR VPWR sky130_fd_sc_hd__decap_4
X_07857_ _02650_ reg_next_pc\[17\] net597 VGND VGND VPWR VPWR _03704_ sky130_fd_sc_hd__mux2_2
XFILLER_72_904 VGND VGND VPWR VPWR sky130_fd_sc_hd__fill_1
XTAP_TAPCELL_ROW_67_1407 VGND VPWR sky130_fd_sc_hd__tapvpwrvgnd_1
XFILLER_56_455 VGND VGND VPWR VPWR sky130_fd_sc_hd__decap_8
XFILLER_17_809 VPWR VGND VPWR VGND sky130_ef_sc_hd__decap_12
X_06808_ cpuregs\[12\]\[18\] cpuregs\[13\]\[18\] cpuregs\[14\]\[18\] cpuregs\[15\]\[18\]
+ net265 net260 VGND VGND VPWR VPWR _03228_ sky130_fd_sc_hd__mux4_1
X_07788_ count_instr\[50\] _03663_ net34 VGND VGND VPWR VPWR _03665_ sky130_fd_sc_hd__o21ai_1
XFILLER_56_477 VGND VGND VPWR VPWR sky130_fd_sc_hd__decap_6
X_06739_ _03108_ _03133_ VGND VGND VPWR VPWR _03161_ sky130_fd_sc_hd__or2_1
XFILLER_71_447 VGND VGND VPWR VPWR sky130_fd_sc_hd__fill_1
XFILLER_25_853 VPWR VGND VPWR VGND sky130_ef_sc_hd__decap_12
X_09527_ latched_rd\[1\] latched_rd\[0\] _03572_ VGND VGND VPWR VPWR _04866_ sky130_fd_sc_hd__and3_4
XFILLER_37_691 VGND VGND VPWR VPWR sky130_fd_sc_hd__fill_1
XFILLER_101_31 VPWR VGND VPWR VGND sky130_ef_sc_hd__decap_12
XTAP_TAPCELL_ROW_80_1618 VGND VPWR sky130_fd_sc_hd__tapvpwrvgnd_1
XTAP_TAPCELL_ROW_80_1607 VGND VPWR sky130_fd_sc_hd__tapvpwrvgnd_1
X_09458_ _02704_ cpuregs\[19\]\[29\] _04863_ VGND VGND VPWR VPWR _01091_ sky130_fd_sc_hd__mux2_1
XFILLER_24_374 VGND VGND VPWR VPWR sky130_fd_sc_hd__decap_6
XFILLER_25_897 VGND VGND VPWR VPWR sky130_fd_sc_hd__decap_8
XTAP_TAPCELL_ROW_35_892 VGND VPWR sky130_fd_sc_hd__tapvpwrvgnd_1
X_08409_ count_cycle\[55\] _04153_ net34 VGND VGND VPWR VPWR _04155_ sky130_fd_sc_hd__o21ai_1
XFILLER_61_57 VPWR VGND VPWR VGND sky130_ef_sc_hd__decap_12
XFILLER_51_193 VPWR VGND VPWR VGND sky130_ef_sc_hd__decap_12
XFILLER_12_558 VGND VGND VPWR VPWR sky130_fd_sc_hd__decap_8
X_09389_ mem_rdata_q\[9\] _04822_ VGND VGND VPWR VPWR _04858_ sky130_fd_sc_hd__and2_1
XFILLER_138_755 VGND VGND VPWR VPWR sky130_fd_sc_hd__fill_1
X_11420_ clknet_leaf_53_clk _01464_ VGND VGND VPWR VPWR cpuregs\[8\]\[18\] sky130_fd_sc_hd__dfxtp_1
XFILLER_124_3 VPWR VGND VPWR VGND sky130_ef_sc_hd__decap_12
X_11351_ clknet_leaf_7_clk _01395_ VGND VGND VPWR VPWR cpuregs\[6\]\[13\] sky130_fd_sc_hd__dfxtp_1
XTAP_TAPCELL_ROW_95_1850 VGND VPWR sky130_fd_sc_hd__tapvpwrvgnd_1
X_10302_ clknet_leaf_11_clk _00432_ VGND VGND VPWR VPWR cpuregs\[26\]\[12\] sky130_fd_sc_hd__dfxtp_1
XFILLER_4_713 VPWR VGND VPWR VGND sky130_ef_sc_hd__decap_12
XFILLER_153_769 VGND VGND VPWR VPWR sky130_fd_sc_hd__decap_4
XFILLER_125_449 VPWR VGND VPWR VGND sky130_ef_sc_hd__decap_12
XFILLER_118_490 VGND VGND VPWR VPWR sky130_fd_sc_hd__fill_1
XTAP_TAPCELL_ROW_111_2106 VGND VPWR sky130_fd_sc_hd__tapvpwrvgnd_1
XFILLER_106_652 VGND VGND VPWR VPWR sky130_fd_sc_hd__decap_8
XFILLER_4_757 VPWR VGND VPWR VGND sky130_ef_sc_hd__decap_12
XFILLER_3_223 VGND VGND VPWR VPWR sky130_fd_sc_hd__fill_1
X_11282_ clknet_leaf_149_clk _01329_ VGND VGND VPWR VPWR cpuregs\[4\]\[11\] sky130_fd_sc_hd__dfxtp_1
XFILLER_106_685 VPWR VGND VPWR VGND sky130_ef_sc_hd__decap_12
XFILLER_106_663 VGND VGND VPWR VPWR sky130_fd_sc_hd__fill_1
X_10233_ clknet_leaf_145_clk _00363_ VGND VGND VPWR VPWR cpuregs\[27\]\[7\] sky130_fd_sc_hd__dfxtp_1
XFILLER_120_121 VGND VGND VPWR VPWR sky130_fd_sc_hd__decap_8
XFILLER_105_195 VGND VGND VPWR VPWR sky130_fd_sc_hd__decap_4
XFILLER_10_83 VGND VGND VPWR VPWR sky130_fd_sc_hd__fill_1
X_10164_ clknet_leaf_119_clk _00294_ VGND VGND VPWR VPWR cpuregs\[9\]\[2\] sky130_fd_sc_hd__dfxtp_1
XFILLER_126_94 VGND VGND VPWR VPWR sky130_fd_sc_hd__decap_3
XFILLER_121_655 VGND VGND VPWR VPWR sky130_fd_sc_hd__fill_1
X_10095_ clknet_leaf_32_clk _00225_ VGND VGND VPWR VPWR cpuregs\[2\]\[29\] sky130_fd_sc_hd__dfxtp_1
XFILLER_19_113 VGND VGND VPWR VPWR sky130_fd_sc_hd__decap_3
XTAP_TAPCELL_ROW_109_2079 VGND VPWR sky130_fd_sc_hd__tapvpwrvgnd_1
XTAP_TAPCELL_ROW_109_2068 VGND VPWR sky130_fd_sc_hd__tapvpwrvgnd_1
XFILLER_19_81 VPWR VGND VPWR VGND sky130_ef_sc_hd__decap_12
XFILLER_19_146 VGND VGND VPWR VPWR sky130_fd_sc_hd__decap_3
XFILLER_47_444 VGND VGND VPWR VPWR sky130_fd_sc_hd__decap_4
XFILLER_142_93 VGND VGND VPWR VPWR sky130_fd_sc_hd__decap_3
XFILLER_90_701 VGND VGND VPWR VPWR sky130_fd_sc_hd__decap_6
XFILLER_62_414 VGND VGND VPWR VPWR sky130_fd_sc_hd__decap_6
XTAP_TAPCELL_ROW_122_2279 VGND VPWR sky130_fd_sc_hd__tapvpwrvgnd_1
X_10997_ clknet_leaf_30_clk _01059_ VGND VGND VPWR VPWR cpuregs\[18\]\[29\] sky130_fd_sc_hd__dfxtp_1
XTAP_TAPCELL_ROW_104_1990 VGND VPWR sky130_fd_sc_hd__tapvpwrvgnd_1
XTAP_TAPCELL_ROW_13_542 VGND VPWR sky130_fd_sc_hd__tapvpwrvgnd_1
XFILLER_31_889 VGND VGND VPWR VPWR sky130_fd_sc_hd__decap_6
XFILLER_7_551 VGND VGND VPWR VPWR sky130_fd_sc_hd__decap_8
XFILLER_128_298 VGND VGND VPWR VPWR sky130_fd_sc_hd__decap_8
XFILLER_128_265 VPWR VGND VPWR VGND sky130_ef_sc_hd__decap_12
XFILLER_144_769 VPWR VGND VPWR VGND sky130_ef_sc_hd__decap_12
XFILLER_143_246 VGND VGND VPWR VPWR sky130_fd_sc_hd__fill_1
X_05070_ count_instr\[33\] instr_rdinstrh instr_rdinstr count_instr\[1\] VGND VGND
+ VPWR VPWR _01684_ sky130_fd_sc_hd__a22o_1
Xmax_cap248 _03562_ VGND VGND VPWR VPWR net248 sky130_fd_sc_hd__buf_12
XFILLER_97_333 VGND VGND VPWR VPWR sky130_fd_sc_hd__decap_3
XFILLER_98_889 VGND VGND VPWR VPWR sky130_fd_sc_hd__decap_6
XFILLER_97_355 VGND VGND VPWR VPWR sky130_fd_sc_hd__decap_4
XFILLER_39_901 VGND VGND VPWR VPWR sky130_fd_sc_hd__fill_1
X_08760_ cpuregs\[12\]\[15\] cpuregs\[13\]\[15\] cpuregs\[14\]\[15\] cpuregs\[15\]\[15\]
+ net275 net271 VGND VGND VPWR VPWR _04447_ sky130_fd_sc_hd__mux4_1
XFILLER_66_731 VGND VGND VPWR VPWR sky130_fd_sc_hd__fill_2
X_05972_ net201 _02489_ _01582_ VGND VGND VPWR VPWR net94 sky130_fd_sc_hd__mux2_1
X_07711_ count_instr\[22\] _03610_ _03614_ VGND VGND VPWR VPWR _03616_ sky130_fd_sc_hd__and3_1
X_04923_ mem_rdata_q\[14\] VGND VGND VPWR VPWR _01556_ sky130_fd_sc_hd__inv_2
X_08691_ _01558_ _04373_ _00010_ VGND VGND VPWR VPWR _04382_ sky130_fd_sc_hd__o21a_1
X_07642_ _02691_ cpuregs\[17\]\[26\] _03574_ VGND VGND VPWR VPWR _00574_ sky130_fd_sc_hd__mux2_1
XFILLER_93_561 VGND VGND VPWR VPWR sky130_fd_sc_hd__decap_4
XTAP_TAPCELL_ROW_49_1115 VGND VPWR sky130_fd_sc_hd__tapvpwrvgnd_1
XFILLER_38_466 VGND VGND VPWR VPWR sky130_fd_sc_hd__decap_4
XFILLER_38_477 VGND VGND VPWR VPWR sky130_fd_sc_hd__fill_2
X_07573_ cpuregs\[25\]\[24\] _02683_ _03571_ VGND VGND VPWR VPWR _00508_ sky130_fd_sc_hd__mux2_1
XFILLER_15_39 VPWR VGND VPWR VGND sky130_ef_sc_hd__decap_12
X_09312_ latched_rd\[0\] _04815_ _04816_ decoded_rd\[0\] VGND VGND VPWR VPWR _00992_
+ sky130_fd_sc_hd__a22o_1
XTAP_TAPCELL_ROW_62_1326 VGND VPWR sky130_fd_sc_hd__tapvpwrvgnd_1
XFILLER_33_160 VGND VGND VPWR VPWR sky130_fd_sc_hd__decap_8
X_06524_ _02872_ _02876_ _02877_ _02900_ _02927_ VGND VGND VPWR VPWR _02954_ sky130_fd_sc_hd__a311oi_4
X_09243_ cpuregs\[1\]\[22\] _02675_ net244 VGND VGND VPWR VPWR _00940_ sky130_fd_sc_hd__mux2_1
X_06455_ cpuregs\[0\]\[5\] cpuregs\[1\]\[5\] cpuregs\[2\]\[5\] cpuregs\[3\]\[5\] net268
+ net262 VGND VGND VPWR VPWR _02888_ sky130_fd_sc_hd__mux4_1
XFILLER_22_867 VGND VGND VPWR VPWR sky130_fd_sc_hd__fill_1
XTAP_TAPCELL_ROW_32_840 VGND VPWR sky130_fd_sc_hd__tapvpwrvgnd_1
XTAP_TAPCELL_ROW_32_851 VGND VPWR sky130_fd_sc_hd__tapvpwrvgnd_1
X_05406_ _01981_ _01984_ _01993_ VGND VGND VPWR VPWR _01994_ sky130_fd_sc_hd__a21o_1
X_09174_ net34 mem_rdata_q\[0\] mem_rdata_q\[1\] mem_rdata_q\[2\] VGND VGND VPWR VPWR
+ _04789_ sky130_fd_sc_hd__and4_1
X_06386_ _02812_ _02813_ _02814_ net258 VGND VGND VPWR VPWR _02821_ sky130_fd_sc_hd__a22o_1
X_08125_ _03936_ _03937_ net34 VGND VGND VPWR VPWR _00695_ sky130_fd_sc_hd__o21a_1
X_05337_ _01674_ _01929_ _01930_ net184 cpu_state\[4\] VGND VGND VPWR VPWR _01931_
+ sky130_fd_sc_hd__a32o_1
XFILLER_31_27 VPWR VGND VPWR VGND sky130_ef_sc_hd__decap_12
XFILLER_147_27 VPWR VGND VPWR VGND sky130_ef_sc_hd__decap_12
XFILLER_135_725 VGND VGND VPWR VPWR sky130_fd_sc_hd__decap_3
XFILLER_134_202 VGND VGND VPWR VPWR sky130_fd_sc_hd__fill_1
XFILLER_123_909 VGND VGND VPWR VPWR sky130_fd_sc_hd__decap_3
XFILLER_107_449 VPWR VGND VPWR VGND sky130_ef_sc_hd__decap_12
X_08056_ _03702_ _03862_ VGND VGND VPWR VPWR _03874_ sky130_fd_sc_hd__and2_1
X_05268_ _01851_ _01853_ _01852_ VGND VGND VPWR VPWR _01867_ sky130_fd_sc_hd__a21boi_2
Xoutput49 net49 VGND VGND VPWR VPWR mem_addr[24] sky130_fd_sc_hd__buf_2
XFILLER_150_728 VPWR VGND VPWR VGND sky130_ef_sc_hd__decap_12
X_07007_ _00015_ _03416_ _03419_ _02735_ VGND VGND VPWR VPWR _03420_ sky130_fd_sc_hd__o211a_1
Xoutput38 net38 VGND VGND VPWR VPWR mem_addr[13] sky130_fd_sc_hd__buf_2
X_05199_ _01801_ _01802_ VGND VGND VPWR VPWR _01803_ sky130_fd_sc_hd__xnor2_2
XFILLER_1_727 VGND VGND VPWR VPWR sky130_fd_sc_hd__fill_1
Xpicorv32_282 VGND VGND VPWR VPWR picorv32_282/HI eoi[1] sky130_fd_sc_hd__conb_1
XFILLER_103_644 VPWR VGND VPWR VGND sky130_ef_sc_hd__decap_12
XFILLER_0_237 VPWR VGND VPWR VGND sky130_ef_sc_hd__decap_12
Xpicorv32_293 VGND VGND VPWR VPWR picorv32_293/HI eoi[12] sky130_fd_sc_hd__conb_1
XFILLER_102_154 VGND VGND VPWR VPWR sky130_fd_sc_hd__decap_3
XTAP_TAPCELL_ROW_73_1499 VGND VPWR sky130_fd_sc_hd__tapvpwrvgnd_1
X_08958_ cpuregs\[4\]\[26\] cpuregs\[5\]\[26\] cpuregs\[6\]\[26\] cpuregs\[7\]\[26\]
+ net280 net274 VGND VGND VPWR VPWR _04634_ sky130_fd_sc_hd__mux4_1
XFILLER_29_422 VGND VGND VPWR VPWR sky130_fd_sc_hd__decap_4
X_08889_ _04560_ _04561_ _04564_ _04565_ _01558_ _01559_ VGND VGND VPWR VPWR _04569_
+ sky130_fd_sc_hd__mux4_1
XFILLER_56_230 VGND VGND VPWR VPWR sky130_fd_sc_hd__fill_1
X_07909_ _03735_ _03736_ _01551_ VGND VGND VPWR VPWR _03739_ sky130_fd_sc_hd__a21o_1
X_10920_ clknet_leaf_29_clk _00982_ VGND VGND VPWR VPWR net153 sky130_fd_sc_hd__dfxtp_1
XFILLER_72_701 VPWR VGND VPWR VGND sky130_ef_sc_hd__decap_12
XPHY_EDGE_ROW_16_Left_170 VGND VGND VPWR VPWR sky130_fd_sc_hd__decap_3
XFILLER_112_41 VGND VGND VPWR VPWR sky130_fd_sc_hd__decap_8
XFILLER_71_222 VGND VGND VPWR VPWR sky130_fd_sc_hd__fill_2
X_10851_ clknet_leaf_102_clk _00915_ VGND VGND VPWR VPWR is_sb_sh_sw sky130_fd_sc_hd__dfxtp_2
XFILLER_25_650 VGND VGND VPWR VPWR sky130_fd_sc_hd__decap_8
X_10782_ clknet_leaf_99_clk _00847_ VGND VGND VPWR VPWR instr_beq sky130_fd_sc_hd__dfxtp_1
XFILLER_12_300 VGND VGND VPWR VPWR sky130_fd_sc_hd__decap_8
XFILLER_13_889 VGND VGND VPWR VPWR sky130_fd_sc_hd__decap_6
XFILLER_40_697 VGND VGND VPWR VPWR sky130_fd_sc_hd__decap_3
XFILLER_138_530 VGND VGND VPWR VPWR sky130_fd_sc_hd__fill_2
X_11403_ clknet_leaf_117_clk _01447_ VGND VGND VPWR VPWR cpuregs\[8\]\[1\] sky130_fd_sc_hd__dfxtp_1
XFILLER_126_747 VGND VGND VPWR VPWR sky130_fd_sc_hd__decap_8
X_11334_ clknet_leaf_135_clk _01381_ VGND VGND VPWR VPWR cpuregs\[5\]\[31\] sky130_fd_sc_hd__dfxtp_1
X_11265_ clknet_leaf_44_clk _01312_ VGND VGND VPWR VPWR cpuregs\[22\]\[26\] sky130_fd_sc_hd__dfxtp_1
X_10216_ clknet_leaf_49_clk _00346_ VGND VGND VPWR VPWR cpuregs\[14\]\[22\] sky130_fd_sc_hd__dfxtp_1
XFILLER_4_598 VGND VGND VPWR VPWR sky130_fd_sc_hd__decap_8
XFILLER_4_587 VGND VGND VPWR VPWR sky130_fd_sc_hd__fill_1
X_11196_ clknet_leaf_80_clk _01243_ VGND VGND VPWR VPWR cpuregs\[29\]\[21\] sky130_fd_sc_hd__dfxtp_1
X_10147_ clknet_leaf_22_clk _00277_ VGND VGND VPWR VPWR cpuregs\[21\]\[17\] sky130_fd_sc_hd__dfxtp_1
XFILLER_153_81 VGND VGND VPWR VPWR sky130_fd_sc_hd__decap_3
XTAP_TAPCELL_ROW_124_2319 VGND VPWR sky130_fd_sc_hd__tapvpwrvgnd_1
XTAP_TAPCELL_ROW_124_2308 VGND VPWR sky130_fd_sc_hd__tapvpwrvgnd_1
XFILLER_94_369 VGND VGND VPWR VPWR sky130_fd_sc_hd__fill_1
XFILLER_82_509 VGND VGND VPWR VPWR sky130_fd_sc_hd__decap_8
X_10078_ clknet_leaf_6_clk _00208_ VGND VGND VPWR VPWR cpuregs\[2\]\[12\] sky130_fd_sc_hd__dfxtp_1
XFILLER_75_583 VPWR VGND VPWR VGND sky130_ef_sc_hd__decap_12
XFILLER_75_561 VGND VGND VPWR VPWR sky130_fd_sc_hd__decap_6
XFILLER_47_274 VGND VGND VPWR VPWR sky130_fd_sc_hd__decap_6
XTAP_TAPCELL_ROW_18_612 VGND VPWR sky130_fd_sc_hd__tapvpwrvgnd_1
XTAP_TAPCELL_ROW_18_623 VGND VPWR sky130_fd_sc_hd__tapvpwrvgnd_1
XFILLER_16_661 VGND VGND VPWR VPWR sky130_fd_sc_hd__fill_1
XFILLER_23_609 VGND VGND VPWR VPWR sky130_fd_sc_hd__decap_6
XFILLER_62_277 VGND VGND VPWR VPWR sky130_fd_sc_hd__decap_8
XFILLER_149_839 VGND VGND VPWR VPWR sky130_fd_sc_hd__fill_1
XFILLER_148_305 VGND VGND VPWR VPWR sky130_fd_sc_hd__decap_3
Xclkbuf_0_clk clk VGND VGND VPWR VPWR clknet_0_clk sky130_fd_sc_hd__clkbuf_16
XTAP_TAPCELL_ROW_44_1034 VGND VPWR sky130_fd_sc_hd__tapvpwrvgnd_1
XTAP_TAPCELL_ROW_139_2562 VGND VPWR sky130_fd_sc_hd__tapvpwrvgnd_1
XTAP_TAPCELL_ROW_139_2551 VGND VPWR sky130_fd_sc_hd__tapvpwrvgnd_1
X_06240_ reg_pc\[25\] _02681_ VGND VGND VPWR VPWR _02685_ sky130_fd_sc_hd__nor2_1
XFILLER_30_141 VPWR VGND VPWR VGND sky130_ef_sc_hd__decap_12
XFILLER_30_185 VGND VGND VPWR VPWR sky130_fd_sc_hd__decap_8
X_06171_ _02583_ _02625_ _02626_ _02628_ VGND VGND VPWR VPWR _02630_ sky130_fd_sc_hd__a22o_4
XFILLER_7_51 VGND VGND VPWR VPWR sky130_fd_sc_hd__decap_4
XTAP_TAPCELL_ROW_152_2762 VGND VPWR sky130_fd_sc_hd__tapvpwrvgnd_1
XFILLER_105_909 VGND VGND VPWR VPWR sky130_fd_sc_hd__decap_3
X_05122_ cpu_state\[4\] net198 _01731_ cpu_state\[6\] net256 VGND VGND VPWR VPWR _01732_
+ sky130_fd_sc_hd__a221o_1
XFILLER_8_893 VPWR VGND VPWR VGND sky130_ef_sc_hd__decap_12
XFILLER_7_381 VGND VGND VPWR VPWR sky130_fd_sc_hd__decap_8
XFILLER_144_577 VGND VGND VPWR VPWR sky130_fd_sc_hd__decap_8
X_09930_ clknet_leaf_40_clk _00065_ VGND VGND VPWR VPWR cpuregs\[11\]\[28\] sky130_fd_sc_hd__dfxtp_1
XFILLER_117_19 VPWR VGND VPWR VGND sky130_ef_sc_hd__decap_12
XFILLER_104_408 VGND VGND VPWR VPWR sky130_fd_sc_hd__decap_6
X_05053_ _01553_ mem_wordsize\[2\] _01666_ VGND VGND VPWR VPWR _01669_ sky130_fd_sc_hd__o21a_2
XPHY_EDGE_ROW_15_Right_15 VGND VGND VPWR VPWR sky130_fd_sc_hd__decap_3
XFILLER_98_664 VGND VGND VPWR VPWR sky130_fd_sc_hd__fill_1
X_09861_ decoded_imm_j\[19\] _01113_ _02513_ VGND VGND VPWR VPWR _00896_ sky130_fd_sc_hd__mux2_1
X_08812_ cpuregs\[4\]\[18\] cpuregs\[5\]\[18\] cpuregs\[6\]\[18\] cpuregs\[7\]\[18\]
+ net277 net272 VGND VGND VPWR VPWR _04496_ sky130_fd_sc_hd__mux4_1
X_09792_ _02579_ _03550_ VGND VGND VPWR VPWR _04875_ sky130_fd_sc_hd__or2_4
X_05955_ net224 _01665_ _02479_ VGND VGND VPWR VPWR net118 sky130_fd_sc_hd__a21o_1
X_08743_ cpuregs\[8\]\[14\] cpuregs\[9\]\[14\] cpuregs\[10\]\[14\] cpuregs\[11\]\[14\]
+ net275 net271 VGND VGND VPWR VPWR _04431_ sky130_fd_sc_hd__mux4_1
XFILLER_94_881 VGND VGND VPWR VPWR sky130_fd_sc_hd__fill_1
XFILLER_66_550 VGND VGND VPWR VPWR sky130_fd_sc_hd__decap_8
XFILLER_54_701 VPWR VGND VPWR VGND sky130_ef_sc_hd__decap_12
X_05886_ _02065_ _02441_ VGND VGND VPWR VPWR _02442_ sky130_fd_sc_hd__xnor2_1
X_08674_ _04356_ _04357_ _01558_ VGND VGND VPWR VPWR _04366_ sky130_fd_sc_hd__mux2_1
XFILLER_26_27 VGND VGND VPWR VPWR sky130_fd_sc_hd__fill_1
XTAP_TAPCELL_ROW_37_921 VGND VPWR sky130_fd_sc_hd__tapvpwrvgnd_1
XFILLER_38_274 VGND VGND VPWR VPWR sky130_fd_sc_hd__decap_8
XFILLER_81_553 VGND VGND VPWR VPWR sky130_fd_sc_hd__decap_6
XFILLER_53_255 VGND VGND VPWR VPWR sky130_fd_sc_hd__fill_1
XPHY_EDGE_ROW_24_Right_24 VGND VGND VPWR VPWR sky130_fd_sc_hd__decap_3
X_07625_ _02621_ cpuregs\[17\]\[9\] _03574_ VGND VGND VPWR VPWR _00557_ sky130_fd_sc_hd__mux2_1
XFILLER_13_108 VGND VGND VPWR VPWR sky130_fd_sc_hd__decap_4
X_07556_ cpuregs\[25\]\[7\] _02612_ _03571_ VGND VGND VPWR VPWR _00491_ sky130_fd_sc_hd__mux2_1
X_06507_ cpuregs\[0\]\[7\] cpuregs\[1\]\[7\] cpuregs\[2\]\[7\] cpuregs\[3\]\[7\] net268
+ net259 VGND VGND VPWR VPWR _02938_ sky130_fd_sc_hd__mux4_1
XFILLER_42_15 VPWR VGND VPWR VGND sky130_ef_sc_hd__decap_12
X_09226_ cpuregs\[1\]\[5\] _02603_ net244 VGND VGND VPWR VPWR _00923_ sky130_fd_sc_hd__mux2_1
X_07487_ cpuregs\[26\]\[5\] _02603_ _03568_ VGND VGND VPWR VPWR _00425_ sky130_fd_sc_hd__mux2_1
XFILLER_148_861 VGND VGND VPWR VPWR sky130_fd_sc_hd__decap_6
XFILLER_139_349 VGND VGND VPWR VPWR sky130_fd_sc_hd__decap_6
XFILLER_10_837 VPWR VGND VPWR VGND sky130_ef_sc_hd__decap_12
X_06438_ net197 _02725_ _02860_ _02871_ VGND VGND VPWR VPWR _00073_ sky130_fd_sc_hd__a22o_1
X_09157_ mem_rdata_q\[31\] _04746_ VGND VGND VPWR VPWR _04775_ sky130_fd_sc_hd__nand2_1
XFILLER_5_329 VGND VGND VPWR VPWR sky130_fd_sc_hd__decap_6
X_06369_ cpu_state\[4\] net200 _02721_ _01641_ VGND VGND VPWR VPWR _02804_ sky130_fd_sc_hd__a31o_1
X_08108_ _03919_ _03921_ VGND VGND VPWR VPWR _03922_ sky130_fd_sc_hd__xor2_1
X_09088_ _02513_ _01100_ _04743_ VGND VGND VPWR VPWR _04744_ sky130_fd_sc_hd__and3_1
X_08039_ _03856_ _03857_ VGND VGND VPWR VPWR _03858_ sky130_fd_sc_hd__nand2_1
XTAP_TAPCELL_ROW_75_1539 VGND VPWR sky130_fd_sc_hd__tapvpwrvgnd_1
XTAP_TAPCELL_ROW_75_1528 VGND VPWR sky130_fd_sc_hd__tapvpwrvgnd_1
XPHY_EDGE_ROW_33_Right_33 VGND VGND VPWR VPWR sky130_fd_sc_hd__decap_3
XFILLER_150_525 VGND VGND VPWR VPWR sky130_fd_sc_hd__decap_6
XFILLER_107_74 VPWR VGND VPWR VGND sky130_ef_sc_hd__decap_12
XFILLER_107_52 VGND VGND VPWR VPWR sky130_fd_sc_hd__decap_4
XFILLER_88_141 VGND VGND VPWR VPWR sky130_fd_sc_hd__decap_4
X_11050_ clknet_leaf_103_clk _01107_ VGND VGND VPWR VPWR mem_rdata_q\[13\] sky130_fd_sc_hd__dfxtp_2
X_10001_ clknet_leaf_14_clk _00131_ VGND VGND VPWR VPWR cpuregs\[12\]\[31\] sky130_fd_sc_hd__dfxtp_1
XFILLER_123_51 VGND VGND VPWR VPWR sky130_fd_sc_hd__decap_4
XTAP_TAPCELL_ROW_106_2027 VGND VPWR sky130_fd_sc_hd__tapvpwrvgnd_1
XFILLER_29_252 VGND VGND VPWR VPWR sky130_fd_sc_hd__fill_1
XFILLER_83_33 VPWR VGND VPWR VGND sky130_ef_sc_hd__decap_12
XFILLER_57_583 VGND VGND VPWR VPWR sky130_fd_sc_hd__decap_8
XTAP_TAPCELL_ROW_4_395 VGND VPWR sky130_fd_sc_hd__tapvpwrvgnd_1
XPHY_EDGE_ROW_42_Right_42 VGND VGND VPWR VPWR sky130_fd_sc_hd__decap_3
XFILLER_72_553 VGND VGND VPWR VPWR sky130_fd_sc_hd__fill_1
X_10903_ clknet_leaf_7_clk _00965_ VGND VGND VPWR VPWR net166 sky130_fd_sc_hd__dfxtp_1
XFILLER_17_447 VGND VGND VPWR VPWR sky130_fd_sc_hd__fill_1
XFILLER_32_417 VGND VGND VPWR VPWR sky130_fd_sc_hd__decap_3
XFILLER_32_428 VGND VGND VPWR VPWR sky130_fd_sc_hd__decap_4
X_10834_ clknet_leaf_111_clk _00899_ VGND VGND VPWR VPWR decoded_rd\[1\] sky130_fd_sc_hd__dfxtp_1
X_10765_ clknet_leaf_92_clk alu_out\[18\] VGND VGND VPWR VPWR alu_out_q\[18\] sky130_fd_sc_hd__dfxtp_1
XFILLER_12_141 VGND VGND VPWR VPWR sky130_fd_sc_hd__decap_3
X_10696_ clknet_leaf_70_clk _00794_ VGND VGND VPWR VPWR net49 sky130_fd_sc_hd__dfxtp_1
XTAP_TAPCELL_ROW_23_692 VGND VPWR sky130_fd_sc_hd__tapvpwrvgnd_1
XPHY_EDGE_ROW_51_Right_51 VGND VGND VPWR VPWR sky130_fd_sc_hd__decap_3
XTAP_TAPCELL_ROW_134_2470 VGND VPWR sky130_fd_sc_hd__tapvpwrvgnd_1
XFILLER_126_533 VGND VGND VPWR VPWR sky130_fd_sc_hd__fill_1
XFILLER_5_841 VPWR VGND VPWR VGND sky130_ef_sc_hd__decap_12
XPHY_EDGE_ROW_136_Right_136 VGND VGND VPWR VPWR sky130_fd_sc_hd__decap_3
XTAP_TAPCELL_ROW_134_2481 VGND VPWR sky130_fd_sc_hd__tapvpwrvgnd_1
XFILLER_126_577 VGND VGND VPWR VPWR sky130_fd_sc_hd__decap_8
X_11317_ clknet_leaf_29_clk _01364_ VGND VGND VPWR VPWR cpuregs\[5\]\[14\] sky130_fd_sc_hd__dfxtp_1
XFILLER_153_385 VGND VGND VPWR VPWR sky130_fd_sc_hd__fill_1
X_11248_ clknet_leaf_0_clk _01295_ VGND VGND VPWR VPWR cpuregs\[22\]\[9\] sky130_fd_sc_hd__dfxtp_1
XFILLER_122_794 VPWR VGND VPWR VGND sky130_ef_sc_hd__decap_12
X_11179_ clknet_leaf_139_clk _01226_ VGND VGND VPWR VPWR cpuregs\[29\]\[4\] sky130_fd_sc_hd__dfxtp_1
XFILLER_79_196 VPWR VGND VPWR VGND sky130_ef_sc_hd__decap_12
XPHY_EDGE_ROW_60_Right_60 VGND VGND VPWR VPWR sky130_fd_sc_hd__decap_3
XFILLER_75_380 VGND VGND VPWR VPWR sky130_fd_sc_hd__fill_1
X_05740_ _02119_ _02240_ _02310_ _02311_ VGND VGND VPWR VPWR alu_out\[11\] sky130_fd_sc_hd__a211o_1
XFILLER_48_583 VGND VGND VPWR VPWR sky130_fd_sc_hd__decap_4
XFILLER_63_542 VGND VGND VPWR VPWR sky130_fd_sc_hd__fill_2
X_05671_ net607 net108 _02251_ VGND VGND VPWR VPWR _02252_ sky130_fd_sc_hd__o21ai_1
X_07410_ cpuregs\[14\]\[28\] _02699_ net247 VGND VGND VPWR VPWR _00352_ sky130_fd_sc_hd__mux2_1
XFILLER_91_895 VGND VGND VPWR VPWR sky130_fd_sc_hd__fill_1
X_08390_ count_cycle\[47\] count_cycle\[48\] _04139_ VGND VGND VPWR VPWR _04143_ sky130_fd_sc_hd__and3_1
XFILLER_51_726 VGND VGND VPWR VPWR sky130_fd_sc_hd__fill_2
XFILLER_23_428 VPWR VGND VPWR VGND sky130_ef_sc_hd__decap_12
X_07341_ cpuregs\[21\]\[25\] _02688_ net248 VGND VGND VPWR VPWR _00285_ sky130_fd_sc_hd__mux2_1
XFILLER_137_809 VPWR VGND VPWR VGND sky130_ef_sc_hd__decap_12
X_07272_ cpuregs\[2\]\[23\] _02678_ net250 VGND VGND VPWR VPWR _00219_ sky130_fd_sc_hd__mux2_1
XFILLER_117_500 VGND VGND VPWR VPWR sky130_fd_sc_hd__decap_4
X_06223_ reg_out\[22\] alu_out_q\[22\] net587 VGND VGND VPWR VPWR _02671_ sky130_fd_sc_hd__mux2_1
X_09011_ cpuregs\[24\]\[29\] cpuregs\[25\]\[29\] cpuregs\[26\]\[29\] cpuregs\[27\]\[29\]
+ net275 net271 VGND VGND VPWR VPWR _04684_ sky130_fd_sc_hd__mux4_1
XFILLER_12_29 VPWR VGND VPWR VGND sky130_ef_sc_hd__decap_12
XFILLER_145_853 VPWR VGND VPWR VGND sky130_ef_sc_hd__decap_12
XFILLER_129_393 VGND VGND VPWR VPWR sky130_fd_sc_hd__decap_3
XFILLER_128_29 VPWR VGND VPWR VGND sky130_ef_sc_hd__decap_12
X_06154_ _02614_ _02615_ _02583_ _02613_ VGND VGND VPWR VPWR _02616_ sky130_fd_sc_hd__a2bb2o_4
XFILLER_145_897 VPWR VGND VPWR VGND sky130_ef_sc_hd__decap_12
XFILLER_117_555 VGND VGND VPWR VPWR sky130_fd_sc_hd__decap_4
XPHY_EDGE_ROW_103_Right_103 VGND VGND VPWR VPWR sky130_fd_sc_hd__decap_3
XTAP_TAPCELL_ROW_57_1236 VGND VPWR sky130_fd_sc_hd__tapvpwrvgnd_1
X_05105_ _01715_ VGND VGND VPWR VPWR _01716_ sky130_fd_sc_hd__inv_2
XTAP_TAPCELL_ROW_57_1247 VGND VPWR sky130_fd_sc_hd__tapvpwrvgnd_1
X_06085_ is_slli_srli_srai _02556_ VGND VGND VPWR VPWR _02557_ sky130_fd_sc_hd__nor2_1
XFILLER_104_249 VGND VGND VPWR VPWR sky130_fd_sc_hd__decap_3
X_05036_ is_sll_srl_sra is_sb_sh_sw VGND VGND VPWR VPWR _01657_ sky130_fd_sc_hd__nor2_1
X_09913_ clknet_leaf_0_clk _00048_ VGND VGND VPWR VPWR cpuregs\[11\]\[11\] sky130_fd_sc_hd__dfxtp_1
XFILLER_113_772 VPWR VGND VPWR VGND sky130_ef_sc_hd__decap_12
X_09844_ _02657_ cpuregs\[10\]\[18\] _04876_ VGND VGND VPWR VPWR _01528_ sky130_fd_sc_hd__mux2_1
XFILLER_98_483 VGND VGND VPWR VPWR sky130_fd_sc_hd__fill_1
XTAP_TAPCELL_ROW_70_1447 VGND VPWR sky130_fd_sc_hd__tapvpwrvgnd_1
XFILLER_59_848 VPWR VGND VPWR VGND sky130_ef_sc_hd__decap_12
XFILLER_86_645 VGND VGND VPWR VPWR sky130_fd_sc_hd__fill_2
XFILLER_74_807 VGND VGND VPWR VPWR sky130_fd_sc_hd__fill_1
XTAP_TAPCELL_ROW_70_1458 VGND VPWR sky130_fd_sc_hd__tapvpwrvgnd_1
XFILLER_37_15 VPWR VGND VPWR VGND sky130_ef_sc_hd__decap_12
X_06987_ decoded_imm\[24\] net187 _03376_ VGND VGND VPWR VPWR _03400_ sky130_fd_sc_hd__a21bo_1
XFILLER_100_477 VGND VGND VPWR VPWR sky130_fd_sc_hd__decap_6
XFILLER_100_466 VGND VGND VPWR VPWR sky130_fd_sc_hd__fill_1
X_09775_ _02646_ cpuregs\[7\]\[15\] _04874_ VGND VGND VPWR VPWR _01429_ sky130_fd_sc_hd__mux2_1
XFILLER_74_829 VGND VGND VPWR VPWR sky130_fd_sc_hd__fill_2
XFILLER_73_306 VGND VGND VPWR VPWR sky130_fd_sc_hd__fill_2
XFILLER_39_550 VGND VGND VPWR VPWR sky130_fd_sc_hd__decap_8
XFILLER_39_561 VPWR VGND VPWR VGND sky130_ef_sc_hd__decap_12
X_05938_ mem_wordsize\[1\] net125 net208 mem_wordsize\[2\] VGND VGND VPWR VPWR _02480_
+ sky130_fd_sc_hd__a22o_1
X_08726_ _04404_ _04405_ _01558_ VGND VGND VPWR VPWR _04415_ sky130_fd_sc_hd__mux2_1
XFILLER_54_531 VGND VGND VPWR VPWR sky130_fd_sc_hd__fill_1
XTAP_TAPCELL_ROW_1_343 VGND VPWR sky130_fd_sc_hd__tapvpwrvgnd_1
X_05869_ instr_sub _02059_ _02424_ _02426_ _02205_ VGND VGND VPWR VPWR _02427_ sky130_fd_sc_hd__o32a_1
XFILLER_82_851 VGND VGND VPWR VPWR sky130_fd_sc_hd__fill_1
XTAP_TAPCELL_ROW_1_354 VGND VPWR sky130_fd_sc_hd__tapvpwrvgnd_1
X_08657_ net269 _04348_ _01559_ VGND VGND VPWR VPWR _04350_ sky130_fd_sc_hd__a21o_1
X_07608_ cpuregs\[20\]\[25\] _02688_ net245 VGND VGND VPWR VPWR _00541_ sky130_fd_sc_hd__mux2_1
XFILLER_26_277 VGND VGND VPWR VPWR sky130_fd_sc_hd__fill_2
XTAP_TAPCELL_ROW_85_1690 VGND VPWR sky130_fd_sc_hd__tapvpwrvgnd_1
X_08588_ cpuregs\[28\]\[6\] cpuregs\[29\]\[6\] cpuregs\[30\]\[6\] cpuregs\[31\]\[6\]
+ net278 net273 VGND VGND VPWR VPWR _04284_ sky130_fd_sc_hd__mux4_1
X_07539_ _02678_ cpuregs\[16\]\[23\] _03570_ VGND VGND VPWR VPWR _00475_ sky130_fd_sc_hd__mux2_1
XFILLER_10_645 VPWR VGND VPWR VGND sky130_ef_sc_hd__decap_12
XFILLER_22_483 VGND VGND VPWR VPWR sky130_fd_sc_hd__fill_2
XFILLER_22_494 VPWR VGND VPWR VGND sky130_ef_sc_hd__decap_12
X_10550_ clknet_leaf_130_clk _00680_ VGND VGND VPWR VPWR reg_next_pc\[5\] sky130_fd_sc_hd__dfxtp_1
X_10481_ clknet_leaf_81_clk _00611_ VGND VGND VPWR VPWR count_instr\[30\] sky130_fd_sc_hd__dfxtp_1
X_09209_ _04738_ _01096_ VGND VGND VPWR VPWR _04794_ sky130_fd_sc_hd__nor2_1
XTAP_TAPCELL_ROW_20_651 VGND VPWR sky130_fd_sc_hd__tapvpwrvgnd_1
XFILLER_108_533 VGND VGND VPWR VPWR sky130_fd_sc_hd__decap_6
XFILLER_108_522 VGND VGND VPWR VPWR sky130_fd_sc_hd__decap_8
XFILLER_5_137 VPWR VGND VPWR VGND sky130_ef_sc_hd__decap_12
XFILLER_2_811 VGND VGND VPWR VPWR sky130_fd_sc_hd__fill_1
XFILLER_151_889 VGND VGND VPWR VPWR sky130_fd_sc_hd__decap_6
XFILLER_150_333 VPWR VGND VPWR VGND sky130_ef_sc_hd__decap_12
XFILLER_111_709 VGND VGND VPWR VPWR sky130_fd_sc_hd__fill_1
XTAP_TAPCELL_ROW_9_476 VGND VPWR sky130_fd_sc_hd__tapvpwrvgnd_1
X_11102_ clknet_leaf_127_clk _00005_ VGND VGND VPWR VPWR reg_sh\[3\] sky130_fd_sc_hd__dfxtp_1
XFILLER_110_208 VGND VGND VPWR VPWR sky130_fd_sc_hd__decap_6
X_11033_ clknet_leaf_87_clk _00033_ VGND VGND VPWR VPWR _00013_ sky130_fd_sc_hd__dfxtp_4
XFILLER_76_111 VGND VGND VPWR VPWR sky130_fd_sc_hd__decap_8
XFILLER_1_387 VGND VGND VPWR VPWR sky130_fd_sc_hd__decap_4
XFILLER_77_667 VGND VGND VPWR VPWR sky130_fd_sc_hd__decap_4
XFILLER_64_328 VGND VGND VPWR VPWR sky130_fd_sc_hd__decap_4
XFILLER_58_881 VGND VGND VPWR VPWR sky130_fd_sc_hd__decap_6
XFILLER_57_380 VPWR VGND VPWR VGND sky130_ef_sc_hd__decap_12
XFILLER_45_520 VGND VGND VPWR VPWR sky130_fd_sc_hd__decap_3
XFILLER_91_169 VPWR VGND VPWR VGND sky130_ef_sc_hd__decap_12
XTAP_TAPCELL_ROW_28_773 VGND VPWR sky130_fd_sc_hd__tapvpwrvgnd_1
XTAP_TAPCELL_ROW_28_784 VGND VPWR sky130_fd_sc_hd__tapvpwrvgnd_1
X_10817_ clknet_leaf_88_clk _00882_ VGND VGND VPWR VPWR instr_rdcycleh sky130_fd_sc_hd__dfxtp_4
XFILLER_60_589 VGND VGND VPWR VPWR sky130_fd_sc_hd__fill_1
XTAP_TAPCELL_ROW_136_2510 VGND VPWR sky130_fd_sc_hd__tapvpwrvgnd_1
XFILLER_119_809 VPWR VGND VPWR VGND sky130_ef_sc_hd__decap_12
XTAP_TAPCELL_ROW_119_2229 VGND VPWR sky130_fd_sc_hd__tapvpwrvgnd_1
X_10748_ clknet_leaf_100_clk alu_out\[1\] VGND VGND VPWR VPWR alu_out_q\[1\] sky130_fd_sc_hd__dfxtp_1
XFILLER_9_465 VPWR VGND VPWR VGND sky130_ef_sc_hd__decap_12
XFILLER_145_138 VPWR VGND VPWR VGND sky130_ef_sc_hd__decap_12
XFILLER_127_853 VPWR VGND VPWR VGND sky130_ef_sc_hd__decap_12
X_10679_ clknet_leaf_123_clk _00777_ VGND VGND VPWR VPWR net62 sky130_fd_sc_hd__dfxtp_1
Xoutput217 net217 VGND VGND VPWR VPWR pcpi_rs2[22] sky130_fd_sc_hd__buf_2
Xoutput206 net206 VGND VGND VPWR VPWR pcpi_rs2[12] sky130_fd_sc_hd__buf_2
XFILLER_127_897 VPWR VGND VPWR VGND sky130_ef_sc_hd__decap_12
XFILLER_99_214 VGND VGND VPWR VPWR sky130_fd_sc_hd__fill_1
XFILLER_5_671 VGND VGND VPWR VPWR sky130_fd_sc_hd__fill_1
Xoutput228 net228 VGND VGND VPWR VPWR pcpi_rs2[3] sky130_fd_sc_hd__buf_2
XFILLER_153_193 VGND VGND VPWR VPWR sky130_fd_sc_hd__decap_3
XFILLER_142_867 VGND VGND VPWR VPWR sky130_fd_sc_hd__fill_1
XFILLER_4_41 VPWR VGND VPWR VGND sky130_ef_sc_hd__decap_12
X_06910_ net184 _02721_ _03243_ _01641_ VGND VGND VPWR VPWR _03326_ sky130_fd_sc_hd__o211a_1
XFILLER_4_85 VPWR VGND VPWR VGND sky130_ef_sc_hd__decap_12
XFILLER_67_133 VGND VGND VPWR VPWR sky130_fd_sc_hd__fill_2
XFILLER_67_111 VGND VGND VPWR VPWR sky130_fd_sc_hd__fill_1
XTAP_TAPCELL_ROW_52_1166 VGND VPWR sky130_fd_sc_hd__tapvpwrvgnd_1
X_07890_ _01551_ _01555_ _03721_ VGND VGND VPWR VPWR _03722_ sky130_fd_sc_hd__or3b_1
XTAP_TAPCELL_ROW_147_2683 VGND VPWR sky130_fd_sc_hd__tapvpwrvgnd_1
X_06841_ _03255_ _03258_ _03259_ _00016_ _01580_ VGND VGND VPWR VPWR _03260_ sky130_fd_sc_hd__a221o_1
XFILLER_56_829 VGND VGND VPWR VPWR sky130_fd_sc_hd__decap_4
X_06772_ net180 net254 _03192_ _01641_ VGND VGND VPWR VPWR _03193_ sky130_fd_sc_hd__o211a_1
XFILLER_67_188 VGND VGND VPWR VPWR sky130_fd_sc_hd__decap_8
XFILLER_49_892 VGND VGND VPWR VPWR sky130_fd_sc_hd__decap_4
X_09560_ _03555_ _03557_ VGND VGND VPWR VPWR _04867_ sky130_fd_sc_hd__nor2_8
X_09491_ cpuregs\[24\]\[29\] _02704_ net241 VGND VGND VPWR VPWR _01155_ sky130_fd_sc_hd__mux2_1
XFILLER_70_309 VGND VGND VPWR VPWR sky130_fd_sc_hd__decap_6
X_05723_ _02133_ _02287_ _02295_ instr_sub _02296_ VGND VGND VPWR VPWR _02297_ sky130_fd_sc_hd__o221a_1
X_08511_ net34 _01612_ _04215_ VGND VGND VPWR VPWR _04216_ sky130_fd_sc_hd__and3_1
X_08442_ cpuregs\[10\]\[31\] cpuregs\[11\]\[31\] net264 VGND VGND VPWR VPWR _04179_
+ sky130_fd_sc_hd__mux2_1
XFILLER_90_191 VGND VGND VPWR VPWR sky130_fd_sc_hd__decap_4
X_05654_ instr_or instr_ori VGND VGND VPWR VPWR _02237_ sky130_fd_sc_hd__or2_4
XFILLER_23_225 VGND VGND VPWR VPWR sky130_fd_sc_hd__decap_3
X_08373_ count_cycle\[41\] _04129_ count_cycle\[42\] VGND VGND VPWR VPWR _04132_ sky130_fd_sc_hd__a21o_1
XFILLER_23_258 VGND VGND VPWR VPWR sky130_fd_sc_hd__decap_8
X_05585_ net198 net124 VGND VGND VPWR VPWR _02168_ sky130_fd_sc_hd__and2_1
XFILLER_149_444 VGND VGND VPWR VPWR sky130_fd_sc_hd__decap_4
XFILLER_23_39 VPWR VGND VPWR VGND sky130_ef_sc_hd__decap_12
X_07324_ cpuregs\[21\]\[8\] _02616_ net248 VGND VGND VPWR VPWR _00268_ sky130_fd_sc_hd__mux2_1
XFILLER_139_39 VPWR VGND VPWR VGND sky130_ef_sc_hd__decap_12
X_07255_ cpuregs\[2\]\[6\] _02607_ net250 VGND VGND VPWR VPWR _00202_ sky130_fd_sc_hd__mux2_1
X_06206_ _02657_ cpuregs\[11\]\[18\] _02582_ VGND VGND VPWR VPWR _00055_ sky130_fd_sc_hd__mux2_1
XFILLER_105_503 VGND VGND VPWR VPWR sky130_fd_sc_hd__fill_1
X_07186_ cpuregs\[30\]\[4\] _02598_ net252 VGND VGND VPWR VPWR _00136_ sky130_fd_sc_hd__mux2_1
X_06137_ _02583_ _02600_ _02601_ VGND VGND VPWR VPWR _02602_ sky130_fd_sc_hd__or3_1
X_06068_ cpuregs\[4\]\[3\] cpuregs\[5\]\[3\] cpuregs\[6\]\[3\] cpuregs\[7\]\[3\] net279
+ _00008_ VGND VGND VPWR VPWR _02540_ sky130_fd_sc_hd__mux4_1
XFILLER_133_889 VGND VGND VPWR VPWR sky130_fd_sc_hd__decap_6
XFILLER_99_781 VGND VGND VPWR VPWR sky130_fd_sc_hd__decap_3
XTAP_TAPCELL_ROW_6_435 VGND VPWR sky130_fd_sc_hd__tapvpwrvgnd_1
XTAP_TAPCELL_ROW_6_424 VGND VPWR sky130_fd_sc_hd__tapvpwrvgnd_1
X_05019_ cpu_state\[4\] _01639_ VGND VGND VPWR VPWR _01642_ sky130_fd_sc_hd__nand2_1
X_09827_ _02588_ cpuregs\[10\]\[1\] _04876_ VGND VGND VPWR VPWR _01511_ sky130_fd_sc_hd__mux2_1
XFILLER_46_306 VGND VGND VPWR VPWR sky130_fd_sc_hd__fill_2
XFILLER_47_818 VGND VGND VPWR VPWR sky130_fd_sc_hd__decap_4
XFILLER_104_53 VGND VGND VPWR VPWR sky130_fd_sc_hd__decap_6
XFILLER_100_263 VGND VGND VPWR VPWR sky130_fd_sc_hd__fill_1
XTAP_TAPCELL_ROW_87_1730 VGND VPWR sky130_fd_sc_hd__tapvpwrvgnd_1
X_09758_ _02712_ cpuregs\[6\]\[31\] _04873_ VGND VGND VPWR VPWR _01413_ sky130_fd_sc_hd__mux2_1
XFILLER_104_75 VGND VGND VPWR VPWR sky130_fd_sc_hd__decap_8
XFILLER_73_136 VGND VGND VPWR VPWR sky130_fd_sc_hd__decap_8
XFILLER_64_24 VGND VGND VPWR VPWR sky130_fd_sc_hd__decap_4
X_08709_ net270 _04395_ _04394_ _01560_ VGND VGND VPWR VPWR _04399_ sky130_fd_sc_hd__o211a_1
X_09689_ cpuregs\[4\]\[28\] _02699_ net238 VGND VGND VPWR VPWR _01346_ sky130_fd_sc_hd__mux2_1
XFILLER_55_895 VGND VGND VPWR VPWR sky130_fd_sc_hd__fill_1
XFILLER_120_41 VGND VGND VPWR VPWR sky130_fd_sc_hd__decap_6
XFILLER_70_832 VGND VGND VPWR VPWR sky130_fd_sc_hd__decap_3
XTAP_TAPCELL_ROW_25_732 VGND VPWR sky130_fd_sc_hd__tapvpwrvgnd_1
XFILLER_42_578 VGND VGND VPWR VPWR sky130_fd_sc_hd__decap_8
XFILLER_120_85 VPWR VGND VPWR VGND sky130_ef_sc_hd__decap_12
X_10602_ clknet_leaf_81_clk _00732_ VGND VGND VPWR VPWR count_cycle\[25\] sky130_fd_sc_hd__dfxtp_1
X_10533_ clknet_leaf_90_clk _00663_ VGND VGND VPWR VPWR reg_pc\[19\] sky130_fd_sc_hd__dfxtp_1
XTAP_TAPCELL_ROW_114_2148 VGND VPWR sky130_fd_sc_hd__tapvpwrvgnd_1
XTAP_TAPCELL_ROW_98_1892 VGND VPWR sky130_fd_sc_hd__tapvpwrvgnd_1
X_10464_ clknet_leaf_86_clk _00594_ VGND VGND VPWR VPWR count_instr\[13\] sky130_fd_sc_hd__dfxtp_1
XFILLER_6_457 VPWR VGND VPWR VGND sky130_ef_sc_hd__decap_12
XTAP_TAPCELL_ROW_114_2159 VGND VPWR sky130_fd_sc_hd__tapvpwrvgnd_1
XFILLER_109_897 VPWR VGND VPWR VGND sky130_ef_sc_hd__decap_12
XFILLER_89_65 VGND VGND VPWR VPWR sky130_fd_sc_hd__fill_1
X_10395_ clknet_leaf_0_clk _00525_ VGND VGND VPWR VPWR cpuregs\[20\]\[9\] sky130_fd_sc_hd__dfxtp_1
XFILLER_124_867 VGND VGND VPWR VPWR sky130_fd_sc_hd__fill_1
XFILLER_89_87 VGND VGND VPWR VPWR sky130_fd_sc_hd__decap_4
XFILLER_150_141 VPWR VGND VPWR VGND sky130_ef_sc_hd__decap_12
XFILLER_97_729 VGND VGND VPWR VPWR sky130_fd_sc_hd__fill_1
XFILLER_145_93 VGND VGND VPWR VPWR sky130_fd_sc_hd__decap_4
XFILLER_77_420 VPWR VGND VPWR VGND sky130_ef_sc_hd__decap_12
XPHY_EDGE_ROW_8_Left_162 VGND VGND VPWR VPWR sky130_fd_sc_hd__decap_3
X_11016_ clknet_leaf_22_clk _01078_ VGND VGND VPWR VPWR cpuregs\[19\]\[16\] sky130_fd_sc_hd__dfxtp_1
XFILLER_77_464 VPWR VGND VPWR VGND sky130_ef_sc_hd__decap_12
XFILLER_38_829 VGND VGND VPWR VPWR sky130_fd_sc_hd__fill_1
XTAP_TAPCELL_ROW_129_2391 VGND VPWR sky130_fd_sc_hd__tapvpwrvgnd_1
XFILLER_65_637 VGND VGND VPWR VPWR sky130_fd_sc_hd__fill_2
XFILLER_92_456 VPWR VGND VPWR VGND sky130_ef_sc_hd__decap_12
XFILLER_18_531 VGND VGND VPWR VPWR sky130_fd_sc_hd__fill_1
XFILLER_18_542 VGND VGND VPWR VPWR sky130_fd_sc_hd__decap_4
XFILLER_21_718 VGND VGND VPWR VPWR sky130_fd_sc_hd__fill_1
X_05370_ _01957_ _01960_ VGND VGND VPWR VPWR _01961_ sky130_fd_sc_hd__or2_1
XFILLER_119_617 VPWR VGND VPWR VGND sky130_ef_sc_hd__decap_12
XFILLER_119_606 VGND VGND VPWR VPWR sky130_fd_sc_hd__decap_8
Xclkload10 clknet_4_12_0_clk VGND VGND VPWR VPWR clkload10/Y sky130_fd_sc_hd__inv_8
X_07040_ decoded_imm\[26\] net189 _03425_ VGND VGND VPWR VPWR _03451_ sky130_fd_sc_hd__a21o_1
Xclkload21 clknet_leaf_6_clk VGND VGND VPWR VPWR clkload21/Y sky130_fd_sc_hd__inv_6
Xclkload32 clknet_leaf_141_clk VGND VGND VPWR VPWR clkload32/Y sky130_fd_sc_hd__clkinv_4
Xclkload43 clknet_leaf_134_clk VGND VGND VPWR VPWR clkload43/Y sky130_fd_sc_hd__inv_6
Xclkload76 clknet_leaf_48_clk VGND VGND VPWR VPWR clkload76/Y sky130_fd_sc_hd__inv_8
XFILLER_126_171 VPWR VGND VPWR VGND sky130_ef_sc_hd__decap_12
Xclkload54 clknet_leaf_33_clk VGND VGND VPWR VPWR clkload54/X sky130_fd_sc_hd__clkbuf_4
Xclkload65 clknet_leaf_20_clk VGND VGND VPWR VPWR clkload65/Y sky130_fd_sc_hd__clkinvlp_4
Xclkload87 clknet_leaf_127_clk VGND VGND VPWR VPWR clkload87/X sky130_fd_sc_hd__clkbuf_8
Xclkload98 clknet_leaf_115_clk VGND VGND VPWR VPWR clkload98/Y sky130_fd_sc_hd__clkinv_8
XTAP_TAPCELL_ROW_149_2723 VGND VPWR sky130_fd_sc_hd__tapvpwrvgnd_1
XTAP_TAPCELL_ROW_149_2712 VGND VPWR sky130_fd_sc_hd__tapvpwrvgnd_1
XFILLER_142_697 VGND VGND VPWR VPWR sky130_fd_sc_hd__decap_3
X_08991_ cpuregs\[12\]\[28\] cpuregs\[13\]\[28\] cpuregs\[14\]\[28\] cpuregs\[15\]\[28\]
+ net280 net271 VGND VGND VPWR VPWR _04665_ sky130_fd_sc_hd__mux4_1
XFILLER_130_837 VPWR VGND VPWR VGND sky130_ef_sc_hd__decap_12
XFILLER_115_889 VGND VGND VPWR VPWR sky130_fd_sc_hd__decap_3
XFILLER_141_185 VGND VGND VPWR VPWR sky130_fd_sc_hd__decap_6
XFILLER_96_740 VGND VGND VPWR VPWR sky130_fd_sc_hd__decap_4
X_07942_ _03691_ _03692_ _03693_ _03738_ VGND VGND VPWR VPWR _03769_ sky130_fd_sc_hd__and4_1
X_07873_ _02684_ reg_next_pc\[25\] net596 VGND VGND VPWR VPWR _03712_ sky130_fd_sc_hd__mux2_2
XFILLER_68_442 VGND VGND VPWR VPWR sky130_fd_sc_hd__decap_8
XFILLER_29_818 VPWR VGND VPWR VGND sky130_ef_sc_hd__decap_12
X_09612_ _02657_ cpuregs\[3\]\[18\] _04868_ VGND VGND VPWR VPWR _01272_ sky130_fd_sc_hd__mux2_1
XFILLER_110_594 VGND VGND VPWR VPWR sky130_fd_sc_hd__decap_6
X_06824_ _01565_ _02721_ VGND VGND VPWR VPWR _03243_ sky130_fd_sc_hd__nand2_1
XFILLER_95_294 VGND VGND VPWR VPWR sky130_fd_sc_hd__fill_1
XFILLER_83_467 VPWR VGND VPWR VGND sky130_ef_sc_hd__decap_12
X_09543_ cpuregs\[23\]\[15\] _02646_ _04866_ VGND VGND VPWR VPWR _01205_ sky130_fd_sc_hd__mux2_1
X_06755_ cpuregs\[12\]\[16\] cpuregs\[13\]\[16\] cpuregs\[14\]\[16\] cpuregs\[15\]\[16\]
+ net265 net260 VGND VGND VPWR VPWR _03177_ sky130_fd_sc_hd__mux4_1
XFILLER_71_629 VGND VGND VPWR VPWR sky130_fd_sc_hd__fill_2
XFILLER_55_169 VGND VGND VPWR VPWR sky130_fd_sc_hd__fill_1
XFILLER_37_895 VGND VGND VPWR VPWR sky130_fd_sc_hd__fill_1
X_06686_ _03082_ _03085_ _03108_ VGND VGND VPWR VPWR _03110_ sky130_fd_sc_hd__a21oi_1
X_09474_ cpuregs\[24\]\[12\] _02633_ net242 VGND VGND VPWR VPWR _01138_ sky130_fd_sc_hd__mux2_1
X_05706_ _02281_ _02189_ instr_sub VGND VGND VPWR VPWR _02282_ sky130_fd_sc_hd__mux2_1
XFILLER_34_27 VGND VGND VPWR VPWR sky130_fd_sc_hd__fill_1
XFILLER_36_383 VGND VGND VPWR VPWR sky130_fd_sc_hd__fill_1
X_08425_ count_cycle\[61\] _04163_ VGND VGND VPWR VPWR _04165_ sky130_fd_sc_hd__and2_1
X_05637_ net217 net185 VGND VGND VPWR VPWR _02220_ sky130_fd_sc_hd__and2b_1
XTAP_TAPCELL_ROW_65_1379 VGND VPWR sky130_fd_sc_hd__tapvpwrvgnd_1
XTAP_TAPCELL_ROW_65_1368 VGND VPWR sky130_fd_sc_hd__tapvpwrvgnd_1
X_08356_ count_cycle\[35\] net395 _04121_ VGND VGND VPWR VPWR _00742_ sky130_fd_sc_hd__o21a_1
XFILLER_24_589 VPWR VGND VPWR VGND sky130_ef_sc_hd__decap_12
X_07307_ cpuregs\[28\]\[25\] _02688_ net249 VGND VGND VPWR VPWR _00253_ sky130_fd_sc_hd__mux2_1
Xclkload4 clknet_4_5_0_clk VGND VGND VPWR VPWR clkload4/X sky130_fd_sc_hd__clkbuf_8
X_05568_ net175 net207 VGND VGND VPWR VPWR _02151_ sky130_fd_sc_hd__and2_1
XFILLER_137_447 VGND VGND VPWR VPWR sky130_fd_sc_hd__fill_1
X_05499_ net186 net218 VGND VGND VPWR VPWR _02082_ sky130_fd_sc_hd__and2_1
XFILLER_109_138 VGND VGND VPWR VPWR sky130_fd_sc_hd__fill_2
X_08287_ count_cycle\[10\] count_cycle\[11\] net446 VGND VGND VPWR VPWR _04077_ sky130_fd_sc_hd__and3_1
X_07238_ cpuregs\[13\]\[22\] _02675_ net251 VGND VGND VPWR VPWR _00186_ sky130_fd_sc_hd__mux2_1
X_07169_ cpuregs\[12\]\[23\] _02678_ net253 VGND VGND VPWR VPWR _00123_ sky130_fd_sc_hd__mux2_1
XFILLER_3_405 VPWR VGND VPWR VGND sky130_ef_sc_hd__decap_12
XFILLER_106_845 VGND VGND VPWR VPWR sky130_fd_sc_hd__decap_4
XFILLER_3_449 VPWR VGND VPWR VGND sky130_ef_sc_hd__decap_12
X_10180_ clknet_leaf_53_clk _00310_ VGND VGND VPWR VPWR cpuregs\[9\]\[18\] sky130_fd_sc_hd__dfxtp_1
XFILLER_59_57 VGND VGND VPWR VPWR sky130_fd_sc_hd__decap_4
XFILLER_59_35 VGND VGND VPWR VPWR sky130_fd_sc_hd__decap_4
XFILLER_87_751 VGND VGND VPWR VPWR sky130_fd_sc_hd__decap_8
XFILLER_59_464 VGND VGND VPWR VPWR sky130_fd_sc_hd__decap_3
XFILLER_101_594 VPWR VGND VPWR VGND sky130_ef_sc_hd__decap_12
XFILLER_101_561 VGND VGND VPWR VPWR sky130_fd_sc_hd__decap_4
XFILLER_75_23 VPWR VGND VPWR VGND sky130_ef_sc_hd__decap_12
XFILLER_47_615 VGND VGND VPWR VPWR sky130_fd_sc_hd__fill_1
XFILLER_75_89 VGND VGND VPWR VPWR sky130_fd_sc_hd__fill_2
XFILLER_74_434 VGND VGND VPWR VPWR sky130_fd_sc_hd__decap_8
XFILLER_131_51 VGND VGND VPWR VPWR sky130_fd_sc_hd__decap_4
XFILLER_61_117 VGND VGND VPWR VPWR sky130_fd_sc_hd__fill_1
XFILLER_55_670 VGND VGND VPWR VPWR sky130_fd_sc_hd__fill_2
XFILLER_34_309 VPWR VGND VPWR VGND sky130_ef_sc_hd__decap_12
XFILLER_91_55 VGND VGND VPWR VPWR sky130_fd_sc_hd__fill_1
XFILLER_70_673 VPWR VGND VPWR VGND sky130_ef_sc_hd__decap_12
XFILLER_43_887 VGND VGND VPWR VPWR sky130_fd_sc_hd__decap_8
XFILLER_10_250 VGND VGND VPWR VPWR sky130_fd_sc_hd__fill_2
XFILLER_7_722 VGND VGND VPWR VPWR sky130_fd_sc_hd__decap_6
X_11496_ clknet_leaf_33_clk _01540_ VGND VGND VPWR VPWR cpuregs\[10\]\[30\] sky130_fd_sc_hd__dfxtp_1
XFILLER_6_221 VPWR VGND VPWR VGND sky130_ef_sc_hd__decap_12
X_10516_ clknet_leaf_128_clk _00646_ VGND VGND VPWR VPWR reg_pc\[2\] sky130_fd_sc_hd__dfxtp_2
X_10447_ clknet_leaf_33_clk _00577_ VGND VGND VPWR VPWR cpuregs\[17\]\[29\] sky130_fd_sc_hd__dfxtp_1
XFILLER_6_265 VPWR VGND VPWR VGND sky130_ef_sc_hd__decap_12
X_10378_ clknet_leaf_67_clk _00508_ VGND VGND VPWR VPWR cpuregs\[25\]\[24\] sky130_fd_sc_hd__dfxtp_1
XFILLER_112_848 VGND VGND VPWR VPWR sky130_fd_sc_hd__decap_4
XFILLER_78_751 VGND VGND VPWR VPWR sky130_fd_sc_hd__decap_4
XTAP_TAPCELL_ROW_144_2631 VGND VPWR sky130_fd_sc_hd__tapvpwrvgnd_1
XFILLER_120_881 VPWR VGND VPWR VGND sky130_ef_sc_hd__decap_12
XTAP_TAPCELL_ROW_144_2642 VGND VPWR sky130_fd_sc_hd__tapvpwrvgnd_1
XFILLER_92_242 VGND VGND VPWR VPWR sky130_fd_sc_hd__fill_1
XFILLER_37_169 VGND VGND VPWR VPWR sky130_fd_sc_hd__fill_2
XFILLER_19_895 VGND VGND VPWR VPWR sky130_fd_sc_hd__fill_1
X_06540_ cpuregs\[28\]\[8\] cpuregs\[29\]\[8\] cpuregs\[30\]\[8\] cpuregs\[31\]\[8\]
+ net263 net259 VGND VGND VPWR VPWR _02970_ sky130_fd_sc_hd__mux4_1
XFILLER_33_353 VGND VGND VPWR VPWR sky130_fd_sc_hd__fill_2
X_06471_ net193 net172 _02721_ VGND VGND VPWR VPWR _02903_ sky130_fd_sc_hd__mux2_1
X_08210_ instr_jal _04014_ _04015_ _04009_ VGND VGND VPWR VPWR _04016_ sky130_fd_sc_hd__a31o_1
X_05422_ _02005_ _02008_ VGND VGND VPWR VPWR _02009_ sky130_fd_sc_hd__xor2_1
XFILLER_60_172 VPWR VGND VPWR VGND sky130_ef_sc_hd__decap_12
XTAP_TAPCELL_ROW_16_584 VGND VPWR sky130_fd_sc_hd__tapvpwrvgnd_1
XFILLER_21_537 VGND VGND VPWR VPWR sky130_fd_sc_hd__decap_4
XTAP_TAPCELL_ROW_47_1076 VGND VPWR sky130_fd_sc_hd__tapvpwrvgnd_1
XTAP_TAPCELL_ROW_47_1087 VGND VPWR sky130_fd_sc_hd__tapvpwrvgnd_1
XFILLER_147_712 VPWR VGND VPWR VGND sky130_ef_sc_hd__decap_12
X_09190_ decoded_imm_j\[12\] _01106_ _02513_ VGND VGND VPWR VPWR _00893_ sky130_fd_sc_hd__mux2_1
XTAP_TAPCELL_ROW_16_595 VGND VPWR sky130_fd_sc_hd__tapvpwrvgnd_1
X_08141_ _03575_ _03951_ _03952_ VGND VGND VPWR VPWR _03953_ sky130_fd_sc_hd__a21o_1
X_05353_ _01942_ _01943_ VGND VGND VPWR VPWR _01945_ sky130_fd_sc_hd__nand2_1
Xclkload121 clknet_leaf_70_clk VGND VGND VPWR VPWR clkload121/X sky130_fd_sc_hd__clkbuf_4
X_08072_ _01547_ reg_next_pc\[16\] _01645_ _03703_ VGND VGND VPWR VPWR _03889_ sky130_fd_sc_hd__a22o_1
X_05284_ count_instr\[49\] instr_rdinstrh net257 _01881_ VGND VGND VPWR VPWR _01882_
+ sky130_fd_sc_hd__a211o_1
XTAP_TAPCELL_ROW_60_1298 VGND VPWR sky130_fd_sc_hd__tapvpwrvgnd_1
XTAP_TAPCELL_ROW_60_1287 VGND VPWR sky130_fd_sc_hd__tapvpwrvgnd_1
Xclkload110 clknet_leaf_110_clk VGND VGND VPWR VPWR clkload110/Y sky130_fd_sc_hd__clkinv_2
X_07023_ cpuregs\[24\]\[26\] cpuregs\[25\]\[26\] cpuregs\[26\]\[26\] cpuregs\[27\]\[26\]
+ net266 net261 VGND VGND VPWR VPWR _03435_ sky130_fd_sc_hd__mux4_1
Xclkload132 clknet_leaf_89_clk VGND VGND VPWR VPWR clkload132/Y sky130_fd_sc_hd__clkinv_4
XFILLER_20_29 VPWR VGND VPWR VGND sky130_ef_sc_hd__decap_12
XFILLER_136_29 VPWR VGND VPWR VGND sky130_ef_sc_hd__decap_12
XFILLER_115_631 VGND VGND VPWR VPWR sky130_fd_sc_hd__fill_1
XFILLER_130_645 VGND VGND VPWR VPWR sky130_fd_sc_hd__fill_2
X_08974_ cpuregs\[28\]\[27\] cpuregs\[29\]\[27\] cpuregs\[30\]\[27\] cpuregs\[31\]\[27\]
+ net275 net271 VGND VGND VPWR VPWR _04649_ sky130_fd_sc_hd__mux4_1
XPHY_EDGE_ROW_89_Right_89 VGND VGND VPWR VPWR sky130_fd_sc_hd__decap_3
X_07925_ _03751_ _03752_ VGND VGND VPWR VPWR _03753_ sky130_fd_sc_hd__nor2_1
XFILLER_29_27 VPWR VGND VPWR VGND sky130_ef_sc_hd__decap_12
XFILLER_56_401 VGND VGND VPWR VPWR sky130_fd_sc_hd__fill_2
XFILLER_29_615 VGND VGND VPWR VPWR sky130_fd_sc_hd__fill_1
X_07856_ reg_pc\[16\] _01624_ _01628_ _03703_ VGND VGND VPWR VPWR _00660_ sky130_fd_sc_hd__a22o_1
XTAP_TAPCELL_ROW_67_1408 VGND VPWR sky130_fd_sc_hd__tapvpwrvgnd_1
XFILLER_28_136 VGND VGND VPWR VPWR sky130_fd_sc_hd__decap_4
X_06807_ cpuregs\[0\]\[18\] cpuregs\[1\]\[18\] cpuregs\[2\]\[18\] cpuregs\[3\]\[18\]
+ net265 net260 VGND VGND VPWR VPWR _03227_ sky130_fd_sc_hd__mux4_1
X_07787_ _03659_ count_instr\[49\] count_instr\[48\] count_instr\[50\] VGND VGND VPWR
+ VPWR _03664_ sky130_fd_sc_hd__and4_1
XFILLER_84_798 VGND VGND VPWR VPWR sky130_fd_sc_hd__decap_3
XFILLER_83_264 VGND VGND VPWR VPWR sky130_fd_sc_hd__decap_6
X_04999_ _01618_ _01626_ _01620_ VGND VGND VPWR VPWR _01627_ sky130_fd_sc_hd__or3b_1
XFILLER_16_309 VGND VGND VPWR VPWR sky130_fd_sc_hd__fill_2
XFILLER_28_158 VGND VGND VPWR VPWR sky130_fd_sc_hd__decap_3
XFILLER_83_297 VGND VGND VPWR VPWR sky130_fd_sc_hd__fill_2
X_06738_ _03057_ _03084_ _03082_ VGND VGND VPWR VPWR _03160_ sky130_fd_sc_hd__o21a_1
X_09526_ cpuregs\[31\]\[31\] _02712_ net240 VGND VGND VPWR VPWR _01189_ sky130_fd_sc_hd__mux2_1
XFILLER_25_821 VPWR VGND VPWR VGND sky130_ef_sc_hd__decap_12
X_09457_ _02699_ cpuregs\[19\]\[28\] _04863_ VGND VGND VPWR VPWR _01090_ sky130_fd_sc_hd__mux2_1
XFILLER_101_43 VPWR VGND VPWR VGND sky130_ef_sc_hd__decap_12
XTAP_TAPCELL_ROW_80_1619 VGND VPWR sky130_fd_sc_hd__tapvpwrvgnd_1
XTAP_TAPCELL_ROW_80_1608 VGND VPWR sky130_fd_sc_hd__tapvpwrvgnd_1
XFILLER_25_865 VPWR VGND VPWR VGND sky130_ef_sc_hd__decap_12
X_08408_ count_cycle\[53\] _04149_ count_cycle\[55\] count_cycle\[54\] VGND VGND VPWR
+ VPWR _04154_ sky130_fd_sc_hd__and4_1
XPHY_EDGE_ROW_98_Right_98 VGND VGND VPWR VPWR sky130_fd_sc_hd__decap_3
X_06669_ _01579_ _03093_ VGND VGND VPWR VPWR _03094_ sky130_fd_sc_hd__or2_1
XFILLER_52_695 VGND VGND VPWR VPWR sky130_fd_sc_hd__decap_4
XTAP_TAPCELL_ROW_35_893 VGND VPWR sky130_fd_sc_hd__tapvpwrvgnd_1
XFILLER_40_813 VGND VGND VPWR VPWR sky130_fd_sc_hd__fill_1
X_09388_ decoded_imm\[3\] _04746_ _04856_ _04857_ VGND VGND VPWR VPWR _01027_ sky130_fd_sc_hd__o22a_1
X_08339_ count_cycle\[29\] _04109_ _01549_ VGND VGND VPWR VPWR _04111_ sky130_fd_sc_hd__a21oi_1
XFILLER_61_69 VGND VGND VPWR VPWR sky130_fd_sc_hd__fill_1
X_11350_ clknet_leaf_5_clk _01394_ VGND VGND VPWR VPWR cpuregs\[6\]\[12\] sky130_fd_sc_hd__dfxtp_1
XFILLER_125_417 VGND VGND VPWR VPWR sky130_fd_sc_hd__decap_4
XPHY_EDGE_ROW_89_Left_243 VGND VGND VPWR VPWR sky130_fd_sc_hd__decap_3
XFILLER_4_725 VPWR VGND VPWR VGND sky130_ef_sc_hd__decap_12
X_10301_ clknet_leaf_147_clk _00431_ VGND VGND VPWR VPWR cpuregs\[26\]\[11\] sky130_fd_sc_hd__dfxtp_1
XTAP_TAPCELL_ROW_111_2107 VGND VPWR sky130_fd_sc_hd__tapvpwrvgnd_1
XTAP_TAPCELL_ROW_95_1851 VGND VPWR sky130_fd_sc_hd__tapvpwrvgnd_1
X_11281_ clknet_leaf_2_clk _01328_ VGND VGND VPWR VPWR cpuregs\[4\]\[10\] sky130_fd_sc_hd__dfxtp_1
XFILLER_4_769 VPWR VGND VPWR VGND sky130_ef_sc_hd__decap_12
X_10232_ clknet_leaf_2_clk _00362_ VGND VGND VPWR VPWR cpuregs\[27\]\[6\] sky130_fd_sc_hd__dfxtp_1
XFILLER_106_697 VGND VGND VPWR VPWR sky130_fd_sc_hd__decap_3
XFILLER_105_185 VGND VGND VPWR VPWR sky130_fd_sc_hd__fill_1
XFILLER_86_11 VPWR VGND VPWR VGND sky130_ef_sc_hd__decap_12
XFILLER_79_559 VGND VGND VPWR VPWR sky130_fd_sc_hd__fill_1
XFILLER_3_279 VGND VGND VPWR VPWR sky130_fd_sc_hd__fill_1
X_10163_ clknet_leaf_118_clk _00293_ VGND VGND VPWR VPWR cpuregs\[9\]\[1\] sky130_fd_sc_hd__dfxtp_1
X_10094_ clknet_leaf_38_clk _00224_ VGND VGND VPWR VPWR cpuregs\[2\]\[28\] sky130_fd_sc_hd__dfxtp_1
XFILLER_59_261 VGND VGND VPWR VPWR sky130_fd_sc_hd__fill_1
XTAP_TAPCELL_ROW_126_2350 VGND VPWR sky130_fd_sc_hd__tapvpwrvgnd_1
XTAP_TAPCELL_ROW_109_2069 VGND VPWR sky130_fd_sc_hd__tapvpwrvgnd_1
XFILLER_142_83 VGND VGND VPWR VPWR sky130_fd_sc_hd__fill_1
XPHY_EDGE_ROW_98_Left_252 VGND VGND VPWR VPWR sky130_fd_sc_hd__decap_3
XFILLER_19_93 VGND VGND VPWR VPWR sky130_fd_sc_hd__fill_2
XFILLER_28_670 VGND VGND VPWR VPWR sky130_fd_sc_hd__decap_3
X_10996_ clknet_leaf_39_clk _01058_ VGND VGND VPWR VPWR cpuregs\[18\]\[28\] sky130_fd_sc_hd__dfxtp_1
XFILLER_90_779 VPWR VGND VPWR VGND sky130_ef_sc_hd__decap_12
XTAP_TAPCELL_ROW_104_1991 VGND VPWR sky130_fd_sc_hd__tapvpwrvgnd_1
XTAP_TAPCELL_ROW_13_532 VGND VPWR sky130_fd_sc_hd__tapvpwrvgnd_1
XTAP_TAPCELL_ROW_13_543 VGND VPWR sky130_fd_sc_hd__tapvpwrvgnd_1
XFILLER_143_203 VGND VGND VPWR VPWR sky130_fd_sc_hd__fill_1
XFILLER_128_277 VGND VGND VPWR VPWR sky130_fd_sc_hd__decap_4
X_11479_ clknet_leaf_10_clk _01523_ VGND VGND VPWR VPWR cpuregs\[10\]\[13\] sky130_fd_sc_hd__dfxtp_1
Xmax_cap238 _04871_ VGND VGND VPWR VPWR net238 sky130_fd_sc_hd__buf_12
XFILLER_98_802 VGND VGND VPWR VPWR sky130_fd_sc_hd__fill_2
XFILLER_152_781 VPWR VGND VPWR VGND sky130_ef_sc_hd__decap_12
XFILLER_124_483 VGND VGND VPWR VPWR sky130_fd_sc_hd__fill_1
XFILLER_32_3 VPWR VGND VPWR VGND sky130_ef_sc_hd__decap_12
XFILLER_112_667 VPWR VGND VPWR VGND sky130_ef_sc_hd__decap_12
XFILLER_112_645 VGND VGND VPWR VPWR sky130_fd_sc_hd__decap_3
XFILLER_111_133 VGND VGND VPWR VPWR sky130_fd_sc_hd__decap_6
XFILLER_111_166 VGND VGND VPWR VPWR sky130_fd_sc_hd__fill_2
XFILLER_111_155 VGND VGND VPWR VPWR sky130_fd_sc_hd__decap_3
X_07710_ _03615_ net34 _03613_ VGND VGND VPWR VPWR _00602_ sky130_fd_sc_hd__and3b_1
XFILLER_78_581 VGND VGND VPWR VPWR sky130_fd_sc_hd__decap_6
X_05971_ reg_out\[8\] reg_next_pc\[8\] net597 VGND VGND VPWR VPWR _02489_ sky130_fd_sc_hd__mux2_1
XFILLER_65_220 VGND VGND VPWR VPWR sky130_fd_sc_hd__decap_4
X_08690_ _04378_ _04379_ _01558_ VGND VGND VPWR VPWR _04381_ sky130_fd_sc_hd__mux2_1
X_04922_ net404 VGND VGND VPWR VPWR _01555_ sky130_fd_sc_hd__clkinv_4
X_07641_ _02688_ cpuregs\[17\]\[25\] _03574_ VGND VGND VPWR VPWR _00573_ sky130_fd_sc_hd__mux2_1
XTAP_TAPCELL_ROW_49_1116 VGND VPWR sky130_fd_sc_hd__tapvpwrvgnd_1
X_07572_ cpuregs\[25\]\[23\] _02678_ _03571_ VGND VGND VPWR VPWR _00507_ sky130_fd_sc_hd__mux2_1
XFILLER_80_256 VPWR VGND VPWR VGND sky130_ef_sc_hd__decap_12
XFILLER_34_640 VGND VGND VPWR VPWR sky130_fd_sc_hd__decap_4
X_06523_ decoded_imm\[6\] net199 _02924_ _02925_ VGND VGND VPWR VPWR _02953_ sky130_fd_sc_hd__a31o_1
X_09311_ cpu_state\[3\] _01629_ VGND VGND VPWR VPWR _04816_ sky130_fd_sc_hd__nor2_1
XFILLER_80_289 VGND VGND VPWR VPWR sky130_fd_sc_hd__fill_1
XTAP_TAPCELL_ROW_62_1327 VGND VPWR sky130_fd_sc_hd__tapvpwrvgnd_1
XTAP_TAPCELL_ROW_62_1316 VGND VPWR sky130_fd_sc_hd__tapvpwrvgnd_1
XFILLER_22_813 VPWR VGND VPWR VGND sky130_ef_sc_hd__decap_12
X_09242_ cpuregs\[1\]\[21\] _02670_ _04799_ VGND VGND VPWR VPWR _00939_ sky130_fd_sc_hd__mux2_1
X_06454_ cpuregs\[4\]\[5\] cpuregs\[5\]\[5\] cpuregs\[6\]\[5\] cpuregs\[7\]\[5\] net264
+ net262 VGND VGND VPWR VPWR _02887_ sky130_fd_sc_hd__mux4_1
XTAP_TAPCELL_ROW_32_841 VGND VPWR sky130_fd_sc_hd__tapvpwrvgnd_1
XFILLER_147_520 VGND VGND VPWR VPWR sky130_fd_sc_hd__fill_1
X_05405_ _01991_ _01992_ VGND VGND VPWR VPWR _01993_ sky130_fd_sc_hd__nand2b_1
X_09173_ mem_rdata_q\[5\] mem_rdata_q\[6\] VGND VGND VPWR VPWR _04788_ sky130_fd_sc_hd__nor2_1
X_06385_ _01579_ _02815_ _02818_ _02819_ VGND VGND VPWR VPWR _02820_ sky130_fd_sc_hd__a22o_1
XFILLER_147_542 VGND VGND VPWR VPWR sky130_fd_sc_hd__fill_2
XFILLER_108_907 VGND VGND VPWR VPWR sky130_fd_sc_hd__decap_4
X_08124_ _01547_ reg_next_pc\[20\] _01645_ _03707_ VGND VGND VPWR VPWR _03937_ sky130_fd_sc_hd__a22o_1
X_05336_ count_cycle\[21\] _01588_ VGND VGND VPWR VPWR _01930_ sky130_fd_sc_hd__or2_1
XFILLER_31_39 VPWR VGND VPWR VGND sky130_ef_sc_hd__decap_12
XFILLER_147_39 VPWR VGND VPWR VGND sky130_ef_sc_hd__decap_12
XFILLER_134_236 VPWR VGND VPWR VGND sky130_ef_sc_hd__decap_12
XFILLER_119_299 VGND VGND VPWR VPWR sky130_fd_sc_hd__fill_1
XFILLER_107_439 VGND VGND VPWR VPWR sky130_fd_sc_hd__fill_1
X_05267_ reg_pc\[16\] decoded_imm\[16\] VGND VGND VPWR VPWR _01866_ sky130_fd_sc_hd__xnor2_1
X_08055_ instr_jal _03872_ VGND VGND VPWR VPWR _03873_ sky130_fd_sc_hd__nand2_1
XFILLER_134_269 VGND VGND VPWR VPWR sky130_fd_sc_hd__decap_3
X_07006_ _03410_ _03417_ _03418_ _01581_ _01580_ VGND VGND VPWR VPWR _03419_ sky130_fd_sc_hd__a221o_1
XFILLER_89_802 VPWR VGND VPWR VGND sky130_ef_sc_hd__decap_12
Xoutput39 net39 VGND VGND VPWR VPWR mem_addr[14] sky130_fd_sc_hd__buf_2
XTAP_TAPCELL_ROW_77_1570 VGND VPWR sky130_fd_sc_hd__tapvpwrvgnd_1
X_05198_ reg_pc\[10\] decoded_imm\[10\] _01792_ VGND VGND VPWR VPWR _01802_ sky130_fd_sc_hd__a21o_1
Xpicorv32_283 VGND VGND VPWR VPWR picorv32_283/HI eoi[2] sky130_fd_sc_hd__conb_1
XFILLER_142_280 VPWR VGND VPWR VGND sky130_ef_sc_hd__decap_12
Xpicorv32_294 VGND VGND VPWR VPWR picorv32_294/HI eoi[13] sky130_fd_sc_hd__conb_1
XFILLER_115_483 VGND VGND VPWR VPWR sky130_fd_sc_hd__decap_3
XFILLER_103_656 VGND VGND VPWR VPWR sky130_fd_sc_hd__decap_6
XTAP_TAPCELL_ROW_90_1770 VGND VPWR sky130_fd_sc_hd__tapvpwrvgnd_1
XFILLER_0_249 VGND VGND VPWR VPWR sky130_fd_sc_hd__decap_3
X_08957_ cpuregs\[16\]\[26\] cpuregs\[17\]\[26\] cpuregs\[18\]\[26\] cpuregs\[19\]\[26\]
+ net280 net274 VGND VGND VPWR VPWR _04633_ sky130_fd_sc_hd__mux4_1
XFILLER_130_475 VGND VGND VPWR VPWR sky130_fd_sc_hd__fill_1
X_08888_ net270 _04567_ VGND VGND VPWR VPWR _04568_ sky130_fd_sc_hd__or2_1
X_07908_ _03688_ _03689_ VGND VGND VPWR VPWR _03738_ sky130_fd_sc_hd__and2_4
XFILLER_72_713 VGND VGND VPWR VPWR sky130_fd_sc_hd__decap_4
X_07839_ _02613_ reg_next_pc\[8\] _02482_ VGND VGND VPWR VPWR _03695_ sky130_fd_sc_hd__mux2_2
XFILLER_45_905 VGND VGND VPWR VPWR sky130_fd_sc_hd__decap_3
XFILLER_72_757 VPWR VGND VPWR VGND sky130_ef_sc_hd__decap_12
XFILLER_72_735 VPWR VGND VPWR VGND sky130_ef_sc_hd__decap_12
X_10850_ clknet_leaf_99_clk _00914_ VGND VGND VPWR VPWR is_jalr_addi_slti_sltiu_xori_ori_andi
+ sky130_fd_sc_hd__dfxtp_1
XFILLER_44_415 VGND VGND VPWR VPWR sky130_fd_sc_hd__decap_4
XFILLER_72_13 VGND VGND VPWR VPWR sky130_fd_sc_hd__decap_4
XFILLER_72_24 VGND VGND VPWR VPWR sky130_fd_sc_hd__decap_4
XFILLER_60_908 VGND VGND VPWR VPWR sky130_fd_sc_hd__fill_1
X_09509_ cpuregs\[31\]\[14\] _02641_ net240 VGND VGND VPWR VPWR _01172_ sky130_fd_sc_hd__mux2_1
X_10781_ clknet_leaf_103_clk _00846_ VGND VGND VPWR VPWR instr_jal sky130_fd_sc_hd__dfxtp_4
XFILLER_52_481 VGND VGND VPWR VPWR sky130_fd_sc_hd__fill_1
XFILLER_12_345 VGND VGND VPWR VPWR sky130_fd_sc_hd__fill_2
XFILLER_40_643 VGND VGND VPWR VPWR sky130_fd_sc_hd__fill_1
XFILLER_138_520 VGND VGND VPWR VPWR sky130_fd_sc_hd__fill_1
XPHY_EDGE_ROW_117_Right_117 VGND VGND VPWR VPWR sky130_fd_sc_hd__decap_3
XFILLER_9_839 VGND VGND VPWR VPWR sky130_fd_sc_hd__fill_1
XFILLER_8_327 VPWR VGND VPWR VGND sky130_ef_sc_hd__decap_12
XFILLER_12_356 VGND VGND VPWR VPWR sky130_fd_sc_hd__decap_8
X_11402_ clknet_leaf_127_clk _01446_ VGND VGND VPWR VPWR cpuregs\[8\]\[0\] sky130_fd_sc_hd__dfxtp_1
XFILLER_125_203 VPWR VGND VPWR VGND sky130_ef_sc_hd__decap_12
XFILLER_125_225 VGND VGND VPWR VPWR sky130_fd_sc_hd__decap_4
X_11333_ clknet_leaf_27_clk _01380_ VGND VGND VPWR VPWR cpuregs\[5\]\[30\] sky130_fd_sc_hd__dfxtp_1
XFILLER_4_533 VPWR VGND VPWR VGND sky130_ef_sc_hd__decap_12
XFILLER_141_729 VGND VGND VPWR VPWR sky130_fd_sc_hd__decap_4
X_11264_ clknet_leaf_68_clk _01311_ VGND VGND VPWR VPWR cpuregs\[22\]\[25\] sky130_fd_sc_hd__dfxtp_1
XFILLER_140_206 VPWR VGND VPWR VGND sky130_ef_sc_hd__decap_12
XFILLER_21_94 VPWR VGND VPWR VGND sky130_ef_sc_hd__decap_12
XFILLER_134_781 VPWR VGND VPWR VGND sky130_ef_sc_hd__decap_12
X_10215_ clknet_leaf_80_clk _00345_ VGND VGND VPWR VPWR cpuregs\[14\]\[21\] sky130_fd_sc_hd__dfxtp_1
X_11195_ clknet_leaf_74_clk _01242_ VGND VGND VPWR VPWR cpuregs\[29\]\[20\] sky130_fd_sc_hd__dfxtp_1
XFILLER_95_805 VGND VGND VPWR VPWR sky130_fd_sc_hd__decap_3
X_10146_ clknet_leaf_54_clk _00276_ VGND VGND VPWR VPWR cpuregs\[21\]\[16\] sky130_fd_sc_hd__dfxtp_1
XFILLER_0_783 VGND VGND VPWR VPWR sky130_fd_sc_hd__fill_1
XTAP_TAPCELL_ROW_124_2309 VGND VPWR sky130_fd_sc_hd__tapvpwrvgnd_1
XFILLER_48_743 VGND VGND VPWR VPWR sky130_fd_sc_hd__decap_6
X_10077_ clknet_leaf_150_clk _00207_ VGND VGND VPWR VPWR cpuregs\[2\]\[11\] sky130_fd_sc_hd__dfxtp_1
XFILLER_63_735 VGND VGND VPWR VPWR sky130_fd_sc_hd__fill_1
XTAP_TAPCELL_ROW_18_613 VGND VPWR sky130_fd_sc_hd__tapvpwrvgnd_1
XTAP_TAPCELL_ROW_18_624 VGND VPWR sky130_fd_sc_hd__tapvpwrvgnd_1
XFILLER_47_297 VGND VGND VPWR VPWR sky130_fd_sc_hd__fill_1
XFILLER_90_587 VGND VGND VPWR VPWR sky130_fd_sc_hd__fill_1
X_10979_ clknet_leaf_149_clk _01041_ VGND VGND VPWR VPWR cpuregs\[18\]\[11\] sky130_fd_sc_hd__dfxtp_1
XFILLER_43_470 VGND VGND VPWR VPWR sky130_fd_sc_hd__fill_2
XFILLER_71_790 VGND VGND VPWR VPWR sky130_fd_sc_hd__decap_8
XFILLER_30_120 VGND VGND VPWR VPWR sky130_fd_sc_hd__fill_1
XFILLER_31_654 VPWR VGND VPWR VGND sky130_ef_sc_hd__decap_12
XTAP_TAPCELL_ROW_44_1035 VGND VPWR sky130_fd_sc_hd__tapvpwrvgnd_1
XTAP_TAPCELL_ROW_139_2563 VGND VPWR sky130_fd_sc_hd__tapvpwrvgnd_1
XTAP_TAPCELL_ROW_139_2552 VGND VPWR sky130_fd_sc_hd__tapvpwrvgnd_1
XFILLER_30_153 VPWR VGND VPWR VGND sky130_ef_sc_hd__decap_12
X_06170_ reg_pc\[11\] reg_pc\[10\] _02619_ VGND VGND VPWR VPWR _02629_ sky130_fd_sc_hd__and3_1
XFILLER_8_861 VGND VGND VPWR VPWR sky130_fd_sc_hd__decap_6
XTAP_TAPCELL_ROW_152_2763 VGND VPWR sky130_fd_sc_hd__tapvpwrvgnd_1
XFILLER_129_597 VGND VGND VPWR VPWR sky130_fd_sc_hd__decap_3
X_05121_ net14 _01669_ net130 net28 _01730_ VGND VGND VPWR VPWR _01731_ sky130_fd_sc_hd__a221o_1
X_05052_ _01667_ VGND VGND VPWR VPWR _01668_ sky130_fd_sc_hd__inv_2
X_09860_ decoded_imm_j\[4\] _01118_ _02513_ VGND VGND VPWR VPWR _00886_ sky130_fd_sc_hd__mux2_1
XFILLER_112_442 VPWR VGND VPWR VGND sky130_ef_sc_hd__decap_12
X_08811_ cpuregs\[24\]\[18\] cpuregs\[25\]\[18\] cpuregs\[26\]\[18\] cpuregs\[27\]\[18\]
+ net276 net272 VGND VGND VPWR VPWR _04495_ sky130_fd_sc_hd__mux4_1
XFILLER_58_529 VGND VGND VPWR VPWR sky130_fd_sc_hd__decap_3
X_09791_ _02712_ cpuregs\[7\]\[31\] _04874_ VGND VGND VPWR VPWR _01445_ sky130_fd_sc_hd__mux2_1
X_05954_ net223 _01665_ _02478_ VGND VGND VPWR VPWR net117 sky130_fd_sc_hd__a21o_1
X_08742_ _01558_ _04429_ VGND VGND VPWR VPWR _04430_ sky130_fd_sc_hd__or2_1
XFILLER_54_713 VGND VGND VPWR VPWR sky130_fd_sc_hd__fill_2
X_08673_ _04354_ _04363_ _04364_ _01560_ _00010_ VGND VGND VPWR VPWR _04365_ sky130_fd_sc_hd__a221o_1
XFILLER_27_905 VGND VGND VPWR VPWR sky130_fd_sc_hd__decap_3
XFILLER_38_253 VGND VGND VPWR VPWR sky130_fd_sc_hd__decap_4
X_05885_ _02440_ _02439_ instr_sub VGND VGND VPWR VPWR _02441_ sky130_fd_sc_hd__mux2_1
XFILLER_81_510 VPWR VGND VPWR VGND sky130_ef_sc_hd__decap_12
XFILLER_53_201 VPWR VGND VPWR VGND sky130_ef_sc_hd__decap_12
X_07624_ _02616_ cpuregs\[17\]\[8\] _03574_ VGND VGND VPWR VPWR _00556_ sky130_fd_sc_hd__mux2_1
XTAP_TAPCELL_ROW_37_922 VGND VPWR sky130_fd_sc_hd__tapvpwrvgnd_1
X_07555_ cpuregs\[25\]\[6\] _02607_ _03571_ VGND VGND VPWR VPWR _00490_ sky130_fd_sc_hd__mux2_1
X_06506_ cpuregs\[4\]\[7\] cpuregs\[5\]\[7\] cpuregs\[6\]\[7\] cpuregs\[7\]\[7\] net268
+ net259 VGND VGND VPWR VPWR _02937_ sky130_fd_sc_hd__mux4_1
XFILLER_22_643 VGND VGND VPWR VPWR sky130_fd_sc_hd__fill_1
X_07486_ cpuregs\[26\]\[4\] _02598_ _03568_ VGND VGND VPWR VPWR _00424_ sky130_fd_sc_hd__mux2_1
XFILLER_10_805 VGND VGND VPWR VPWR sky130_fd_sc_hd__decap_6
X_09225_ cpuregs\[1\]\[4\] _02598_ net244 VGND VGND VPWR VPWR _00922_ sky130_fd_sc_hd__mux2_1
X_06437_ _02714_ _02866_ _02868_ _02870_ _02724_ VGND VGND VPWR VPWR _02871_ sky130_fd_sc_hd__o41a_1
XFILLER_42_27 VGND VGND VPWR VPWR sky130_fd_sc_hd__fill_1
XFILLER_10_849 VPWR VGND VPWR VGND sky130_ef_sc_hd__decap_12
XFILLER_21_164 VGND VGND VPWR VPWR sky130_fd_sc_hd__decap_4
X_09156_ is_alu_reg_imm _04755_ _04773_ _04747_ instr_srai VGND VGND VPWR VPWR _00880_
+ sky130_fd_sc_hd__a32o_1
X_06368_ net193 net197 _02721_ VGND VGND VPWR VPWR _02803_ sky130_fd_sc_hd__mux2_1
X_05319_ _01909_ _01912_ VGND VGND VPWR VPWR _01914_ sky130_fd_sc_hd__or2_1
XFILLER_107_225 VGND VGND VPWR VPWR sky130_fd_sc_hd__fill_2
X_08107_ _03900_ _03920_ _03908_ VGND VGND VPWR VPWR _03921_ sky130_fd_sc_hd__o21a_1
X_09087_ _04741_ _01098_ VGND VGND VPWR VPWR _04743_ sky130_fd_sc_hd__nor2_1
X_06299_ net258 _02736_ VGND VGND VPWR VPWR _02737_ sky130_fd_sc_hd__or2_1
Xclkbuf_leaf_110_clk clknet_4_11_0_clk VGND VGND VPWR VPWR clknet_leaf_110_clk sky130_fd_sc_hd__clkbuf_8
XFILLER_123_707 VGND VGND VPWR VPWR sky130_fd_sc_hd__decap_8
XTAP_TAPCELL_ROW_92_1810 VGND VPWR sky130_fd_sc_hd__tapvpwrvgnd_1
X_08038_ decoded_imm_j\[14\] _03701_ VGND VGND VPWR VPWR _03857_ sky130_fd_sc_hd__or2_1
XTAP_TAPCELL_ROW_75_1529 VGND VPWR sky130_fd_sc_hd__tapvpwrvgnd_1
XFILLER_150_548 VPWR VGND VPWR VGND sky130_ef_sc_hd__decap_12
XFILLER_1_503 VGND VGND VPWR VPWR sky130_fd_sc_hd__fill_1
XFILLER_131_751 VGND VGND VPWR VPWR sky130_fd_sc_hd__decap_3
XFILLER_103_431 VGND VGND VPWR VPWR sky130_fd_sc_hd__fill_2
X_10000_ clknet_leaf_24_clk _00130_ VGND VGND VPWR VPWR cpuregs\[12\]\[30\] sky130_fd_sc_hd__dfxtp_1
X_09989_ clknet_leaf_73_clk _00119_ VGND VGND VPWR VPWR cpuregs\[12\]\[19\] sky130_fd_sc_hd__dfxtp_1
XFILLER_107_86 VGND VGND VPWR VPWR sky130_fd_sc_hd__decap_8
XFILLER_77_838 VGND VGND VPWR VPWR sky130_fd_sc_hd__fill_2
XTAP_TAPCELL_ROW_106_2028 VGND VPWR sky130_fd_sc_hd__tapvpwrvgnd_1
XFILLER_91_307 VPWR VGND VPWR VGND sky130_ef_sc_hd__decap_12
XFILLER_18_905 VGND VGND VPWR VPWR sky130_fd_sc_hd__decap_6
XFILLER_29_231 VGND VGND VPWR VPWR sky130_fd_sc_hd__fill_1
XTAP_TAPCELL_ROW_4_396 VGND VPWR sky130_fd_sc_hd__tapvpwrvgnd_1
XFILLER_29_297 VGND VGND VPWR VPWR sky130_fd_sc_hd__decap_4
XFILLER_83_45 VGND VGND VPWR VPWR sky130_fd_sc_hd__decap_8
X_10902_ clknet_leaf_5_clk _00964_ VGND VGND VPWR VPWR net165 sky130_fd_sc_hd__dfxtp_1
XFILLER_60_738 VPWR VGND VPWR VGND sky130_ef_sc_hd__decap_12
X_10833_ clknet_leaf_111_clk _00898_ VGND VGND VPWR VPWR decoded_rd\[0\] sky130_fd_sc_hd__dfxtp_1
X_10764_ clknet_leaf_92_clk alu_out\[17\] VGND VGND VPWR VPWR alu_out_q\[17\] sky130_fd_sc_hd__dfxtp_1
XFILLER_16_83 VGND VGND VPWR VPWR sky130_fd_sc_hd__fill_1
XTAP_TAPCELL_ROW_101_1950 VGND VPWR sky130_fd_sc_hd__tapvpwrvgnd_1
XFILLER_12_153 VGND VGND VPWR VPWR sky130_fd_sc_hd__decap_8
X_10695_ clknet_leaf_71_clk _00793_ VGND VGND VPWR VPWR net48 sky130_fd_sc_hd__dfxtp_1
XTAP_TAPCELL_ROW_23_693 VGND VPWR sky130_fd_sc_hd__tapvpwrvgnd_1
XFILLER_40_473 VGND VGND VPWR VPWR sky130_fd_sc_hd__decap_3
XFILLER_40_484 VPWR VGND VPWR VGND sky130_ef_sc_hd__decap_12
XFILLER_139_895 VGND VGND VPWR VPWR sky130_fd_sc_hd__fill_1
XFILLER_138_350 VGND VGND VPWR VPWR sky130_fd_sc_hd__decap_4
XFILLER_12_197 VGND VGND VPWR VPWR sky130_fd_sc_hd__decap_6
Xclkbuf_leaf_101_clk clknet_4_11_0_clk VGND VGND VPWR VPWR clknet_leaf_101_clk sky130_fd_sc_hd__clkbuf_8
XTAP_TAPCELL_ROW_134_2482 VGND VPWR sky130_fd_sc_hd__tapvpwrvgnd_1
XTAP_TAPCELL_ROW_134_2471 VGND VPWR sky130_fd_sc_hd__tapvpwrvgnd_1
X_11316_ clknet_leaf_7_clk _01363_ VGND VGND VPWR VPWR cpuregs\[5\]\[13\] sky130_fd_sc_hd__dfxtp_1
XFILLER_5_853 VPWR VGND VPWR VGND sky130_ef_sc_hd__decap_12
XFILLER_5_897 VPWR VGND VPWR VGND sky130_ef_sc_hd__decap_12
XFILLER_4_363 VGND VGND VPWR VPWR sky130_fd_sc_hd__fill_1
XFILLER_79_131 VGND VGND VPWR VPWR sky130_fd_sc_hd__decap_4
X_11247_ clknet_leaf_1_clk _01294_ VGND VGND VPWR VPWR cpuregs\[22\]\[8\] sky130_fd_sc_hd__dfxtp_1
XFILLER_110_902 VGND VGND VPWR VPWR sky130_fd_sc_hd__decap_6
XFILLER_95_602 VPWR VGND VPWR VGND sky130_ef_sc_hd__decap_12
X_11178_ clknet_leaf_122_clk _01225_ VGND VGND VPWR VPWR cpuregs\[29\]\[3\] sky130_fd_sc_hd__dfxtp_1
X_10129_ clknet_leaf_18_clk _00259_ VGND VGND VPWR VPWR cpuregs\[28\]\[31\] sky130_fd_sc_hd__dfxtp_1
XFILLER_67_337 VGND VGND VPWR VPWR sky130_fd_sc_hd__decap_3
XFILLER_63_521 VPWR VGND VPWR VGND sky130_ef_sc_hd__decap_12
XFILLER_91_841 VGND VGND VPWR VPWR sky130_fd_sc_hd__decap_6
X_05670_ net171 net97 net108 net607 VGND VGND VPWR VPWR _02251_ sky130_fd_sc_hd__a22o_1
XFILLER_35_289 VGND VGND VPWR VPWR sky130_fd_sc_hd__fill_2
X_07340_ cpuregs\[21\]\[24\] _02683_ net248 VGND VGND VPWR VPWR _00284_ sky130_fd_sc_hd__mux2_1
XFILLER_50_237 VPWR VGND VPWR VGND sky130_ef_sc_hd__decap_12
XPHY_EDGE_ROW_35_Left_189 VGND VGND VPWR VPWR sky130_fd_sc_hd__decap_3
XFILLER_149_615 VGND VGND VPWR VPWR sky130_fd_sc_hd__fill_1
X_07271_ cpuregs\[2\]\[22\] _02675_ net250 VGND VGND VPWR VPWR _00218_ sky130_fd_sc_hd__mux2_1
X_09010_ cpuregs\[28\]\[29\] cpuregs\[29\]\[29\] cpuregs\[30\]\[29\] cpuregs\[31\]\[29\]
+ net275 net271 VGND VGND VPWR VPWR _04683_ sky130_fd_sc_hd__mux4_1
XFILLER_136_309 VGND VGND VPWR VPWR sky130_fd_sc_hd__decap_6
X_06222_ _02670_ cpuregs\[11\]\[21\] _02582_ VGND VGND VPWR VPWR _00058_ sky130_fd_sc_hd__mux2_1
XFILLER_145_821 VPWR VGND VPWR VGND sky130_ef_sc_hd__decap_12
XFILLER_117_534 VGND VGND VPWR VPWR sky130_fd_sc_hd__fill_1
X_06153_ reg_pc\[8\] _02610_ _02584_ VGND VGND VPWR VPWR _02615_ sky130_fd_sc_hd__o21ai_1
XFILLER_145_865 VPWR VGND VPWR VGND sky130_ef_sc_hd__decap_12
XFILLER_144_331 VPWR VGND VPWR VGND sky130_ef_sc_hd__decap_12
XTAP_TAPCELL_ROW_57_1237 VGND VPWR sky130_fd_sc_hd__tapvpwrvgnd_1
X_05104_ reg_pc\[4\] decoded_imm\[4\] VGND VGND VPWR VPWR _01715_ sky130_fd_sc_hd__nand2_1
XFILLER_144_386 VGND VGND VPWR VPWR sky130_fd_sc_hd__decap_8
XTAP_TAPCELL_ROW_57_1248 VGND VPWR sky130_fd_sc_hd__tapvpwrvgnd_1
X_06084_ _02551_ _02555_ _02526_ _02547_ VGND VGND VPWR VPWR _02556_ sky130_fd_sc_hd__a211o_1
XPHY_EDGE_ROW_44_Left_198 VGND VGND VPWR VPWR sky130_fd_sc_hd__decap_3
XFILLER_144_29 VPWR VGND VPWR VGND sky130_ef_sc_hd__decap_12
XFILLER_113_751 VGND VGND VPWR VPWR sky130_fd_sc_hd__fill_1
X_05035_ is_lb_lh_lw_lbu_lhu _01655_ VGND VGND VPWR VPWR _01656_ sky130_fd_sc_hd__nor2_1
X_09912_ clknet_leaf_12_clk _00047_ VGND VGND VPWR VPWR cpuregs\[11\]\[10\] sky130_fd_sc_hd__dfxtp_1
XFILLER_100_401 VGND VGND VPWR VPWR sky130_fd_sc_hd__decap_8
X_09843_ _02654_ cpuregs\[10\]\[17\] _04876_ VGND VGND VPWR VPWR _01527_ sky130_fd_sc_hd__mux2_1
XTAP_TAPCELL_ROW_70_1448 VGND VPWR sky130_fd_sc_hd__tapvpwrvgnd_1
XFILLER_112_272 VGND VGND VPWR VPWR sky130_fd_sc_hd__decap_8
XTAP_TAPCELL_ROW_70_1459 VGND VPWR sky130_fd_sc_hd__tapvpwrvgnd_1
X_06986_ _03397_ _03398_ VGND VGND VPWR VPWR _03399_ sky130_fd_sc_hd__nand2_1
X_09774_ _02641_ cpuregs\[7\]\[14\] _04874_ VGND VGND VPWR VPWR _01428_ sky130_fd_sc_hd__mux2_1
XFILLER_86_668 VGND VGND VPWR VPWR sky130_fd_sc_hd__decap_6
XFILLER_37_27 VPWR VGND VPWR VGND sky130_ef_sc_hd__decap_12
X_05937_ mem_wordsize\[1\] net124 net207 _01672_ VGND VGND VPWR VPWR net101 sky130_fd_sc_hd__a22o_1
X_08725_ _01558_ _04411_ _01560_ VGND VGND VPWR VPWR _04414_ sky130_fd_sc_hd__o21a_1
XFILLER_39_573 VGND VGND VPWR VPWR sky130_fd_sc_hd__fill_1
X_05868_ instr_sub _02425_ VGND VGND VPWR VPWR _02426_ sky130_fd_sc_hd__nand2_1
XTAP_TAPCELL_ROW_1_344 VGND VPWR sky130_fd_sc_hd__tapvpwrvgnd_1
XTAP_TAPCELL_ROW_1_355 VGND VPWR sky130_fd_sc_hd__tapvpwrvgnd_1
X_08656_ net270 _04344_ _04343_ _01560_ VGND VGND VPWR VPWR _04349_ sky130_fd_sc_hd__o211a_1
X_07607_ cpuregs\[20\]\[24\] _02683_ _03573_ VGND VGND VPWR VPWR _00540_ sky130_fd_sc_hd__mux2_1
XFILLER_54_587 VGND VGND VPWR VPWR sky130_fd_sc_hd__fill_1
XFILLER_53_26 VGND VGND VPWR VPWR sky130_fd_sc_hd__fill_2
XFILLER_42_716 VGND VGND VPWR VPWR sky130_fd_sc_hd__decap_3
X_08587_ cpuregs\[16\]\[6\] cpuregs\[17\]\[6\] cpuregs\[18\]\[6\] cpuregs\[19\]\[6\]
+ net278 net273 VGND VGND VPWR VPWR _04283_ sky130_fd_sc_hd__mux4_1
X_07538_ _02675_ cpuregs\[16\]\[22\] _03570_ VGND VGND VPWR VPWR _00474_ sky130_fd_sc_hd__mux2_1
X_05799_ _02362_ _02363_ VGND VGND VPWR VPWR _02364_ sky130_fd_sc_hd__nor2_1
XTAP_TAPCELL_ROW_85_1691 VGND VPWR sky130_fd_sc_hd__tapvpwrvgnd_1
XFILLER_53_37 VPWR VGND VPWR VGND sky130_ef_sc_hd__decap_12
X_07469_ cpuregs\[15\]\[20\] _02665_ net246 VGND VGND VPWR VPWR _00408_ sky130_fd_sc_hd__mux2_1
XFILLER_139_169 VPWR VGND VPWR VGND sky130_ef_sc_hd__decap_12
X_10480_ clknet_leaf_81_clk _00610_ VGND VGND VPWR VPWR count_instr\[29\] sky130_fd_sc_hd__dfxtp_1
X_09208_ _01099_ _01098_ VGND VGND VPWR VPWR _04793_ sky130_fd_sc_hd__nor2_1
XFILLER_10_657 VGND VGND VPWR VPWR sky130_fd_sc_hd__decap_4
Xrebuffer221 net182 VGND VGND VPWR VPWR net607 sky130_fd_sc_hd__dlygate4sd1_1
X_09139_ _04752_ _04767_ _04769_ VGND VGND VPWR VPWR _04770_ sky130_fd_sc_hd__and3_1
XFILLER_5_105 VGND VGND VPWR VPWR sky130_fd_sc_hd__decap_6
XTAP_TAPCELL_ROW_20_652 VGND VPWR sky130_fd_sc_hd__tapvpwrvgnd_1
XFILLER_118_41 VPWR VGND VPWR VGND sky130_ef_sc_hd__decap_12
XFILLER_5_149 VPWR VGND VPWR VGND sky130_ef_sc_hd__decap_12
XTAP_TAPCELL_ROW_116_2190 VGND VPWR sky130_fd_sc_hd__tapvpwrvgnd_1
X_11101_ clknet_leaf_128_clk _00004_ VGND VGND VPWR VPWR reg_sh\[2\] sky130_fd_sc_hd__dfxtp_1
XFILLER_150_345 VGND VGND VPWR VPWR sky130_fd_sc_hd__fill_2
XFILLER_118_96 VGND VGND VPWR VPWR sky130_fd_sc_hd__decap_4
XFILLER_118_85 VGND VGND VPWR VPWR sky130_fd_sc_hd__fill_2
XFILLER_89_440 VGND VGND VPWR VPWR sky130_fd_sc_hd__fill_1
XTAP_TAPCELL_ROW_9_477 VGND VPWR sky130_fd_sc_hd__tapvpwrvgnd_1
XFILLER_2_867 VGND VGND VPWR VPWR sky130_fd_sc_hd__fill_1
X_11032_ clknet_leaf_88_clk _00032_ VGND VGND VPWR VPWR _00012_ sky130_fd_sc_hd__dfxtp_4
XFILLER_77_635 VGND VGND VPWR VPWR sky130_fd_sc_hd__fill_1
XFILLER_94_77 VGND VGND VPWR VPWR sky130_fd_sc_hd__decap_6
XFILLER_94_66 VGND VGND VPWR VPWR sky130_fd_sc_hd__fill_2
XFILLER_17_212 VGND VGND VPWR VPWR sky130_fd_sc_hd__decap_4
XFILLER_18_757 VPWR VGND VPWR VGND sky130_ef_sc_hd__decap_12
XFILLER_150_83 VGND VGND VPWR VPWR sky130_fd_sc_hd__fill_1
XFILLER_73_874 VGND VGND VPWR VPWR sky130_fd_sc_hd__decap_3
XFILLER_72_362 VGND VGND VPWR VPWR sky130_fd_sc_hd__fill_2
XTAP_TAPCELL_ROW_28_774 VGND VPWR sky130_fd_sc_hd__tapvpwrvgnd_1
XTAP_TAPCELL_ROW_28_785 VGND VPWR sky130_fd_sc_hd__tapvpwrvgnd_1
XFILLER_45_565 VGND VGND VPWR VPWR sky130_fd_sc_hd__fill_1
XFILLER_32_237 VPWR VGND VPWR VGND sky130_ef_sc_hd__decap_12
X_10816_ clknet_leaf_88_clk _00881_ VGND VGND VPWR VPWR instr_rdcycle sky130_fd_sc_hd__dfxtp_1
XTAP_TAPCELL_ROW_136_2511 VGND VPWR sky130_fd_sc_hd__tapvpwrvgnd_1
XTAP_TAPCELL_ROW_136_2500 VGND VPWR sky130_fd_sc_hd__tapvpwrvgnd_1
X_10747_ clknet_leaf_100_clk alu_out\[0\] VGND VGND VPWR VPWR alu_out_q\[0\] sky130_fd_sc_hd__dfxtp_1
XFILLER_13_462 VGND VGND VPWR VPWR sky130_fd_sc_hd__fill_1
XFILLER_145_106 VGND VGND VPWR VPWR sky130_fd_sc_hd__decap_6
XFILLER_118_309 VGND VGND VPWR VPWR sky130_fd_sc_hd__decap_6
XFILLER_9_477 VPWR VGND VPWR VGND sky130_ef_sc_hd__decap_12
XFILLER_9_455 VGND VGND VPWR VPWR sky130_fd_sc_hd__fill_1
X_10678_ clknet_leaf_123_clk _00776_ VGND VGND VPWR VPWR net61 sky130_fd_sc_hd__dfxtp_1
XFILLER_127_821 VPWR VGND VPWR VGND sky130_ef_sc_hd__decap_12
XFILLER_127_865 VPWR VGND VPWR VGND sky130_ef_sc_hd__decap_12
Xoutput207 net207 VGND VGND VPWR VPWR pcpi_rs2[13] sky130_fd_sc_hd__buf_2
Xoutput218 net218 VGND VGND VPWR VPWR pcpi_rs2[23] sky130_fd_sc_hd__buf_2
XFILLER_142_813 VPWR VGND VPWR VGND sky130_ef_sc_hd__decap_12
Xoutput229 net229 VGND VGND VPWR VPWR pcpi_rs2[4] sky130_fd_sc_hd__buf_2
XFILLER_5_694 VPWR VGND VPWR VGND sky130_ef_sc_hd__decap_12
XFILLER_4_53 VPWR VGND VPWR VGND sky130_ef_sc_hd__decap_12
X_06840_ _03248_ _03249_ _00014_ VGND VGND VPWR VPWR _03259_ sky130_fd_sc_hd__mux2_1
XFILLER_122_581 VGND VGND VPWR VPWR sky130_fd_sc_hd__decap_6
XTAP_TAPCELL_ROW_52_1167 VGND VPWR sky130_fd_sc_hd__tapvpwrvgnd_1
XTAP_TAPCELL_ROW_52_1156 VGND VPWR sky130_fd_sc_hd__tapvpwrvgnd_1
XFILLER_4_97 VPWR VGND VPWR VGND sky130_ef_sc_hd__decap_12
XTAP_TAPCELL_ROW_147_2684 VGND VPWR sky130_fd_sc_hd__tapvpwrvgnd_1
XFILLER_67_167 VGND VGND VPWR VPWR sky130_fd_sc_hd__fill_1
X_06771_ net178 _02721_ VGND VGND VPWR VPWR _03192_ sky130_fd_sc_hd__or2_1
X_09490_ cpuregs\[24\]\[28\] _02699_ net241 VGND VGND VPWR VPWR _01154_ sky130_fd_sc_hd__mux2_1
X_05722_ net233 net201 instr_sub VGND VGND VPWR VPWR _02296_ sky130_fd_sc_hd__nand3b_1
X_08510_ _04214_ mem_do_rinst _04211_ VGND VGND VPWR VPWR _04215_ sky130_fd_sc_hd__mux2_1
X_05653_ _02048_ _02175_ _02232_ _02235_ VGND VGND VPWR VPWR _02236_ sky130_fd_sc_hd__o22a_2
X_08441_ net259 _04177_ VGND VGND VPWR VPWR _04178_ sky130_fd_sc_hd__or2_1
XFILLER_51_502 VGND VGND VPWR VPWR sky130_fd_sc_hd__fill_2
XFILLER_23_237 VPWR VGND VPWR VGND sky130_ef_sc_hd__decap_12
X_08372_ count_cycle\[41\] _04129_ _04131_ VGND VGND VPWR VPWR _00748_ sky130_fd_sc_hd__o21a_1
XFILLER_51_557 VGND VGND VPWR VPWR sky130_fd_sc_hd__decap_3
X_05584_ _02165_ _02166_ VGND VGND VPWR VPWR _02167_ sky130_fd_sc_hd__nor2_1
XFILLER_149_423 VGND VGND VPWR VPWR sky130_fd_sc_hd__fill_1
X_07323_ cpuregs\[21\]\[7\] _02612_ net248 VGND VGND VPWR VPWR _00267_ sky130_fd_sc_hd__mux2_1
XFILLER_137_607 VGND VGND VPWR VPWR sky130_fd_sc_hd__decap_8
XFILLER_109_309 VGND VGND VPWR VPWR sky130_fd_sc_hd__decap_8
X_07254_ cpuregs\[2\]\[5\] _02603_ net250 VGND VGND VPWR VPWR _00201_ sky130_fd_sc_hd__mux2_1
XFILLER_31_281 VGND VGND VPWR VPWR sky130_fd_sc_hd__decap_4
XFILLER_118_821 VPWR VGND VPWR VGND sky130_ef_sc_hd__decap_12
X_06205_ _02655_ _02656_ _02584_ VGND VGND VPWR VPWR _02657_ sky130_fd_sc_hd__mux2_8
XFILLER_129_180 VGND VGND VPWR VPWR sky130_fd_sc_hd__fill_1
XFILLER_118_865 VGND VGND VPWR VPWR sky130_fd_sc_hd__decap_3
XPHY_EDGE_ROW_52_Left_206 VGND VGND VPWR VPWR sky130_fd_sc_hd__decap_3
X_07185_ cpuregs\[30\]\[3\] _02593_ net252 VGND VGND VPWR VPWR _00135_ sky130_fd_sc_hd__mux2_1
X_06136_ reg_pc\[5\] _02595_ VGND VGND VPWR VPWR _02601_ sky130_fd_sc_hd__and2_1
X_06067_ _01638_ _02538_ _01639_ VGND VGND VPWR VPWR _02539_ sky130_fd_sc_hd__a21oi_1
XTAP_TAPCELL_ROW_6_425 VGND VPWR sky130_fd_sc_hd__tapvpwrvgnd_1
X_05018_ _01554_ _01640_ VGND VGND VPWR VPWR _01641_ sky130_fd_sc_hd__nor2_8
XFILLER_86_421 VPWR VGND VPWR VGND sky130_ef_sc_hd__decap_12
XFILLER_100_253 VGND VGND VPWR VPWR sky130_fd_sc_hd__fill_1
XFILLER_86_454 VGND VGND VPWR VPWR sky130_fd_sc_hd__decap_3
X_09826_ _02586_ cpuregs\[10\]\[0\] _04876_ VGND VGND VPWR VPWR _01510_ sky130_fd_sc_hd__mux2_1
X_06969_ cpuregs\[28\]\[24\] cpuregs\[29\]\[24\] cpuregs\[30\]\[24\] cpuregs\[31\]\[24\]
+ net267 net261 VGND VGND VPWR VPWR _03383_ sky130_fd_sc_hd__mux4_1
X_09757_ _02709_ cpuregs\[6\]\[30\] _04873_ VGND VGND VPWR VPWR _01412_ sky130_fd_sc_hd__mux2_1
XTAP_TAPCELL_ROW_87_1720 VGND VPWR sky130_fd_sc_hd__tapvpwrvgnd_1
XFILLER_73_126 VGND VGND VPWR VPWR sky130_fd_sc_hd__fill_1
XTAP_TAPCELL_ROW_87_1731 VGND VPWR sky130_fd_sc_hd__tapvpwrvgnd_1
X_08708_ _04388_ _04396_ _04397_ _01560_ _00010_ VGND VGND VPWR VPWR _04398_ sky130_fd_sc_hd__a221o_1
XPHY_EDGE_ROW_61_Left_215 VGND VGND VPWR VPWR sky130_fd_sc_hd__decap_3
XFILLER_27_521 VGND VGND VPWR VPWR sky130_fd_sc_hd__fill_1
X_09688_ cpuregs\[4\]\[27\] _02696_ net238 VGND VGND VPWR VPWR _01345_ sky130_fd_sc_hd__mux2_1
XFILLER_54_373 VGND VGND VPWR VPWR sky130_fd_sc_hd__fill_2
XFILLER_70_844 VPWR VGND VPWR VGND sky130_ef_sc_hd__decap_12
XTAP_TAPCELL_ROW_25_733 VGND VPWR sky130_fd_sc_hd__tapvpwrvgnd_1
X_08639_ _04331_ _04332_ _04266_ _04329_ VGND VGND VPWR VPWR _04333_ sky130_fd_sc_hd__o211a_1
XFILLER_147_3 VPWR VGND VPWR VGND sky130_ef_sc_hd__decap_12
XFILLER_120_97 VGND VGND VPWR VPWR sky130_fd_sc_hd__decap_3
X_10601_ clknet_leaf_90_clk _00731_ VGND VGND VPWR VPWR count_cycle\[24\] sky130_fd_sc_hd__dfxtp_1
XFILLER_70_899 VGND VGND VPWR VPWR sky130_fd_sc_hd__fill_1
XFILLER_23_782 VGND VGND VPWR VPWR sky130_fd_sc_hd__fill_2
XFILLER_127_106 VGND VGND VPWR VPWR sky130_fd_sc_hd__decap_6
X_10532_ clknet_leaf_90_clk _00662_ VGND VGND VPWR VPWR reg_pc\[18\] sky130_fd_sc_hd__dfxtp_2
XFILLER_10_443 VPWR VGND VPWR VGND sky130_ef_sc_hd__decap_12
XFILLER_13_51 VGND VGND VPWR VPWR sky130_fd_sc_hd__decap_4
XFILLER_129_51 VGND VGND VPWR VPWR sky130_fd_sc_hd__decap_4
XFILLER_109_810 VPWR VGND VPWR VGND sky130_ef_sc_hd__decap_12
XPHY_EDGE_ROW_70_Left_224 VGND VGND VPWR VPWR sky130_fd_sc_hd__decap_3
XTAP_TAPCELL_ROW_98_1893 VGND VPWR sky130_fd_sc_hd__tapvpwrvgnd_1
X_10463_ clknet_leaf_105_clk _00593_ VGND VGND VPWR VPWR count_instr\[12\] sky130_fd_sc_hd__dfxtp_1
XFILLER_6_469 VGND VGND VPWR VPWR sky130_fd_sc_hd__fill_2
XFILLER_136_684 VPWR VGND VPWR VGND sky130_ef_sc_hd__decap_12
XTAP_TAPCELL_ROW_131_2430 VGND VPWR sky130_fd_sc_hd__tapvpwrvgnd_1
XFILLER_124_813 VPWR VGND VPWR VGND sky130_ef_sc_hd__decap_12
XTAP_TAPCELL_ROW_114_2149 VGND VPWR sky130_fd_sc_hd__tapvpwrvgnd_1
XFILLER_89_55 VGND VGND VPWR VPWR sky130_fd_sc_hd__fill_1
X_10394_ clknet_leaf_136_clk _00524_ VGND VGND VPWR VPWR cpuregs\[20\]\[8\] sky130_fd_sc_hd__dfxtp_1
XFILLER_135_194 VGND VGND VPWR VPWR sky130_fd_sc_hd__decap_6
XFILLER_150_153 VPWR VGND VPWR VGND sky130_ef_sc_hd__decap_12
XFILLER_150_197 VPWR VGND VPWR VGND sky130_ef_sc_hd__decap_12
XFILLER_104_592 VGND VGND VPWR VPWR sky130_fd_sc_hd__fill_2
XFILLER_89_281 VGND VGND VPWR VPWR sky130_fd_sc_hd__fill_1
X_11015_ clknet_leaf_21_clk _01077_ VGND VGND VPWR VPWR cpuregs\[19\]\[15\] sky130_fd_sc_hd__dfxtp_1
XFILLER_77_432 VPWR VGND VPWR VGND sky130_ef_sc_hd__decap_12
XTAP_TAPCELL_ROW_129_2392 VGND VPWR sky130_fd_sc_hd__tapvpwrvgnd_1
XFILLER_64_115 VGND VGND VPWR VPWR sky130_fd_sc_hd__fill_1
XFILLER_92_468 VGND VGND VPWR VPWR sky130_fd_sc_hd__decap_8
XFILLER_58_690 VGND VGND VPWR VPWR sky130_fd_sc_hd__decap_8
XFILLER_18_598 VGND VGND VPWR VPWR sky130_fd_sc_hd__decap_8
XFILLER_33_546 VPWR VGND VPWR VGND sky130_ef_sc_hd__decap_12
XFILLER_33_524 VPWR VGND VPWR VGND sky130_ef_sc_hd__decap_12
XFILLER_45_373 VGND VGND VPWR VPWR sky130_fd_sc_hd__decap_8
XFILLER_60_365 VPWR VGND VPWR VGND sky130_ef_sc_hd__decap_12
XFILLER_146_404 VPWR VGND VPWR VGND sky130_ef_sc_hd__decap_12
XFILLER_119_629 VPWR VGND VPWR VGND sky130_ef_sc_hd__decap_12
XPHY_EDGE_ROW_109_Left_263 VGND VGND VPWR VPWR sky130_fd_sc_hd__decap_3
XFILLER_13_281 VGND VGND VPWR VPWR sky130_fd_sc_hd__decap_8
XFILLER_118_139 VGND VGND VPWR VPWR sky130_fd_sc_hd__fill_1
Xclkload11 clknet_4_14_0_clk VGND VGND VPWR VPWR clkload11/X sky130_fd_sc_hd__clkbuf_8
Xclkload22 clknet_leaf_7_clk VGND VGND VPWR VPWR clkload22/Y sky130_fd_sc_hd__inv_6
Xclkload44 clknet_leaf_135_clk VGND VGND VPWR VPWR clkload44/Y sky130_fd_sc_hd__inv_8
Xclkload33 clknet_leaf_142_clk VGND VGND VPWR VPWR clkload33/Y sky130_fd_sc_hd__clkinv_4
Xclkload77 clknet_leaf_49_clk VGND VGND VPWR VPWR clkload77/Y sky130_fd_sc_hd__inv_8
Xclkload55 clknet_leaf_31_clk VGND VGND VPWR VPWR clkload55/Y sky130_fd_sc_hd__inv_12
Xclkload66 clknet_leaf_54_clk VGND VGND VPWR VPWR clkload66/X sky130_fd_sc_hd__clkbuf_4
XFILLER_142_654 VPWR VGND VPWR VGND sky130_ef_sc_hd__decap_12
XFILLER_126_183 VGND VGND VPWR VPWR sky130_fd_sc_hd__decap_4
XFILLER_88_708 VGND VGND VPWR VPWR sky130_fd_sc_hd__decap_4
Xclkload99 clknet_leaf_116_clk VGND VGND VPWR VPWR clkload99/Y sky130_fd_sc_hd__inv_6
Xclkload88 clknet_leaf_128_clk VGND VGND VPWR VPWR clkload88/Y sky130_fd_sc_hd__inv_4
XTAP_TAPCELL_ROW_149_2713 VGND VPWR sky130_fd_sc_hd__tapvpwrvgnd_1
X_08990_ net222 _01585_ _04663_ _04664_ VGND VGND VPWR VPWR _00833_ sky130_fd_sc_hd__o22a_1
XFILLER_130_849 VPWR VGND VPWR VGND sky130_ef_sc_hd__decap_12
XPHY_EDGE_ROW_118_Left_272 VGND VGND VPWR VPWR sky130_fd_sc_hd__decap_3
XFILLER_68_421 VGND VGND VPWR VPWR sky130_fd_sc_hd__fill_2
X_07941_ _01551_ _03766_ _03767_ VGND VGND VPWR VPWR _03768_ sky130_fd_sc_hd__or3_1
X_07872_ reg_pc\[24\] _01624_ _01628_ _03711_ VGND VGND VPWR VPWR _00668_ sky130_fd_sc_hd__a22o_1
XFILLER_96_752 VGND VGND VPWR VPWR sky130_fd_sc_hd__decap_4
XFILLER_95_251 VGND VGND VPWR VPWR sky130_fd_sc_hd__fill_2
X_09611_ _02654_ cpuregs\[3\]\[17\] _04868_ VGND VGND VPWR VPWR _01271_ sky130_fd_sc_hd__mux2_1
X_06823_ _03240_ _03241_ VGND VGND VPWR VPWR _03242_ sky130_fd_sc_hd__xnor2_1
XFILLER_95_262 VGND VGND VPWR VPWR sky130_fd_sc_hd__decap_8
XFILLER_68_498 VGND VGND VPWR VPWR sky130_fd_sc_hd__fill_2
XFILLER_18_29 VPWR VGND VPWR VGND sky130_ef_sc_hd__decap_12
XFILLER_28_307 VGND VGND VPWR VPWR sky130_fd_sc_hd__fill_1
X_06754_ cpuregs\[0\]\[16\] cpuregs\[1\]\[16\] cpuregs\[2\]\[16\] cpuregs\[3\]\[16\]
+ net265 net260 VGND VGND VPWR VPWR _03176_ sky130_fd_sc_hd__mux4_1
XFILLER_83_446 VGND VGND VPWR VPWR sky130_fd_sc_hd__fill_2
X_09542_ cpuregs\[23\]\[14\] _02641_ _04866_ VGND VGND VPWR VPWR _01204_ sky130_fd_sc_hd__mux2_1
XFILLER_37_830 VGND VGND VPWR VPWR sky130_fd_sc_hd__decap_8
XFILLER_37_841 VPWR VGND VPWR VGND sky130_ef_sc_hd__decap_12
XFILLER_83_479 VGND VGND VPWR VPWR sky130_fd_sc_hd__fill_2
X_05705_ _02162_ _02275_ _02163_ VGND VGND VPWR VPWR _02281_ sky130_fd_sc_hd__a21o_1
XFILLER_36_362 VGND VGND VPWR VPWR sky130_fd_sc_hd__fill_2
Xclkbuf_leaf_90_clk clknet_4_14_0_clk VGND VGND VPWR VPWR clknet_leaf_90_clk sky130_fd_sc_hd__clkbuf_8
X_06685_ _03082_ _03085_ _03108_ VGND VGND VPWR VPWR _03109_ sky130_fd_sc_hd__and3_1
XFILLER_52_833 VGND VGND VPWR VPWR sky130_fd_sc_hd__fill_1
X_09473_ cpuregs\[24\]\[11\] _02630_ net242 VGND VGND VPWR VPWR _01137_ sky130_fd_sc_hd__mux2_1
XFILLER_24_513 VGND VGND VPWR VPWR sky130_fd_sc_hd__fill_1
X_08424_ _04163_ _04164_ VGND VGND VPWR VPWR _00767_ sky130_fd_sc_hd__nor2_1
X_05636_ _02085_ _02088_ _02218_ VGND VGND VPWR VPWR _02219_ sky130_fd_sc_hd__or3b_1
XTAP_TAPCELL_ROW_82_1650 VGND VPWR sky130_fd_sc_hd__tapvpwrvgnd_1
XTAP_TAPCELL_ROW_65_1369 VGND VPWR sky130_fd_sc_hd__tapvpwrvgnd_1
XPHY_EDGE_ROW_127_Left_281 VGND VGND VPWR VPWR sky130_fd_sc_hd__decap_3
X_05567_ net175 net207 VGND VGND VPWR VPWR _02150_ sky130_fd_sc_hd__nor2_1
X_08355_ count_cycle\[35\] _04119_ _01549_ VGND VGND VPWR VPWR _04121_ sky130_fd_sc_hd__a21oi_1
XFILLER_138_905 VGND VGND VPWR VPWR sky130_fd_sc_hd__decap_6
X_07306_ cpuregs\[28\]\[24\] _02683_ net249 VGND VGND VPWR VPWR _00252_ sky130_fd_sc_hd__mux2_1
Xclkload5 clknet_4_6_0_clk VGND VGND VPWR VPWR clkload5/Y sky130_fd_sc_hd__clkinvlp_4
XFILLER_149_297 VPWR VGND VPWR VGND sky130_ef_sc_hd__decap_12
XFILLER_149_275 VGND VGND VPWR VPWR sky130_fd_sc_hd__decap_4
X_05498_ _02080_ VGND VGND VPWR VPWR _02081_ sky130_fd_sc_hd__inv_2
X_08286_ count_cycle\[10\] net447 count_cycle\[11\] VGND VGND VPWR VPWR _04076_ sky130_fd_sc_hd__a21o_1
XFILLER_50_27 VGND VGND VPWR VPWR sky130_fd_sc_hd__fill_1
XFILLER_118_651 VGND VGND VPWR VPWR sky130_fd_sc_hd__decap_3
XFILLER_119_7 VPWR VGND VPWR VGND sky130_ef_sc_hd__decap_12
X_07237_ cpuregs\[13\]\[21\] _02670_ _03558_ VGND VGND VPWR VPWR _00185_ sky130_fd_sc_hd__mux2_1
X_07168_ cpuregs\[12\]\[22\] _02675_ net253 VGND VGND VPWR VPWR _00122_ sky130_fd_sc_hd__mux2_1
XFILLER_118_684 VGND VGND VPWR VPWR sky130_fd_sc_hd__fill_2
XFILLER_118_673 VGND VGND VPWR VPWR sky130_fd_sc_hd__fill_1
XFILLER_3_417 VPWR VGND VPWR VGND sky130_ef_sc_hd__decap_12
X_06119_ reg_pc\[1\] _02587_ _02583_ VGND VGND VPWR VPWR _02588_ sky130_fd_sc_hd__mux2_8
XPHY_EDGE_ROW_136_Left_290 VGND VGND VPWR VPWR sky130_fd_sc_hd__decap_3
X_07099_ net191 _02721_ _03428_ _01641_ VGND VGND VPWR VPWR _03508_ sky130_fd_sc_hd__o211a_1
XFILLER_132_197 VGND VGND VPWR VPWR sky130_fd_sc_hd__fill_2
XFILLER_101_540 VGND VGND VPWR VPWR sky130_fd_sc_hd__fill_2
X_09809_ _02649_ cpuregs\[8\]\[16\] _04875_ VGND VGND VPWR VPWR _01462_ sky130_fd_sc_hd__mux2_1
XFILLER_86_284 VPWR VGND VPWR VGND sky130_ef_sc_hd__decap_12
XFILLER_75_35 VPWR VGND VPWR VGND sky130_ef_sc_hd__decap_12
XFILLER_74_402 VPWR VGND VPWR VGND sky130_ef_sc_hd__decap_12
XFILLER_59_476 VGND VGND VPWR VPWR sky130_fd_sc_hd__fill_1
XFILLER_74_468 VGND VGND VPWR VPWR sky130_fd_sc_hd__decap_8
Xclkbuf_leaf_81_clk clknet_4_14_0_clk VGND VGND VPWR VPWR clknet_leaf_81_clk sky130_fd_sc_hd__clkbuf_8
XFILLER_15_579 VGND VGND VPWR VPWR sky130_fd_sc_hd__fill_1
XFILLER_91_78 VGND VGND VPWR VPWR sky130_fd_sc_hd__decap_8
XFILLER_70_696 VGND VGND VPWR VPWR sky130_fd_sc_hd__decap_4
XFILLER_70_685 VGND VGND VPWR VPWR sky130_fd_sc_hd__decap_6
XFILLER_42_365 VGND VGND VPWR VPWR sky130_fd_sc_hd__decap_4
XFILLER_23_590 VGND VGND VPWR VPWR sky130_fd_sc_hd__decap_3
XFILLER_24_83 VGND VGND VPWR VPWR sky130_fd_sc_hd__fill_1
XFILLER_11_785 VPWR VGND VPWR VGND sky130_ef_sc_hd__decap_12
X_11495_ clknet_leaf_34_clk _01539_ VGND VGND VPWR VPWR cpuregs\[10\]\[29\] sky130_fd_sc_hd__dfxtp_1
XFILLER_109_640 VGND VGND VPWR VPWR sky130_fd_sc_hd__fill_1
XFILLER_6_233 VPWR VGND VPWR VGND sky130_ef_sc_hd__decap_12
X_10515_ clknet_leaf_101_clk _00645_ VGND VGND VPWR VPWR reg_pc\[1\] sky130_fd_sc_hd__dfxtp_1
X_10446_ clknet_leaf_39_clk _00576_ VGND VGND VPWR VPWR cpuregs\[17\]\[28\] sky130_fd_sc_hd__dfxtp_1
XFILLER_109_673 VGND VGND VPWR VPWR sky130_fd_sc_hd__fill_2
XFILLER_6_277 VPWR VGND VPWR VGND sky130_ef_sc_hd__decap_12
X_10377_ clknet_leaf_51_clk _00507_ VGND VGND VPWR VPWR cpuregs\[25\]\[23\] sky130_fd_sc_hd__dfxtp_1
XFILLER_69_218 VGND VGND VPWR VPWR sky130_fd_sc_hd__decap_6
XFILLER_2_472 VGND VGND VPWR VPWR sky130_fd_sc_hd__decap_4
XFILLER_78_763 VGND VGND VPWR VPWR sky130_fd_sc_hd__decap_3
XFILLER_49_80 VGND VGND VPWR VPWR sky130_fd_sc_hd__fill_1
XTAP_TAPCELL_ROW_144_2632 VGND VPWR sky130_fd_sc_hd__tapvpwrvgnd_1
XFILLER_120_893 VPWR VGND VPWR VGND sky130_ef_sc_hd__decap_12
XFILLER_77_251 VGND VGND VPWR VPWR sky130_fd_sc_hd__decap_8
XFILLER_65_413 VGND VGND VPWR VPWR sky130_fd_sc_hd__decap_6
XFILLER_38_627 VPWR VGND VPWR VGND sky130_ef_sc_hd__decap_12
XTAP_TAPCELL_ROW_144_2643 VGND VPWR sky130_fd_sc_hd__tapvpwrvgnd_1
XFILLER_65_435 VPWR VGND VPWR VGND sky130_ef_sc_hd__decap_12
XFILLER_19_841 VPWR VGND VPWR VGND sky130_ef_sc_hd__decap_12
XFILLER_93_799 VPWR VGND VPWR VGND sky130_ef_sc_hd__decap_12
XFILLER_93_777 VGND VGND VPWR VPWR sky130_fd_sc_hd__decap_6
XFILLER_80_416 VGND VGND VPWR VPWR sky130_fd_sc_hd__decap_4
XFILLER_34_811 VGND VGND VPWR VPWR sky130_fd_sc_hd__fill_1
Xclkbuf_leaf_72_clk clknet_4_13_0_clk VGND VGND VPWR VPWR clknet_leaf_72_clk sky130_fd_sc_hd__clkbuf_8
X_06470_ _02897_ _02900_ _01622_ VGND VGND VPWR VPWR _02902_ sky130_fd_sc_hd__o21a_1
X_05421_ _02006_ _02007_ VGND VGND VPWR VPWR _02008_ sky130_fd_sc_hd__nand2_1
XTAP_TAPCELL_ROW_47_1077 VGND VPWR sky130_fd_sc_hd__tapvpwrvgnd_1
XTAP_TAPCELL_ROW_47_1088 VGND VPWR sky130_fd_sc_hd__tapvpwrvgnd_1
X_08140_ _01547_ reg_next_pc\[21\] _01645_ _03708_ VGND VGND VPWR VPWR _03952_ sky130_fd_sc_hd__a22o_1
XFILLER_60_184 VPWR VGND VPWR VGND sky130_ef_sc_hd__decap_12
XTAP_TAPCELL_ROW_16_585 VGND VPWR sky130_fd_sc_hd__tapvpwrvgnd_1
XFILLER_147_724 VGND VGND VPWR VPWR sky130_fd_sc_hd__decap_4
X_05352_ _01943_ VGND VGND VPWR VPWR _01944_ sky130_fd_sc_hd__inv_2
Xclkload122 clknet_leaf_71_clk VGND VGND VPWR VPWR clkload122/Y sky130_fd_sc_hd__clkinvlp_4
Xclkload111 clknet_leaf_59_clk VGND VGND VPWR VPWR clkload111/Y sky130_fd_sc_hd__bufinv_16
X_05283_ count_instr\[17\] instr_rdinstr count_cycle\[49\] instr_rdcycleh VGND VGND
+ VPWR VPWR _01881_ sky130_fd_sc_hd__a22o_1
X_08071_ _03884_ _03887_ _03576_ VGND VGND VPWR VPWR _03888_ sky130_fd_sc_hd__a21oi_1
XTAP_TAPCELL_ROW_60_1299 VGND VPWR sky130_fd_sc_hd__tapvpwrvgnd_1
XTAP_TAPCELL_ROW_60_1288 VGND VPWR sky130_fd_sc_hd__tapvpwrvgnd_1
Xclkload100 clknet_leaf_117_clk VGND VGND VPWR VPWR clkload100/Y sky130_fd_sc_hd__clkinv_8
XFILLER_146_278 VGND VGND VPWR VPWR sky130_fd_sc_hd__decap_6
X_07022_ cpuregs\[28\]\[26\] cpuregs\[29\]\[26\] cpuregs\[30\]\[26\] cpuregs\[31\]\[26\]
+ net266 net261 VGND VGND VPWR VPWR _03434_ sky130_fd_sc_hd__mux4_1
Xclkload133 clknet_leaf_90_clk VGND VGND VPWR VPWR clkload133/Y sky130_fd_sc_hd__inv_8
X_08973_ cpuregs\[16\]\[27\] cpuregs\[17\]\[27\] cpuregs\[18\]\[27\] cpuregs\[19\]\[27\]
+ net280 net271 VGND VGND VPWR VPWR _04648_ sky130_fd_sc_hd__mux4_1
XFILLER_88_538 VGND VGND VPWR VPWR sky130_fd_sc_hd__decap_8
XFILLER_114_197 VGND VGND VPWR VPWR sky130_fd_sc_hd__fill_1
XFILLER_69_741 VPWR VGND VPWR VGND sky130_ef_sc_hd__decap_12
X_07924_ decoded_imm_j\[5\] _03692_ VGND VGND VPWR VPWR _03752_ sky130_fd_sc_hd__and2_1
XFILLER_29_39 VGND VGND VPWR VPWR sky130_fd_sc_hd__decap_8
XFILLER_152_29 VPWR VGND VPWR VGND sky130_ef_sc_hd__decap_12
XFILLER_96_582 VGND VGND VPWR VPWR sky130_fd_sc_hd__decap_6
XFILLER_68_262 VGND VGND VPWR VPWR sky130_fd_sc_hd__decap_8
X_07855_ _02647_ reg_next_pc\[16\] _02482_ VGND VGND VPWR VPWR _03703_ sky130_fd_sc_hd__mux2_1
X_06806_ cpuregs\[4\]\[18\] cpuregs\[5\]\[18\] cpuregs\[6\]\[18\] cpuregs\[7\]\[18\]
+ net267 net260 VGND VGND VPWR VPWR _03226_ sky130_fd_sc_hd__mux4_1
X_07786_ _03663_ net34 _03662_ VGND VGND VPWR VPWR _00630_ sky130_fd_sc_hd__and3b_1
XFILLER_83_243 VGND VGND VPWR VPWR sky130_fd_sc_hd__decap_4
XTAP_TAPCELL_ROW_67_1409 VGND VPWR sky130_fd_sc_hd__tapvpwrvgnd_1
X_04998_ mem_do_wdata cpu_state\[5\] _01614_ _01625_ VGND VGND VPWR VPWR _01626_ sky130_fd_sc_hd__a31o_1
X_09525_ cpuregs\[31\]\[30\] _02709_ net240 VGND VGND VPWR VPWR _01188_ sky130_fd_sc_hd__mux2_1
X_06737_ decoded_imm\[15\] net177 _03158_ VGND VGND VPWR VPWR _03159_ sky130_fd_sc_hd__a21oi_1
XFILLER_25_833 VGND VGND VPWR VPWR sky130_fd_sc_hd__decap_6
XFILLER_37_671 VGND VGND VPWR VPWR sky130_fd_sc_hd__fill_1
X_09456_ _02696_ cpuregs\[19\]\[27\] _04863_ VGND VGND VPWR VPWR _01089_ sky130_fd_sc_hd__mux2_1
Xclkbuf_leaf_63_clk clknet_4_12_0_clk VGND VGND VPWR VPWR clknet_leaf_63_clk sky130_fd_sc_hd__clkbuf_8
XTAP_TAPCELL_ROW_80_1609 VGND VPWR sky130_fd_sc_hd__tapvpwrvgnd_1
X_06668_ cpuregs\[28\]\[13\] cpuregs\[29\]\[13\] cpuregs\[30\]\[13\] cpuregs\[31\]\[13\]
+ net265 net260 VGND VGND VPWR VPWR _03093_ sky130_fd_sc_hd__mux4_1
XFILLER_24_321 VGND VGND VPWR VPWR sky130_fd_sc_hd__fill_2
XFILLER_25_877 VPWR VGND VPWR VGND sky130_ef_sc_hd__decap_12
XFILLER_101_55 VGND VGND VPWR VPWR sky130_fd_sc_hd__fill_1
X_08407_ _04153_ net34 _04152_ VGND VGND VPWR VPWR _00761_ sky130_fd_sc_hd__and3b_1
X_05619_ _01562_ net209 _02157_ _02195_ _02201_ VGND VGND VPWR VPWR _02202_ sky130_fd_sc_hd__o221a_1
X_06599_ _03021_ _03022_ net258 VGND VGND VPWR VPWR _03027_ sky130_fd_sc_hd__mux2_1
XTAP_TAPCELL_ROW_35_894 VGND VPWR sky130_fd_sc_hd__tapvpwrvgnd_1
X_09387_ instr_jal decoded_imm_j\[3\] _04822_ mem_rdata_q\[10\] _04747_ VGND VGND
+ VPWR VPWR _04857_ sky130_fd_sc_hd__a221o_1
XFILLER_40_869 VPWR VGND VPWR VGND sky130_ef_sc_hd__decap_12
X_08338_ _04109_ _04110_ VGND VGND VPWR VPWR _00735_ sky130_fd_sc_hd__nor2_1
XFILLER_138_779 VPWR VGND VPWR VGND sky130_ef_sc_hd__decap_12
XFILLER_138_757 VGND VGND VPWR VPWR sky130_fd_sc_hd__decap_6
XFILLER_137_223 VGND VGND VPWR VPWR sky130_fd_sc_hd__fill_1
X_08269_ count_cycle\[4\] net403 _04065_ VGND VGND VPWR VPWR _00711_ sky130_fd_sc_hd__o21a_1
X_10300_ clknet_leaf_11_clk _00430_ VGND VGND VPWR VPWR cpuregs\[26\]\[10\] sky130_fd_sc_hd__dfxtp_1
X_11280_ clknet_leaf_0_clk _01327_ VGND VGND VPWR VPWR cpuregs\[4\]\[9\] sky130_fd_sc_hd__dfxtp_1
XFILLER_153_749 VGND VGND VPWR VPWR sky130_fd_sc_hd__decap_3
XTAP_TAPCELL_ROW_111_2108 VGND VPWR sky130_fd_sc_hd__tapvpwrvgnd_1
XFILLER_106_643 VGND VGND VPWR VPWR sky130_fd_sc_hd__fill_1
XTAP_TAPCELL_ROW_95_1852 VGND VPWR sky130_fd_sc_hd__tapvpwrvgnd_1
XFILLER_4_737 VPWR VGND VPWR VGND sky130_ef_sc_hd__decap_12
XFILLER_3_225 VPWR VGND VPWR VGND sky130_ef_sc_hd__decap_12
X_10231_ clknet_leaf_140_clk _00361_ VGND VGND VPWR VPWR cpuregs\[27\]\[5\] sky130_fd_sc_hd__dfxtp_1
XFILLER_133_462 VGND VGND VPWR VPWR sky130_fd_sc_hd__fill_2
XFILLER_10_41 VPWR VGND VPWR VGND sky130_ef_sc_hd__decap_12
XFILLER_126_41 VPWR VGND VPWR VGND sky130_ef_sc_hd__decap_12
XFILLER_121_635 VGND VGND VPWR VPWR sky130_fd_sc_hd__fill_1
XFILLER_10_85 VPWR VGND VPWR VGND sky130_ef_sc_hd__decap_12
X_10162_ clknet_leaf_125_clk _00292_ VGND VGND VPWR VPWR cpuregs\[9\]\[0\] sky130_fd_sc_hd__dfxtp_1
X_10093_ clknet_leaf_36_clk _00223_ VGND VGND VPWR VPWR cpuregs\[2\]\[27\] sky130_fd_sc_hd__dfxtp_1
XFILLER_86_23 VGND VGND VPWR VPWR sky130_fd_sc_hd__decap_4
XTAP_TAPCELL_ROW_126_2351 VGND VPWR sky130_fd_sc_hd__tapvpwrvgnd_1
XTAP_TAPCELL_ROW_126_2340 VGND VPWR sky130_fd_sc_hd__tapvpwrvgnd_1
XFILLER_74_232 VPWR VGND VPWR VGND sky130_ef_sc_hd__decap_12
XFILLER_47_457 VGND VGND VPWR VPWR sky130_fd_sc_hd__fill_2
XFILLER_62_427 VGND VGND VPWR VPWR sky130_fd_sc_hd__fill_1
XFILLER_16_811 VGND VGND VPWR VPWR sky130_fd_sc_hd__fill_1
X_10995_ clknet_leaf_38_clk _01057_ VGND VGND VPWR VPWR cpuregs\[18\]\[27\] sky130_fd_sc_hd__dfxtp_1
Xclkbuf_leaf_54_clk clknet_4_6_0_clk VGND VGND VPWR VPWR clknet_leaf_54_clk sky130_fd_sc_hd__clkbuf_8
XTAP_TAPCELL_ROW_104_1992 VGND VPWR sky130_fd_sc_hd__tapvpwrvgnd_1
XFILLER_70_493 VGND VGND VPWR VPWR sky130_fd_sc_hd__fill_1
XTAP_TAPCELL_ROW_13_533 VGND VPWR sky130_fd_sc_hd__tapvpwrvgnd_1
XTAP_TAPCELL_ROW_13_544 VGND VPWR sky130_fd_sc_hd__tapvpwrvgnd_1
XFILLER_51_81 VPWR VGND VPWR VGND sky130_ef_sc_hd__decap_12
XFILLER_116_429 VGND VGND VPWR VPWR sky130_fd_sc_hd__fill_2
X_11478_ clknet_leaf_9_clk _01522_ VGND VGND VPWR VPWR cpuregs\[10\]\[12\] sky130_fd_sc_hd__dfxtp_1
Xmax_cap239 _04867_ VGND VGND VPWR VPWR net239 sky130_fd_sc_hd__buf_12
X_10429_ clknet_leaf_147_clk _00559_ VGND VGND VPWR VPWR cpuregs\[17\]\[11\] sky130_fd_sc_hd__dfxtp_1
XFILLER_152_793 VPWR VGND VPWR VGND sky130_ef_sc_hd__decap_12
XFILLER_151_292 VPWR VGND VPWR VGND sky130_ef_sc_hd__decap_12
XFILLER_151_281 VGND VGND VPWR VPWR sky130_fd_sc_hd__fill_2
XFILLER_98_869 VPWR VGND VPWR VGND sky130_ef_sc_hd__decap_12
X_05970_ net200 _02488_ _01582_ VGND VGND VPWR VPWR net93 sky130_fd_sc_hd__mux2_1
XFILLER_112_679 VGND VGND VPWR VPWR sky130_fd_sc_hd__fill_2
XFILLER_66_711 VPWR VGND VPWR VGND sky130_ef_sc_hd__decap_12
XFILLER_25_3 VPWR VGND VPWR VGND sky130_ef_sc_hd__decap_12
X_04921_ cpu_state\[4\] VGND VGND VPWR VPWR _01554_ sky130_fd_sc_hd__inv_6
XFILLER_111_189 VGND VGND VPWR VPWR sky130_fd_sc_hd__decap_3
X_07640_ _02683_ cpuregs\[17\]\[24\] _03574_ VGND VGND VPWR VPWR _00572_ sky130_fd_sc_hd__mux2_1
XFILLER_93_574 VGND VGND VPWR VPWR sky130_fd_sc_hd__decap_4
XFILLER_81_703 VPWR VGND VPWR VGND sky130_ef_sc_hd__decap_12
XTAP_TAPCELL_ROW_49_1117 VGND VPWR sky130_fd_sc_hd__tapvpwrvgnd_1
X_07571_ cpuregs\[25\]\[22\] _02675_ _03571_ VGND VGND VPWR VPWR _00506_ sky130_fd_sc_hd__mux2_1
XFILLER_19_671 VGND VGND VPWR VPWR sky130_fd_sc_hd__fill_1
Xclkbuf_leaf_45_clk clknet_4_7_0_clk VGND VGND VPWR VPWR clknet_leaf_45_clk sky130_fd_sc_hd__clkbuf_8
X_06522_ _02950_ _02951_ VGND VGND VPWR VPWR _02952_ sky130_fd_sc_hd__nor2_1
XFILLER_53_449 VGND VGND VPWR VPWR sky130_fd_sc_hd__decap_3
X_09310_ _01543_ _01547_ _01549_ _01644_ VGND VGND VPWR VPWR _04815_ sky130_fd_sc_hd__a211o_2
XTAP_TAPCELL_ROW_62_1328 VGND VPWR sky130_fd_sc_hd__tapvpwrvgnd_1
XTAP_TAPCELL_ROW_62_1317 VGND VPWR sky130_fd_sc_hd__tapvpwrvgnd_1
XFILLER_22_825 VPWR VGND VPWR VGND sky130_ef_sc_hd__decap_12
X_09241_ cpuregs\[1\]\[20\] _02665_ _04799_ VGND VGND VPWR VPWR _00938_ sky130_fd_sc_hd__mux2_1
X_06453_ cpuregs\[8\]\[5\] cpuregs\[9\]\[5\] cpuregs\[10\]\[5\] cpuregs\[11\]\[5\]
+ net264 net262 VGND VGND VPWR VPWR _02886_ sky130_fd_sc_hd__mux4_1
XFILLER_22_869 VPWR VGND VPWR VGND sky130_ef_sc_hd__decap_12
XTAP_TAPCELL_ROW_32_842 VGND VPWR sky130_fd_sc_hd__tapvpwrvgnd_1
XFILLER_119_212 VPWR VGND VPWR VGND sky130_ef_sc_hd__decap_12
X_05404_ reg_pc\[27\] decoded_imm\[27\] VGND VGND VPWR VPWR _01992_ sky130_fd_sc_hd__nand2_1
X_09172_ _04778_ _04787_ instr_rdinstr _04747_ VGND VGND VPWR VPWR _00883_ sky130_fd_sc_hd__a2bb2o_1
X_06384_ net262 _02816_ net258 VGND VGND VPWR VPWR _02819_ sky130_fd_sc_hd__o21a_1
X_08123_ _03932_ _03935_ _03576_ VGND VGND VPWR VPWR _03936_ sky130_fd_sc_hd__a21oi_1
X_05335_ count_instr\[53\] instr_rdinstrh _01587_ _01928_ VGND VGND VPWR VPWR _01929_
+ sky130_fd_sc_hd__a211o_1
X_08054_ _03869_ _03871_ VGND VGND VPWR VPWR _03872_ sky130_fd_sc_hd__xnor2_1
X_07005_ _03412_ _03413_ _00014_ VGND VGND VPWR VPWR _03418_ sky130_fd_sc_hd__mux2_1
XFILLER_128_790 VPWR VGND VPWR VGND sky130_ef_sc_hd__decap_12
X_05266_ _01854_ _01855_ _01865_ VGND VGND VPWR VPWR _04884_ sky130_fd_sc_hd__o21ai_1
XFILLER_143_760 VGND VGND VPWR VPWR sky130_fd_sc_hd__decap_3
XFILLER_134_248 VGND VGND VPWR VPWR sky130_fd_sc_hd__decap_4
XFILLER_89_814 VGND VGND VPWR VPWR sky130_fd_sc_hd__decap_4
XTAP_TAPCELL_ROW_77_1571 VGND VPWR sky130_fd_sc_hd__tapvpwrvgnd_1
XTAP_TAPCELL_ROW_77_1560 VGND VPWR sky130_fd_sc_hd__tapvpwrvgnd_1
X_05197_ _01799_ _01800_ VGND VGND VPWR VPWR _01801_ sky130_fd_sc_hd__nand2_1
XFILLER_103_635 VGND VGND VPWR VPWR sky130_fd_sc_hd__fill_2
Xpicorv32_284 VGND VGND VPWR VPWR picorv32_284/HI eoi[3] sky130_fd_sc_hd__conb_1
XFILLER_1_729 VPWR VGND VPWR VGND sky130_ef_sc_hd__decap_12
Xpicorv32_295 VGND VGND VPWR VPWR picorv32_295/HI eoi[14] sky130_fd_sc_hd__conb_1
XFILLER_142_292 VPWR VGND VPWR VGND sky130_ef_sc_hd__decap_12
XTAP_TAPCELL_ROW_90_1771 VGND VPWR sky130_fd_sc_hd__tapvpwrvgnd_1
X_08956_ _01558_ _04631_ VGND VGND VPWR VPWR _04632_ sky130_fd_sc_hd__or2_1
XFILLER_103_679 VPWR VGND VPWR VGND sky130_ef_sc_hd__decap_12
X_08887_ cpuregs\[16\]\[22\] cpuregs\[17\]\[22\] cpuregs\[18\]\[22\] cpuregs\[19\]\[22\]
+ net280 net274 VGND VGND VPWR VPWR _04567_ sky130_fd_sc_hd__mux4_1
X_07907_ _03735_ _03736_ VGND VGND VPWR VPWR _03737_ sky130_fd_sc_hd__nor2_1
XFILLER_84_563 VGND VGND VPWR VPWR sky130_fd_sc_hd__fill_1
X_07838_ reg_pc\[7\] _01624_ _01628_ _03694_ VGND VGND VPWR VPWR _00651_ sky130_fd_sc_hd__a22o_1
XFILLER_72_747 VGND VGND VPWR VPWR sky130_fd_sc_hd__decap_8
XFILLER_56_298 VGND VGND VPWR VPWR sky130_fd_sc_hd__fill_1
Xclkbuf_leaf_36_clk clknet_4_5_0_clk VGND VGND VPWR VPWR clknet_leaf_36_clk sky130_fd_sc_hd__clkbuf_8
XFILLER_72_769 VGND VGND VPWR VPWR sky130_fd_sc_hd__decap_6
X_09508_ cpuregs\[31\]\[13\] _02638_ net240 VGND VGND VPWR VPWR _01171_ sky130_fd_sc_hd__mux2_1
X_07769_ count_instr\[43\] count_instr\[42\] _03649_ VGND VGND VPWR VPWR _03653_ sky130_fd_sc_hd__and3_1
XTAP_TAPCELL_ROW_121_2270 VGND VPWR sky130_fd_sc_hd__tapvpwrvgnd_1
XFILLER_80_780 VGND VGND VPWR VPWR sky130_fd_sc_hd__fill_1
X_10780_ clknet_leaf_102_clk _00845_ VGND VGND VPWR VPWR instr_auipc sky130_fd_sc_hd__dfxtp_1
XFILLER_24_162 VGND VGND VPWR VPWR sky130_fd_sc_hd__decap_6
X_09439_ _02624_ cpuregs\[19\]\[10\] _04863_ VGND VGND VPWR VPWR _01072_ sky130_fd_sc_hd__mux2_1
XFILLER_8_339 VGND VGND VPWR VPWR sky130_fd_sc_hd__fill_2
X_11401_ clknet_leaf_135_clk _01445_ VGND VGND VPWR VPWR cpuregs\[7\]\[31\] sky130_fd_sc_hd__dfxtp_1
XFILLER_138_598 VGND VGND VPWR VPWR sky130_fd_sc_hd__decap_6
XFILLER_125_215 VGND VGND VPWR VPWR sky130_fd_sc_hd__decap_8
X_11332_ clknet_leaf_32_clk _01379_ VGND VGND VPWR VPWR cpuregs\[5\]\[29\] sky130_fd_sc_hd__dfxtp_1
XFILLER_21_51 VGND VGND VPWR VPWR sky130_fd_sc_hd__decap_4
XFILLER_153_557 VGND VGND VPWR VPWR sky130_fd_sc_hd__decap_3
X_11263_ clknet_leaf_69_clk _01310_ VGND VGND VPWR VPWR cpuregs\[22\]\[24\] sky130_fd_sc_hd__dfxtp_1
XFILLER_137_51 VGND VGND VPWR VPWR sky130_fd_sc_hd__decap_4
XFILLER_97_11 VPWR VGND VPWR VGND sky130_ef_sc_hd__decap_12
XFILLER_4_545 VPWR VGND VPWR VGND sky130_ef_sc_hd__decap_12
XFILLER_140_218 VGND VGND VPWR VPWR sky130_fd_sc_hd__decap_6
XFILLER_134_793 VPWR VGND VPWR VGND sky130_ef_sc_hd__decap_12
X_10214_ clknet_leaf_72_clk _00344_ VGND VGND VPWR VPWR cpuregs\[14\]\[20\] sky130_fd_sc_hd__dfxtp_1
X_11194_ clknet_leaf_73_clk _01241_ VGND VGND VPWR VPWR cpuregs\[29\]\[19\] sky130_fd_sc_hd__dfxtp_1
XFILLER_106_484 VGND VGND VPWR VPWR sky130_fd_sc_hd__decap_4
XFILLER_97_55 VGND VGND VPWR VPWR sky130_fd_sc_hd__fill_1
X_10145_ clknet_leaf_20_clk _00275_ VGND VGND VPWR VPWR cpuregs\[21\]\[15\] sky130_fd_sc_hd__dfxtp_1
XFILLER_121_465 VGND VGND VPWR VPWR sky130_fd_sc_hd__fill_1
XFILLER_95_839 VGND VGND VPWR VPWR sky130_fd_sc_hd__fill_1
XFILLER_0_762 VGND VGND VPWR VPWR sky130_fd_sc_hd__decap_4
XFILLER_102_690 VGND VGND VPWR VPWR sky130_fd_sc_hd__fill_2
X_10076_ clknet_leaf_3_clk _00206_ VGND VGND VPWR VPWR cpuregs\[2\]\[10\] sky130_fd_sc_hd__dfxtp_1
XFILLER_90_533 VGND VGND VPWR VPWR sky130_fd_sc_hd__decap_4
XFILLER_48_799 VGND VGND VPWR VPWR sky130_fd_sc_hd__fill_1
XTAP_TAPCELL_ROW_18_614 VGND VPWR sky130_fd_sc_hd__tapvpwrvgnd_1
XTAP_TAPCELL_ROW_18_625 VGND VPWR sky130_fd_sc_hd__tapvpwrvgnd_1
XFILLER_90_555 VGND VGND VPWR VPWR sky130_fd_sc_hd__decap_8
Xclkbuf_leaf_27_clk clknet_4_4_0_clk VGND VGND VPWR VPWR clknet_leaf_27_clk sky130_fd_sc_hd__clkbuf_8
XFILLER_71_780 VGND VGND VPWR VPWR sky130_fd_sc_hd__decap_4
XFILLER_50_419 VGND VGND VPWR VPWR sky130_fd_sc_hd__fill_1
X_10978_ clknet_leaf_2_clk _01040_ VGND VGND VPWR VPWR cpuregs\[18\]\[10\] sky130_fd_sc_hd__dfxtp_1
XFILLER_15_162 VGND VGND VPWR VPWR sky130_fd_sc_hd__decap_6
XFILLER_31_611 VGND VGND VPWR VPWR sky130_fd_sc_hd__decap_4
XFILLER_31_633 VGND VGND VPWR VPWR sky130_fd_sc_hd__decap_4
XTAP_TAPCELL_ROW_44_1036 VGND VPWR sky130_fd_sc_hd__tapvpwrvgnd_1
XTAP_TAPCELL_ROW_139_2553 VGND VPWR sky130_fd_sc_hd__tapvpwrvgnd_1
XFILLER_31_666 VGND VGND VPWR VPWR sky130_fd_sc_hd__decap_6
XFILLER_30_165 VGND VGND VPWR VPWR sky130_fd_sc_hd__decap_8
XFILLER_117_727 VGND VGND VPWR VPWR sky130_fd_sc_hd__fill_1
X_05120_ net171 mem_wordsize\[1\] _01729_ VGND VGND VPWR VPWR _01730_ sky130_fd_sc_hd__and3_1
XTAP_TAPCELL_ROW_152_2764 VGND VPWR sky130_fd_sc_hd__tapvpwrvgnd_1
XFILLER_7_361 VGND VGND VPWR VPWR sky130_fd_sc_hd__fill_1
XFILLER_125_760 VPWR VGND VPWR VGND sky130_ef_sc_hd__decap_12
X_05051_ net608 mem_wordsize\[2\] VGND VGND VPWR VPWR _01667_ sky130_fd_sc_hd__nand2_4
XFILLER_98_633 VGND VGND VPWR VPWR sky130_fd_sc_hd__decap_8
X_08810_ cpuregs\[28\]\[18\] cpuregs\[29\]\[18\] cpuregs\[30\]\[18\] cpuregs\[31\]\[18\]
+ net276 net272 VGND VGND VPWR VPWR _04494_ sky130_fd_sc_hd__mux4_1
XFILLER_112_421 VGND VGND VPWR VPWR sky130_fd_sc_hd__decap_4
XFILLER_112_454 VPWR VGND VPWR VGND sky130_ef_sc_hd__decap_12
XFILLER_98_699 VGND VGND VPWR VPWR sky130_fd_sc_hd__fill_1
X_09790_ _02709_ cpuregs\[7\]\[30\] _04874_ VGND VGND VPWR VPWR _01444_ sky130_fd_sc_hd__mux2_1
X_05953_ net222 _01665_ _02477_ VGND VGND VPWR VPWR net116 sky130_fd_sc_hd__a21o_1
XFILLER_100_638 VGND VGND VPWR VPWR sky130_fd_sc_hd__fill_1
X_08741_ cpuregs\[12\]\[14\] cpuregs\[13\]\[14\] cpuregs\[14\]\[14\] cpuregs\[15\]\[14\]
+ net275 net271 VGND VGND VPWR VPWR _04429_ sky130_fd_sc_hd__mux4_1
XTAP_TAPCELL_ROW_72_1490 VGND VPWR sky130_fd_sc_hd__tapvpwrvgnd_1
X_05884_ _02055_ _02433_ _02054_ VGND VGND VPWR VPWR _02440_ sky130_fd_sc_hd__o21a_1
X_08672_ _04358_ _04359_ _01558_ VGND VGND VPWR VPWR _04364_ sky130_fd_sc_hd__mux2_1
XFILLER_93_371 VGND VGND VPWR VPWR sky130_fd_sc_hd__fill_1
XFILLER_81_522 VGND VGND VPWR VPWR sky130_fd_sc_hd__fill_2
XFILLER_53_213 VGND VGND VPWR VPWR sky130_fd_sc_hd__decap_8
X_07623_ _02612_ cpuregs\[17\]\[7\] _03574_ VGND VGND VPWR VPWR _00555_ sky130_fd_sc_hd__mux2_1
XFILLER_26_29 VPWR VGND VPWR VGND sky130_ef_sc_hd__decap_12
XTAP_TAPCELL_ROW_37_923 VGND VPWR sky130_fd_sc_hd__tapvpwrvgnd_1
Xclkbuf_leaf_18_clk clknet_4_3_0_clk VGND VGND VPWR VPWR clknet_leaf_18_clk sky130_fd_sc_hd__clkbuf_8
XPHY_EDGE_ROW_5_Right_5 VGND VGND VPWR VPWR sky130_fd_sc_hd__decap_3
XFILLER_81_588 VGND VGND VPWR VPWR sky130_fd_sc_hd__fill_1
X_07554_ cpuregs\[25\]\[5\] _02603_ _03571_ VGND VGND VPWR VPWR _00489_ sky130_fd_sc_hd__mux2_1
XFILLER_41_419 VGND VGND VPWR VPWR sky130_fd_sc_hd__fill_2
X_07485_ cpuregs\[26\]\[3\] _02593_ _03568_ VGND VGND VPWR VPWR _00423_ sky130_fd_sc_hd__mux2_1
X_06505_ cpuregs\[24\]\[7\] cpuregs\[25\]\[7\] cpuregs\[26\]\[7\] cpuregs\[27\]\[7\]
+ net268 net262 VGND VGND VPWR VPWR _02936_ sky130_fd_sc_hd__mux4_1
XFILLER_139_329 VGND VGND VPWR VPWR sky130_fd_sc_hd__decap_6
X_09224_ cpuregs\[1\]\[3\] _02593_ net244 VGND VGND VPWR VPWR _00921_ sky130_fd_sc_hd__mux2_1
X_06436_ net198 _02720_ _02869_ _01641_ VGND VGND VPWR VPWR _02870_ sky130_fd_sc_hd__o211a_1
XTAP_TAPCELL_ROW_79_1600 VGND VPWR sky130_fd_sc_hd__tapvpwrvgnd_1
XFILLER_22_688 VGND VGND VPWR VPWR sky130_fd_sc_hd__decap_3
X_09155_ instr_and _04748_ _04757_ _04772_ VGND VGND VPWR VPWR _00879_ sky130_fd_sc_hd__a22o_1
X_06367_ net193 _02724_ _02792_ _02802_ VGND VGND VPWR VPWR _00071_ sky130_fd_sc_hd__o22a_1
X_05318_ _01909_ _01912_ VGND VGND VPWR VPWR _01913_ sky130_fd_sc_hd__nand2_1
X_08106_ decoded_imm_j\[17\] _03704_ _03705_ decoded_imm_j\[18\] VGND VGND VPWR VPWR
+ _03920_ sky130_fd_sc_hd__a22o_1
X_09086_ _04739_ _04741_ _04742_ _02514_ instr_auipc VGND VGND VPWR VPWR _00845_ sky130_fd_sc_hd__a32o_1
X_06298_ cpuregs\[16\]\[0\] cpuregs\[17\]\[0\] cpuregs\[18\]\[0\] cpuregs\[19\]\[0\]
+ net264 net262 VGND VGND VPWR VPWR _02736_ sky130_fd_sc_hd__mux4_1
XTAP_TAPCELL_ROW_92_1811 VGND VPWR sky130_fd_sc_hd__tapvpwrvgnd_1
XTAP_TAPCELL_ROW_92_1800 VGND VPWR sky130_fd_sc_hd__tapvpwrvgnd_1
X_05249_ count_cycle\[14\] _01588_ net256 _01849_ VGND VGND VPWR VPWR _01850_ sky130_fd_sc_hd__o211a_1
X_08037_ decoded_imm_j\[14\] _03701_ VGND VGND VPWR VPWR _03856_ sky130_fd_sc_hd__nand2_1
XFILLER_122_218 VGND VGND VPWR VPWR sky130_fd_sc_hd__fill_1
XFILLER_115_281 VGND VGND VPWR VPWR sky130_fd_sc_hd__decap_6
XFILLER_89_666 VGND VGND VPWR VPWR sky130_fd_sc_hd__decap_6
XFILLER_1_559 VGND VGND VPWR VPWR sky130_fd_sc_hd__fill_1
XFILLER_131_785 VPWR VGND VPWR VGND sky130_ef_sc_hd__decap_12
X_09988_ clknet_leaf_54_clk _00118_ VGND VGND VPWR VPWR cpuregs\[12\]\[18\] sky130_fd_sc_hd__dfxtp_1
XFILLER_88_154 VGND VGND VPWR VPWR sky130_fd_sc_hd__fill_2
XFILLER_49_508 VGND VGND VPWR VPWR sky130_fd_sc_hd__decap_6
X_08939_ cpuregs\[0\]\[25\] cpuregs\[1\]\[25\] cpuregs\[2\]\[25\] cpuregs\[3\]\[25\]
+ net280 net274 VGND VGND VPWR VPWR _04616_ sky130_fd_sc_hd__mux4_1
XPHY_EDGE_ROW_150_Right_150 VGND VGND VPWR VPWR sky130_fd_sc_hd__decap_3
XTAP_TAPCELL_ROW_106_2029 VGND VPWR sky130_fd_sc_hd__tapvpwrvgnd_1
XFILLER_85_872 VGND VGND VPWR VPWR sky130_fd_sc_hd__fill_1
XFILLER_91_319 VPWR VGND VPWR VGND sky130_ef_sc_hd__decap_12
XFILLER_57_574 VGND VGND VPWR VPWR sky130_fd_sc_hd__fill_1
XTAP_TAPCELL_ROW_4_397 VGND VPWR sky130_fd_sc_hd__tapvpwrvgnd_1
X_10901_ clknet_leaf_4_clk _00963_ VGND VGND VPWR VPWR net164 sky130_fd_sc_hd__dfxtp_1
XFILLER_44_213 VGND VGND VPWR VPWR sky130_fd_sc_hd__decap_6
XFILLER_83_57 VGND VGND VPWR VPWR sky130_fd_sc_hd__decap_6
XFILLER_17_449 VPWR VGND VPWR VGND sky130_ef_sc_hd__decap_12
XFILLER_44_235 VPWR VGND VPWR VGND sky130_ef_sc_hd__decap_12
X_10832_ clknet_leaf_93_clk _00897_ VGND VGND VPWR VPWR decoded_imm_j\[20\] sky130_fd_sc_hd__dfxtp_4
XFILLER_83_79 VGND VGND VPWR VPWR sky130_fd_sc_hd__fill_1
X_10763_ clknet_leaf_92_clk alu_out\[16\] VGND VGND VPWR VPWR alu_out_q\[16\] sky130_fd_sc_hd__dfxtp_1
XTAP_TAPCELL_ROW_101_1951 VGND VPWR sky130_fd_sc_hd__tapvpwrvgnd_1
XTAP_TAPCELL_ROW_101_1940 VGND VPWR sky130_fd_sc_hd__tapvpwrvgnd_1
X_10694_ clknet_leaf_71_clk _00792_ VGND VGND VPWR VPWR net47 sky130_fd_sc_hd__dfxtp_1
XFILLER_139_841 VPWR VGND VPWR VGND sky130_ef_sc_hd__decap_12
XFILLER_13_699 VGND VGND VPWR VPWR sky130_fd_sc_hd__decap_8
XFILLER_40_496 VPWR VGND VPWR VGND sky130_ef_sc_hd__decap_12
XTAP_TAPCELL_ROW_23_694 VGND VPWR sky130_fd_sc_hd__tapvpwrvgnd_1
XFILLER_32_83 VGND VGND VPWR VPWR sky130_fd_sc_hd__fill_1
XFILLER_148_83 VGND VGND VPWR VPWR sky130_fd_sc_hd__fill_1
XFILLER_5_821 VPWR VGND VPWR VGND sky130_ef_sc_hd__decap_12
XFILLER_153_343 VGND VGND VPWR VPWR sky130_fd_sc_hd__decap_3
XFILLER_141_505 VPWR VGND VPWR VGND sky130_ef_sc_hd__decap_12
XTAP_TAPCELL_ROW_134_2483 VGND VPWR sky130_fd_sc_hd__tapvpwrvgnd_1
XTAP_TAPCELL_ROW_134_2472 VGND VPWR sky130_fd_sc_hd__tapvpwrvgnd_1
X_11315_ clknet_leaf_5_clk _01362_ VGND VGND VPWR VPWR cpuregs\[5\]\[12\] sky130_fd_sc_hd__dfxtp_1
XFILLER_5_865 VPWR VGND VPWR VGND sky130_ef_sc_hd__decap_12
XFILLER_153_365 VGND VGND VPWR VPWR sky130_fd_sc_hd__fill_2
XFILLER_141_538 VGND VGND VPWR VPWR sky130_fd_sc_hd__decap_6
XFILLER_113_207 VGND VGND VPWR VPWR sky130_fd_sc_hd__fill_1
XFILLER_122_752 VGND VGND VPWR VPWR sky130_fd_sc_hd__decap_4
X_11246_ clknet_leaf_143_clk _01293_ VGND VGND VPWR VPWR cpuregs\[22\]\[7\] sky130_fd_sc_hd__dfxtp_1
XFILLER_95_614 VGND VGND VPWR VPWR sky130_fd_sc_hd__fill_2
XFILLER_67_305 VPWR VGND VPWR VGND sky130_ef_sc_hd__decap_12
X_11177_ clknet_leaf_120_clk _01224_ VGND VGND VPWR VPWR cpuregs\[29\]\[2\] sky130_fd_sc_hd__dfxtp_1
X_10128_ clknet_leaf_23_clk _00258_ VGND VGND VPWR VPWR cpuregs\[28\]\[30\] sky130_fd_sc_hd__dfxtp_1
XFILLER_67_327 VGND VGND VPWR VPWR sky130_fd_sc_hd__decap_8
X_10059_ clknet_leaf_48_clk _00189_ VGND VGND VPWR VPWR cpuregs\[13\]\[25\] sky130_fd_sc_hd__dfxtp_1
XFILLER_91_831 VGND VGND VPWR VPWR sky130_fd_sc_hd__decap_8
XFILLER_63_500 VGND VGND VPWR VPWR sky130_fd_sc_hd__decap_4
XFILLER_75_393 VGND VGND VPWR VPWR sky130_fd_sc_hd__fill_2
XFILLER_63_533 VGND VGND VPWR VPWR sky130_fd_sc_hd__decap_6
XFILLER_91_897 VGND VGND VPWR VPWR sky130_fd_sc_hd__decap_6
XFILLER_90_363 VGND VGND VPWR VPWR sky130_fd_sc_hd__fill_1
XFILLER_63_588 VGND VGND VPWR VPWR sky130_fd_sc_hd__fill_2
XFILLER_35_279 VGND VGND VPWR VPWR sky130_fd_sc_hd__fill_1
XFILLER_50_249 VGND VGND VPWR VPWR sky130_fd_sc_hd__decap_3
X_07270_ cpuregs\[2\]\[21\] _02670_ _03559_ VGND VGND VPWR VPWR _00217_ sky130_fd_sc_hd__mux2_1
X_06221_ _02666_ _02669_ _02584_ VGND VGND VPWR VPWR _02670_ sky130_fd_sc_hd__mux2_8
XFILLER_145_833 VGND VGND VPWR VPWR sky130_fd_sc_hd__decap_6
XFILLER_144_321 VGND VGND VPWR VPWR sky130_fd_sc_hd__fill_1
X_06152_ reg_pc\[8\] _02610_ VGND VGND VPWR VPWR _02614_ sky130_fd_sc_hd__and2_1
XFILLER_145_877 VPWR VGND VPWR VGND sky130_ef_sc_hd__decap_12
XFILLER_144_343 VGND VGND VPWR VPWR sky130_fd_sc_hd__decap_4
X_06083_ _00010_ _02554_ _01560_ VGND VGND VPWR VPWR _02555_ sky130_fd_sc_hd__a21oi_1
X_05103_ cpu_state\[3\] _01707_ _01714_ VGND VGND VPWR VPWR _04903_ sky130_fd_sc_hd__a21o_1
Xclkbuf_leaf_7_clk clknet_4_1_0_clk VGND VGND VPWR VPWR clknet_leaf_7_clk sky130_fd_sc_hd__clkbuf_8
XTAP_TAPCELL_ROW_57_1249 VGND VPWR sky130_fd_sc_hd__tapvpwrvgnd_1
XTAP_TAPCELL_ROW_57_1238 VGND VPWR sky130_fd_sc_hd__tapvpwrvgnd_1
X_05034_ instr_rdcycle is_slli_srli_srai _01588_ _01603_ VGND VGND VPWR VPWR _01655_
+ sky130_fd_sc_hd__or4_1
X_09911_ clknet_leaf_0_clk _00046_ VGND VGND VPWR VPWR cpuregs\[11\]\[9\] sky130_fd_sc_hd__dfxtp_1
X_09842_ _02649_ cpuregs\[10\]\[16\] _04876_ VGND VGND VPWR VPWR _01526_ sky130_fd_sc_hd__mux2_1
XFILLER_59_806 VGND VGND VPWR VPWR sky130_fd_sc_hd__decap_8
X_09773_ _02638_ cpuregs\[7\]\[13\] _04874_ VGND VGND VPWR VPWR _01427_ sky130_fd_sc_hd__mux2_1
XTAP_TAPCELL_ROW_70_1449 VGND VPWR sky130_fd_sc_hd__tapvpwrvgnd_1
X_06985_ decoded_imm\[25\] net188 VGND VGND VPWR VPWR _03398_ sky130_fd_sc_hd__nand2_1
X_08724_ net270 _04412_ VGND VGND VPWR VPWR _04413_ sky130_fd_sc_hd__or2_1
XFILLER_37_39 VPWR VGND VPWR VGND sky130_ef_sc_hd__decap_12
XFILLER_39_541 VGND VGND VPWR VPWR sky130_fd_sc_hd__decap_4
X_05936_ mem_wordsize\[1\] net124 net207 mem_wordsize\[2\] VGND VGND VPWR VPWR _02479_
+ sky130_fd_sc_hd__a22o_1
XFILLER_67_894 VGND VGND VPWR VPWR sky130_fd_sc_hd__fill_2
XFILLER_39_585 VPWR VGND VPWR VGND sky130_ef_sc_hd__decap_12
X_05867_ _02061_ _02413_ VGND VGND VPWR VPWR _02425_ sky130_fd_sc_hd__nand2_1
XFILLER_66_393 VGND VGND VPWR VPWR sky130_fd_sc_hd__decap_8
XFILLER_66_382 VGND VGND VPWR VPWR sky130_fd_sc_hd__fill_1
XFILLER_54_555 VPWR VGND VPWR VGND sky130_ef_sc_hd__decap_12
XTAP_TAPCELL_ROW_1_345 VGND VPWR sky130_fd_sc_hd__tapvpwrvgnd_1
X_08655_ _04338_ _04339_ _01558_ VGND VGND VPWR VPWR _04348_ sky130_fd_sc_hd__mux2_1
X_07606_ cpuregs\[20\]\[23\] _02678_ net245 VGND VGND VPWR VPWR _00539_ sky130_fd_sc_hd__mux2_1
XFILLER_82_897 VGND VGND VPWR VPWR sky130_fd_sc_hd__decap_3
X_08586_ _01558_ _04281_ VGND VGND VPWR VPWR _04282_ sky130_fd_sc_hd__or2_1
X_07537_ _02670_ cpuregs\[16\]\[21\] _03570_ VGND VGND VPWR VPWR _00473_ sky130_fd_sc_hd__mux2_1
X_05798_ _02109_ _02111_ _02108_ VGND VGND VPWR VPWR _02363_ sky130_fd_sc_hd__o21a_1
XTAP_TAPCELL_ROW_85_1692 VGND VPWR sky130_fd_sc_hd__tapvpwrvgnd_1
XFILLER_53_49 VGND VGND VPWR VPWR sky130_fd_sc_hd__decap_6
XFILLER_35_780 VGND VGND VPWR VPWR sky130_fd_sc_hd__decap_4
XFILLER_41_238 VGND VGND VPWR VPWR sky130_fd_sc_hd__fill_1
XFILLER_50_761 VGND VGND VPWR VPWR sky130_fd_sc_hd__fill_1
XFILLER_22_452 VPWR VGND VPWR VGND sky130_ef_sc_hd__decap_12
XFILLER_139_137 VGND VGND VPWR VPWR sky130_fd_sc_hd__decap_4
X_07468_ cpuregs\[15\]\[19\] _02662_ net246 VGND VGND VPWR VPWR _00407_ sky130_fd_sc_hd__mux2_1
XFILLER_108_502 VPWR VGND VPWR VGND sky130_ef_sc_hd__decap_12
X_07399_ cpuregs\[14\]\[17\] _02654_ net247 VGND VGND VPWR VPWR _00341_ sky130_fd_sc_hd__mux2_1
Xrebuffer200 _03659_ VGND VGND VPWR VPWR net586 sky130_fd_sc_hd__dlygate4sd1_1
X_06419_ _01578_ _02850_ _02852_ _01579_ VGND VGND VPWR VPWR _02853_ sky130_fd_sc_hd__o211a_1
Xrebuffer222 net182 VGND VGND VPWR VPWR net608 sky130_fd_sc_hd__buf_2
X_09207_ decoded_imm\[0\] _04746_ _04792_ VGND VGND VPWR VPWR _00911_ sky130_fd_sc_hd__o21a_1
X_09138_ _04747_ _04768_ VGND VGND VPWR VPWR _04769_ sky130_fd_sc_hd__nor2_1
XTAP_TAPCELL_ROW_20_653 VGND VPWR sky130_fd_sc_hd__tapvpwrvgnd_1
XFILLER_147_181 VPWR VGND VPWR VGND sky130_ef_sc_hd__decap_12
XTAP_TAPCELL_ROW_116_2180 VGND VPWR sky130_fd_sc_hd__tapvpwrvgnd_1
XFILLER_118_53 VGND VGND VPWR VPWR sky130_fd_sc_hd__decap_3
XTAP_TAPCELL_ROW_116_2191 VGND VPWR sky130_fd_sc_hd__tapvpwrvgnd_1
X_11100_ clknet_leaf_17_clk _01157_ VGND VGND VPWR VPWR cpuregs\[24\]\[31\] sky130_fd_sc_hd__dfxtp_1
XFILLER_2_813 VPWR VGND VPWR VGND sky130_ef_sc_hd__decap_12
X_09069_ cpu_state\[3\] net602 net388 net34 _04736_ VGND VGND VPWR VPWR _00840_ sky130_fd_sc_hd__o311a_1
X_11031_ clknet_leaf_14_clk _01093_ VGND VGND VPWR VPWR cpuregs\[19\]\[31\] sky130_fd_sc_hd__dfxtp_1
XTAP_TAPCELL_ROW_9_478 VGND VPWR sky130_fd_sc_hd__tapvpwrvgnd_1
XFILLER_134_41 VPWR VGND VPWR VGND sky130_ef_sc_hd__decap_12
XFILLER_89_496 VGND VGND VPWR VPWR sky130_fd_sc_hd__fill_1
XFILLER_91_105 VGND VGND VPWR VPWR sky130_fd_sc_hd__decap_6
XFILLER_73_831 VGND VGND VPWR VPWR sky130_fd_sc_hd__decap_3
XFILLER_18_769 VPWR VGND VPWR VGND sky130_ef_sc_hd__decap_12
XFILLER_73_897 VGND VGND VPWR VPWR sky130_fd_sc_hd__decap_3
XFILLER_60_503 VGND VGND VPWR VPWR sky130_fd_sc_hd__fill_2
XTAP_TAPCELL_ROW_28_775 VGND VPWR sky130_fd_sc_hd__tapvpwrvgnd_1
X_10815_ clknet_leaf_99_clk _00880_ VGND VGND VPWR VPWR instr_srai sky130_fd_sc_hd__dfxtp_1
XFILLER_60_525 VGND VGND VPWR VPWR sky130_fd_sc_hd__fill_1
XFILLER_26_780 VPWR VGND VPWR VGND sky130_ef_sc_hd__decap_12
XTAP_TAPCELL_ROW_28_786 VGND VPWR sky130_fd_sc_hd__tapvpwrvgnd_1
XFILLER_60_569 VGND VGND VPWR VPWR sky130_fd_sc_hd__decap_3
XFILLER_32_249 VGND VGND VPWR VPWR sky130_fd_sc_hd__decap_3
XTAP_TAPCELL_ROW_136_2512 VGND VPWR sky130_fd_sc_hd__tapvpwrvgnd_1
XTAP_TAPCELL_ROW_136_2501 VGND VPWR sky130_fd_sc_hd__tapvpwrvgnd_1
X_10746_ clknet_leaf_103_clk _00843_ VGND VGND VPWR VPWR latched_is_lb sky130_fd_sc_hd__dfxtp_1
XFILLER_40_271 VGND VGND VPWR VPWR sky130_fd_sc_hd__fill_1
XFILLER_41_783 VGND VGND VPWR VPWR sky130_fd_sc_hd__fill_1
X_10677_ clknet_leaf_141_clk _00775_ VGND VGND VPWR VPWR net60 sky130_fd_sc_hd__dfxtp_1
XFILLER_139_671 VGND VGND VPWR VPWR sky130_fd_sc_hd__fill_1
XFILLER_127_833 VGND VGND VPWR VPWR sky130_fd_sc_hd__decap_6
XFILLER_9_489 VGND VGND VPWR VPWR sky130_fd_sc_hd__fill_2
XFILLER_127_877 VPWR VGND VPWR VGND sky130_ef_sc_hd__decap_12
XFILLER_126_343 VGND VGND VPWR VPWR sky130_fd_sc_hd__decap_4
Xoutput208 net208 VGND VGND VPWR VPWR pcpi_rs2[14] sky130_fd_sc_hd__buf_2
Xoutput219 net219 VGND VGND VPWR VPWR pcpi_rs2[24] sky130_fd_sc_hd__buf_2
XFILLER_142_825 VPWR VGND VPWR VGND sky130_ef_sc_hd__decap_12
XFILLER_114_505 VPWR VGND VPWR VGND sky130_ef_sc_hd__decap_12
XFILLER_5_673 VPWR VGND VPWR VGND sky130_ef_sc_hd__decap_12
XFILLER_142_869 VPWR VGND VPWR VGND sky130_ef_sc_hd__decap_12
XFILLER_141_335 VGND VGND VPWR VPWR sky130_fd_sc_hd__fill_1
X_11229_ clknet_leaf_46_clk _01276_ VGND VGND VPWR VPWR cpuregs\[3\]\[22\] sky130_fd_sc_hd__dfxtp_1
XFILLER_122_560 VGND VGND VPWR VPWR sky130_fd_sc_hd__decap_4
XFILLER_96_901 VGND VGND VPWR VPWR sky130_fd_sc_hd__decap_3
XFILLER_4_65 VPWR VGND VPWR VGND sky130_ef_sc_hd__decap_12
XFILLER_110_711 VGND VGND VPWR VPWR sky130_fd_sc_hd__decap_4
XFILLER_67_113 VPWR VGND VPWR VGND sky130_ef_sc_hd__decap_12
XTAP_TAPCELL_ROW_52_1157 VGND VPWR sky130_fd_sc_hd__tapvpwrvgnd_1
XFILLER_95_444 VGND VGND VPWR VPWR sky130_fd_sc_hd__decap_4
XTAP_TAPCELL_ROW_52_1168 VGND VPWR sky130_fd_sc_hd__tapvpwrvgnd_1
XTAP_TAPCELL_ROW_147_2685 VGND VPWR sky130_fd_sc_hd__tapvpwrvgnd_1
X_06770_ _03166_ _03189_ _03190_ _01621_ VGND VGND VPWR VPWR _03191_ sky130_fd_sc_hd__a211o_1
XFILLER_83_617 VPWR VGND VPWR VGND sky130_ef_sc_hd__decap_12
XFILLER_48_371 VGND VGND VPWR VPWR sky130_fd_sc_hd__fill_1
X_05721_ _02133_ _02286_ _02131_ VGND VGND VPWR VPWR _02295_ sky130_fd_sc_hd__a21o_1
XFILLER_91_650 VGND VGND VPWR VPWR sky130_fd_sc_hd__decap_8
X_05652_ is_slti_blt_slt _02231_ _02233_ _02234_ VGND VGND VPWR VPWR _02235_ sky130_fd_sc_hd__a211o_1
X_08440_ cpuregs\[8\]\[31\] cpuregs\[9\]\[31\] net264 VGND VGND VPWR VPWR _04177_
+ sky130_fd_sc_hd__mux2_1
XFILLER_63_374 VPWR VGND VPWR VGND sky130_ef_sc_hd__decap_12
X_08371_ count_cycle\[41\] _04129_ _01549_ VGND VGND VPWR VPWR _04131_ sky130_fd_sc_hd__a21oi_1
X_05583_ net193 net119 VGND VGND VPWR VPWR _02166_ sky130_fd_sc_hd__nor2_1
XFILLER_16_290 VGND VGND VPWR VPWR sky130_fd_sc_hd__fill_2
X_07322_ cpuregs\[21\]\[6\] _02607_ net248 VGND VGND VPWR VPWR _00266_ sky130_fd_sc_hd__mux2_1
X_07253_ cpuregs\[2\]\[4\] _02598_ net250 VGND VGND VPWR VPWR _00200_ sky130_fd_sc_hd__mux2_1
XFILLER_118_833 VPWR VGND VPWR VGND sky130_ef_sc_hd__decap_12
X_06204_ reg_pc\[18\] _02652_ VGND VGND VPWR VPWR _02656_ sky130_fd_sc_hd__xor2_1
X_07184_ cpuregs\[30\]\[2\] _02590_ net252 VGND VGND VPWR VPWR _00134_ sky130_fd_sc_hd__mux2_1
X_06135_ reg_pc\[5\] _02595_ VGND VGND VPWR VPWR _02600_ sky130_fd_sc_hd__nor2_1
XFILLER_132_313 VGND VGND VPWR VPWR sky130_fd_sc_hd__fill_1
XFILLER_117_387 VGND VGND VPWR VPWR sky130_fd_sc_hd__decap_4
XFILLER_105_505 VPWR VGND VPWR VGND sky130_ef_sc_hd__decap_12
XFILLER_2_109 VPWR VGND VPWR VGND sky130_ef_sc_hd__decap_12
XFILLER_144_195 VGND VGND VPWR VPWR sky130_fd_sc_hd__fill_1
X_06066_ reg_sh\[3\] reg_sh\[2\] VGND VGND VPWR VPWR _02538_ sky130_fd_sc_hd__nand2_1
XFILLER_132_357 VGND VGND VPWR VPWR sky130_fd_sc_hd__decap_6
XFILLER_101_700 VPWR VGND VPWR VGND sky130_ef_sc_hd__decap_12
XFILLER_59_603 VPWR VGND VPWR VGND sky130_ef_sc_hd__decap_12
XTAP_TAPCELL_ROW_6_426 VGND VPWR sky130_fd_sc_hd__tapvpwrvgnd_1
X_05017_ reg_sh\[4\] _01638_ VGND VGND VPWR VPWR _01640_ sky130_fd_sc_hd__or2_4
XFILLER_59_636 VGND VGND VPWR VPWR sky130_fd_sc_hd__decap_8
XFILLER_48_27 VGND VGND VPWR VPWR sky130_fd_sc_hd__fill_1
X_09825_ _02579_ _03554_ VGND VGND VPWR VPWR _04876_ sky130_fd_sc_hd__or2_4
XFILLER_58_157 VGND VGND VPWR VPWR sky130_fd_sc_hd__decap_6
X_06968_ cpuregs\[16\]\[24\] cpuregs\[17\]\[24\] cpuregs\[18\]\[24\] cpuregs\[19\]\[24\]
+ net267 net261 VGND VGND VPWR VPWR _03382_ sky130_fd_sc_hd__mux4_1
X_09756_ _02704_ cpuregs\[6\]\[29\] _04873_ VGND VGND VPWR VPWR _01411_ sky130_fd_sc_hd__mux2_1
XTAP_TAPCELL_ROW_87_1721 VGND VPWR sky130_fd_sc_hd__tapvpwrvgnd_1
XFILLER_86_477 VGND VGND VPWR VPWR sky130_fd_sc_hd__decap_8
XFILLER_58_179 VGND VGND VPWR VPWR sky130_fd_sc_hd__fill_1
XFILLER_39_371 VGND VGND VPWR VPWR sky130_fd_sc_hd__fill_2
X_09687_ cpuregs\[4\]\[26\] _02691_ net238 VGND VGND VPWR VPWR _01344_ sky130_fd_sc_hd__mux2_1
X_05919_ _02242_ _02470_ VGND VGND VPWR VPWR _02471_ sky130_fd_sc_hd__nor2_1
X_08707_ _04391_ _04392_ _01558_ VGND VGND VPWR VPWR _04397_ sky130_fd_sc_hd__mux2_1
XFILLER_39_382 VGND VGND VPWR VPWR sky130_fd_sc_hd__fill_1
X_06899_ _01580_ _03315_ _02735_ VGND VGND VPWR VPWR _03316_ sky130_fd_sc_hd__o21a_1
XFILLER_54_363 VGND VGND VPWR VPWR sky130_fd_sc_hd__fill_1
XFILLER_27_577 VGND VGND VPWR VPWR sky130_fd_sc_hd__decap_6
X_08638_ net269 _04330_ _01559_ VGND VGND VPWR VPWR _04332_ sky130_fd_sc_hd__a21o_1
XFILLER_70_856 VPWR VGND VPWR VGND sky130_ef_sc_hd__decap_12
XFILLER_55_897 VGND VGND VPWR VPWR sky130_fd_sc_hd__decap_8
XTAP_TAPCELL_ROW_25_734 VGND VPWR sky130_fd_sc_hd__tapvpwrvgnd_1
X_08569_ _01654_ _02526_ VGND VGND VPWR VPWR _04266_ sky130_fd_sc_hd__nor2_8
X_10600_ clknet_leaf_90_clk _00730_ VGND VGND VPWR VPWR count_cycle\[23\] sky130_fd_sc_hd__dfxtp_1
XTAP_TAPCELL_ROW_118_2220 VGND VPWR sky130_fd_sc_hd__tapvpwrvgnd_1
X_10531_ clknet_leaf_89_clk _00661_ VGND VGND VPWR VPWR reg_pc\[17\] sky130_fd_sc_hd__dfxtp_2
XFILLER_7_905 VGND VGND VPWR VPWR sky130_fd_sc_hd__decap_3
XFILLER_109_833 VGND VGND VPWR VPWR sky130_fd_sc_hd__fill_1
XFILLER_10_477 VPWR VGND VPWR VGND sky130_ef_sc_hd__decap_12
XFILLER_10_455 VGND VGND VPWR VPWR sky130_fd_sc_hd__decap_6
XFILLER_109_866 VGND VGND VPWR VPWR sky130_fd_sc_hd__decap_3
XFILLER_89_23 VGND VGND VPWR VPWR sky130_fd_sc_hd__decap_8
X_10462_ clknet_leaf_105_clk _00592_ VGND VGND VPWR VPWR count_instr\[11\] sky130_fd_sc_hd__dfxtp_1
XTAP_TAPCELL_ROW_131_2431 VGND VPWR sky130_fd_sc_hd__tapvpwrvgnd_1
XTAP_TAPCELL_ROW_131_2420 VGND VPWR sky130_fd_sc_hd__tapvpwrvgnd_1
XFILLER_124_825 VPWR VGND VPWR VGND sky130_ef_sc_hd__decap_12
XFILLER_124_803 VGND VGND VPWR VPWR sky130_fd_sc_hd__decap_8
XFILLER_108_365 VPWR VGND VPWR VGND sky130_ef_sc_hd__decap_12
XTAP_TAPCELL_ROW_98_1894 VGND VPWR sky130_fd_sc_hd__tapvpwrvgnd_1
X_10393_ clknet_leaf_143_clk _00523_ VGND VGND VPWR VPWR cpuregs\[20\]\[7\] sky130_fd_sc_hd__dfxtp_1
XFILLER_150_121 VPWR VGND VPWR VGND sky130_ef_sc_hd__decap_12
XFILLER_136_696 VGND VGND VPWR VPWR sky130_fd_sc_hd__decap_4
XFILLER_124_869 VPWR VGND VPWR VGND sky130_ef_sc_hd__decap_12
XFILLER_123_335 VGND VGND VPWR VPWR sky130_fd_sc_hd__fill_1
XFILLER_150_165 VPWR VGND VPWR VGND sky130_ef_sc_hd__decap_12
XFILLER_145_51 VGND VGND VPWR VPWR sky130_fd_sc_hd__decap_4
XFILLER_2_643 VGND VGND VPWR VPWR sky130_fd_sc_hd__fill_1
X_11014_ clknet_leaf_28_clk _01076_ VGND VGND VPWR VPWR cpuregs\[19\]\[14\] sky130_fd_sc_hd__dfxtp_1
XFILLER_77_444 VGND VGND VPWR VPWR sky130_fd_sc_hd__decap_4
XFILLER_49_124 VGND VGND VPWR VPWR sky130_fd_sc_hd__decap_6
XTAP_TAPCELL_ROW_129_2393 VGND VPWR sky130_fd_sc_hd__tapvpwrvgnd_1
XFILLER_65_617 VGND VGND VPWR VPWR sky130_fd_sc_hd__decap_4
XFILLER_38_60 VGND VGND VPWR VPWR sky130_fd_sc_hd__decap_3
XFILLER_73_661 VGND VGND VPWR VPWR sky130_fd_sc_hd__decap_4
XFILLER_33_536 VGND VGND VPWR VPWR sky130_fd_sc_hd__fill_1
XFILLER_33_558 VGND VGND VPWR VPWR sky130_fd_sc_hd__fill_2
XFILLER_60_388 VPWR VGND VPWR VGND sky130_ef_sc_hd__decap_12
XFILLER_60_377 VGND VGND VPWR VPWR sky130_fd_sc_hd__decap_6
XFILLER_20_208 VGND VGND VPWR VPWR sky130_fd_sc_hd__decap_4
X_10729_ clknet_leaf_74_clk _00826_ VGND VGND VPWR VPWR net215 sky130_fd_sc_hd__dfxtp_2
XFILLER_146_416 VGND VGND VPWR VPWR sky130_fd_sc_hd__decap_4
Xclkload12 clknet_4_15_0_clk VGND VGND VPWR VPWR clkload12/Y sky130_fd_sc_hd__inv_6
Xclkload23 clknet_leaf_8_clk VGND VGND VPWR VPWR clkload23/Y sky130_fd_sc_hd__clkinv_4
XFILLER_70_91 VGND VGND VPWR VPWR sky130_fd_sc_hd__fill_1
Xclkload34 clknet_leaf_143_clk VGND VGND VPWR VPWR clkload34/Y sky130_fd_sc_hd__inv_6
Xclkload78 clknet_leaf_50_clk VGND VGND VPWR VPWR clkload78/Y sky130_fd_sc_hd__clkinv_4
Xclkload67 clknet_leaf_55_clk VGND VGND VPWR VPWR clkload67/Y sky130_fd_sc_hd__clkinv_8
Xclkload56 clknet_leaf_32_clk VGND VGND VPWR VPWR clkload56/Y sky130_fd_sc_hd__inv_8
Xclkload45 clknet_leaf_138_clk VGND VGND VPWR VPWR clkload45/Y sky130_fd_sc_hd__inv_12
Xclkload89 clknet_leaf_96_clk VGND VGND VPWR VPWR clkload89/Y sky130_fd_sc_hd__clkinv_4
XTAP_TAPCELL_ROW_149_2714 VGND VPWR sky130_fd_sc_hd__tapvpwrvgnd_1
XFILLER_142_677 VPWR VGND VPWR VGND sky130_ef_sc_hd__decap_12
XFILLER_142_666 VGND VGND VPWR VPWR sky130_fd_sc_hd__fill_2
X_07940_ _03762_ _03764_ _03765_ VGND VGND VPWR VPWR _03767_ sky130_fd_sc_hd__a21oi_1
X_07871_ _02679_ reg_next_pc\[24\] net596 VGND VGND VPWR VPWR _03711_ sky130_fd_sc_hd__mux2_2
XFILLER_122_390 VGND VGND VPWR VPWR sky130_fd_sc_hd__decap_4
XFILLER_56_606 VGND VGND VPWR VPWR sky130_fd_sc_hd__fill_2
X_06822_ decoded_imm\[18\] net180 _03215_ VGND VGND VPWR VPWR _03241_ sky130_fd_sc_hd__a21o_1
X_09610_ _02649_ cpuregs\[3\]\[16\] _04868_ VGND VGND VPWR VPWR _01270_ sky130_fd_sc_hd__mux2_1
X_06753_ cpuregs\[4\]\[16\] cpuregs\[5\]\[16\] cpuregs\[6\]\[16\] cpuregs\[7\]\[16\]
+ net265 net260 VGND VGND VPWR VPWR _03175_ sky130_fd_sc_hd__mux4_1
XTAP_TAPCELL_ROW_69_1440 VGND VPWR sky130_fd_sc_hd__tapvpwrvgnd_1
X_09541_ cpuregs\[23\]\[13\] _02638_ _04866_ VGND VGND VPWR VPWR _01203_ sky130_fd_sc_hd__mux2_1
XFILLER_37_853 VPWR VGND VPWR VGND sky130_ef_sc_hd__decap_12
XFILLER_64_661 VGND VGND VPWR VPWR sky130_fd_sc_hd__decap_3
X_05704_ _02161_ _02238_ _02278_ _02280_ VGND VGND VPWR VPWR alu_out\[6\] sky130_fd_sc_hd__a211o_1
X_06684_ decoded_imm\[14\] net176 VGND VGND VPWR VPWR _03108_ sky130_fd_sc_hd__xnor2_1
X_09472_ cpuregs\[24\]\[10\] _02624_ net242 VGND VGND VPWR VPWR _01136_ sky130_fd_sc_hd__mux2_1
XFILLER_51_322 VGND VGND VPWR VPWR sky130_fd_sc_hd__fill_1
XFILLER_37_897 VGND VGND VPWR VPWR sky130_fd_sc_hd__decap_8
X_08423_ count_cycle\[60\] _04161_ net34 VGND VGND VPWR VPWR _04164_ sky130_fd_sc_hd__o21ai_1
X_05635_ _02097_ _02217_ _02216_ VGND VGND VPWR VPWR _02218_ sky130_fd_sc_hd__a21o_1
XTAP_TAPCELL_ROW_82_1651 VGND VPWR sky130_fd_sc_hd__tapvpwrvgnd_1
XTAP_TAPCELL_ROW_82_1640 VGND VPWR sky130_fd_sc_hd__tapvpwrvgnd_1
XFILLER_24_558 VPWR VGND VPWR VGND sky130_ef_sc_hd__decap_12
XFILLER_34_29 VPWR VGND VPWR VGND sky130_ef_sc_hd__decap_12
X_05566_ _02147_ _02148_ VGND VGND VPWR VPWR _02149_ sky130_fd_sc_hd__nor2_1
X_08354_ _04119_ _04120_ VGND VGND VPWR VPWR _00741_ sky130_fd_sc_hd__nor2_1
XFILLER_51_377 VGND VGND VPWR VPWR sky130_fd_sc_hd__fill_1
X_07305_ cpuregs\[28\]\[23\] _02678_ net249 VGND VGND VPWR VPWR _00251_ sky130_fd_sc_hd__mux2_1
XFILLER_51_399 VGND VGND VPWR VPWR sky130_fd_sc_hd__decap_6
XFILLER_20_731 VGND VGND VPWR VPWR sky130_fd_sc_hd__fill_2
X_05497_ _02066_ _02071_ _02075_ _02079_ VGND VGND VPWR VPWR _02080_ sky130_fd_sc_hd__and4_1
X_08285_ count_cycle\[10\] _04073_ _04075_ VGND VGND VPWR VPWR _00717_ sky130_fd_sc_hd__o21a_1
Xclkload6 clknet_4_8_0_clk VGND VGND VPWR VPWR clkload6/X sky130_fd_sc_hd__clkbuf_8
XFILLER_137_449 VGND VGND VPWR VPWR sky130_fd_sc_hd__decap_6
X_07236_ cpuregs\[13\]\[20\] _02665_ _03558_ VGND VGND VPWR VPWR _00184_ sky130_fd_sc_hd__mux2_1
XFILLER_152_419 VGND VGND VPWR VPWR sky130_fd_sc_hd__fill_1
X_07167_ cpuregs\[12\]\[21\] _02670_ _03552_ VGND VGND VPWR VPWR _00121_ sky130_fd_sc_hd__mux2_1
XFILLER_105_335 VGND VGND VPWR VPWR sky130_fd_sc_hd__fill_1
XFILLER_3_429 VPWR VGND VPWR VGND sky130_ef_sc_hd__decap_12
X_06118_ reg_out\[1\] alu_out_q\[1\] latched_stalu VGND VGND VPWR VPWR _02587_ sky130_fd_sc_hd__mux2_1
X_07098_ net188 _02721_ _02744_ _03482_ VGND VGND VPWR VPWR _03507_ sky130_fd_sc_hd__o211a_1
XFILLER_121_839 VGND VGND VPWR VPWR sky130_fd_sc_hd__fill_1
XFILLER_59_411 VPWR VGND VPWR VGND sky130_ef_sc_hd__decap_12
X_06049_ cpuregs\[8\]\[2\] cpuregs\[9\]\[2\] cpuregs\[10\]\[2\] cpuregs\[11\]\[2\]
+ net279 _00008_ VGND VGND VPWR VPWR _02522_ sky130_fd_sc_hd__mux4_1
XFILLER_101_552 VGND VGND VPWR VPWR sky130_fd_sc_hd__decap_8
XFILLER_86_274 VGND VGND VPWR VPWR sky130_fd_sc_hd__fill_1
XFILLER_74_414 VGND VGND VPWR VPWR sky130_fd_sc_hd__decap_6
X_09808_ _02646_ cpuregs\[8\]\[15\] _04875_ VGND VGND VPWR VPWR _01461_ sky130_fd_sc_hd__mux2_1
XFILLER_19_308 VGND VGND VPWR VPWR sky130_fd_sc_hd__decap_4
XFILLER_47_617 VGND VGND VPWR VPWR sky130_fd_sc_hd__decap_6
XFILLER_86_296 VPWR VGND VPWR VGND sky130_ef_sc_hd__decap_12
XFILLER_75_47 VGND VGND VPWR VPWR sky130_fd_sc_hd__decap_8
X_09739_ _02633_ cpuregs\[6\]\[12\] _04873_ VGND VGND VPWR VPWR _01394_ sky130_fd_sc_hd__mux2_1
XFILLER_46_149 VGND VGND VPWR VPWR sky130_fd_sc_hd__decap_3
XFILLER_131_75 VGND VGND VPWR VPWR sky130_fd_sc_hd__fill_1
XFILLER_55_694 VGND VGND VPWR VPWR sky130_fd_sc_hd__decap_6
XFILLER_15_536 VGND VGND VPWR VPWR sky130_fd_sc_hd__decap_6
XFILLER_42_300 VGND VGND VPWR VPWR sky130_fd_sc_hd__decap_8
XFILLER_91_57 VGND VGND VPWR VPWR sky130_fd_sc_hd__decap_4
XFILLER_30_528 VGND VGND VPWR VPWR sky130_fd_sc_hd__decap_4
XFILLER_42_377 VGND VGND VPWR VPWR sky130_fd_sc_hd__decap_3
X_11494_ clknet_leaf_40_clk _01538_ VGND VGND VPWR VPWR cpuregs\[10\]\[28\] sky130_fd_sc_hd__dfxtp_1
X_10514_ clknet_leaf_80_clk _00644_ VGND VGND VPWR VPWR count_instr\[63\] sky130_fd_sc_hd__dfxtp_1
XFILLER_11_797 VPWR VGND VPWR VGND sky130_ef_sc_hd__decap_12
X_10445_ clknet_leaf_35_clk _00575_ VGND VGND VPWR VPWR cpuregs\[17\]\[27\] sky130_fd_sc_hd__dfxtp_1
XFILLER_109_652 VGND VGND VPWR VPWR sky130_fd_sc_hd__fill_2
XFILLER_6_245 VGND VGND VPWR VPWR sky130_fd_sc_hd__decap_6
XFILLER_108_162 VPWR VGND VPWR VGND sky130_ef_sc_hd__decap_12
XFILLER_6_289 VPWR VGND VPWR VGND sky130_ef_sc_hd__decap_12
XFILLER_40_83 VGND VGND VPWR VPWR sky130_fd_sc_hd__fill_1
X_10376_ clknet_leaf_49_clk _00506_ VGND VGND VPWR VPWR cpuregs\[25\]\[22\] sky130_fd_sc_hd__dfxtp_1
XFILLER_112_828 VGND VGND VPWR VPWR sky130_fd_sc_hd__decap_8
XFILLER_2_462 VGND VGND VPWR VPWR sky130_fd_sc_hd__fill_1
XFILLER_77_241 VGND VGND VPWR VPWR sky130_fd_sc_hd__fill_1
XFILLER_120_861 VGND VGND VPWR VPWR sky130_fd_sc_hd__decap_6
XFILLER_78_786 VPWR VGND VPWR VGND sky130_ef_sc_hd__decap_12
XFILLER_38_617 VGND VGND VPWR VPWR sky130_fd_sc_hd__fill_1
XTAP_TAPCELL_ROW_144_2633 VGND VPWR sky130_fd_sc_hd__tapvpwrvgnd_1
XFILLER_65_447 VGND VGND VPWR VPWR sky130_fd_sc_hd__fill_1
XFILLER_1_55 VGND VGND VPWR VPWR sky130_fd_sc_hd__fill_1
XFILLER_38_639 VGND VGND VPWR VPWR sky130_fd_sc_hd__decap_4
XFILLER_93_767 VGND VGND VPWR VPWR sky130_fd_sc_hd__fill_1
XFILLER_19_853 VPWR VGND VPWR VGND sky130_ef_sc_hd__decap_12
XFILLER_92_299 VGND VGND VPWR VPWR sky130_fd_sc_hd__decap_8
XFILLER_80_439 VGND VGND VPWR VPWR sky130_fd_sc_hd__decap_3
XFILLER_18_374 VGND VGND VPWR VPWR sky130_fd_sc_hd__decap_3
XFILLER_19_897 VGND VGND VPWR VPWR sky130_fd_sc_hd__decap_6
XFILLER_33_322 VGND VGND VPWR VPWR sky130_fd_sc_hd__decap_6
XFILLER_34_867 VGND VGND VPWR VPWR sky130_fd_sc_hd__fill_1
XFILLER_45_182 VGND VGND VPWR VPWR sky130_fd_sc_hd__fill_1
X_05420_ reg_pc\[28\] decoded_imm\[28\] VGND VGND VPWR VPWR _02007_ sky130_fd_sc_hd__nand2_1
XFILLER_60_141 VGND VGND VPWR VPWR sky130_fd_sc_hd__decap_3
XTAP_TAPCELL_ROW_47_1078 VGND VPWR sky130_fd_sc_hd__tapvpwrvgnd_1
XTAP_TAPCELL_ROW_47_1089 VGND VPWR sky130_fd_sc_hd__tapvpwrvgnd_1
X_05351_ reg_pc\[23\] decoded_imm\[23\] VGND VGND VPWR VPWR _01943_ sky130_fd_sc_hd__nand2_1
XFILLER_14_580 VGND VGND VPWR VPWR sky130_fd_sc_hd__decap_8
XTAP_TAPCELL_ROW_16_586 VGND VPWR sky130_fd_sc_hd__tapvpwrvgnd_1
XFILLER_146_213 VGND VGND VPWR VPWR sky130_fd_sc_hd__fill_1
XFILLER_119_449 VGND VGND VPWR VPWR sky130_fd_sc_hd__fill_2
Xclkload112 clknet_leaf_62_clk VGND VGND VPWR VPWR clkload112/Y sky130_fd_sc_hd__clkinv_2
X_08070_ instr_jal _03885_ _03886_ VGND VGND VPWR VPWR _03887_ sky130_fd_sc_hd__or3_1
X_05282_ net9 _01665_ _01856_ VGND VGND VPWR VPWR _01880_ sky130_fd_sc_hd__a21o_1
XTAP_TAPCELL_ROW_60_1289 VGND VPWR sky130_fd_sc_hd__tapvpwrvgnd_1
Xclkload101 clknet_leaf_118_clk VGND VGND VPWR VPWR clkload101/Y sky130_fd_sc_hd__inv_6
X_07021_ cpuregs\[16\]\[26\] cpuregs\[17\]\[26\] cpuregs\[18\]\[26\] cpuregs\[19\]\[26\]
+ net267 net261 VGND VGND VPWR VPWR _03433_ sky130_fd_sc_hd__mux4_1
Xclkload123 clknet_leaf_72_clk VGND VGND VPWR VPWR clkload123/Y sky130_fd_sc_hd__clkinvlp_4
XFILLER_115_600 VPWR VGND VPWR VGND sky130_ef_sc_hd__decap_12
Xclkload134 clknet_leaf_93_clk VGND VGND VPWR VPWR clkload134/Y sky130_fd_sc_hd__inv_6
XFILLER_114_110 VPWR VGND VPWR VGND sky130_ef_sc_hd__decap_12
X_08972_ cpuregs\[20\]\[27\] cpuregs\[21\]\[27\] cpuregs\[22\]\[27\] cpuregs\[23\]\[27\]
+ net275 net271 VGND VGND VPWR VPWR _04647_ sky130_fd_sc_hd__mux4_1
XFILLER_69_753 VGND VGND VPWR VPWR sky130_fd_sc_hd__decap_3
X_07923_ decoded_imm_j\[5\] _03692_ VGND VGND VPWR VPWR _03751_ sky130_fd_sc_hd__nor2_1
X_07854_ reg_pc\[15\] _01624_ _01628_ _03702_ VGND VGND VPWR VPWR _00659_ sky130_fd_sc_hd__a22o_1
XFILLER_29_617 VGND VGND VPWR VPWR sky130_fd_sc_hd__decap_6
X_06805_ cpuregs\[24\]\[18\] cpuregs\[25\]\[18\] cpuregs\[26\]\[18\] cpuregs\[27\]\[18\]
+ net265 net260 VGND VGND VPWR VPWR _03225_ sky130_fd_sc_hd__mux4_1
XFILLER_111_894 VGND VGND VPWR VPWR sky130_fd_sc_hd__fill_2
X_07785_ _03659_ count_instr\[48\] count_instr\[49\] VGND VGND VPWR VPWR _03663_ sky130_fd_sc_hd__and3_1
XFILLER_84_789 VGND VGND VPWR VPWR sky130_fd_sc_hd__fill_1
X_04997_ mem_do_prefetch _01612_ _01622_ _01623_ VGND VGND VPWR VPWR _01625_ sky130_fd_sc_hd__a31o_1
X_09524_ cpuregs\[31\]\[29\] _02704_ net240 VGND VGND VPWR VPWR _01187_ sky130_fd_sc_hd__mux2_1
X_06736_ decoded_imm\[14\] net176 _03131_ VGND VGND VPWR VPWR _03158_ sky130_fd_sc_hd__and3_1
X_09455_ _02691_ cpuregs\[19\]\[26\] _04863_ VGND VGND VPWR VPWR _01088_ sky130_fd_sc_hd__mux2_1
X_06667_ cpuregs\[24\]\[13\] cpuregs\[25\]\[13\] cpuregs\[26\]\[13\] cpuregs\[27\]\[13\]
+ net265 net260 VGND VGND VPWR VPWR _03092_ sky130_fd_sc_hd__mux4_1
X_08406_ count_cycle\[53\] _04149_ count_cycle\[54\] VGND VGND VPWR VPWR _04153_ sky130_fd_sc_hd__and3_1
X_05618_ _02199_ _02200_ _02149_ VGND VGND VPWR VPWR _02201_ sky130_fd_sc_hd__a21o_1
XFILLER_25_889 VGND VGND VPWR VPWR sky130_fd_sc_hd__decap_6
XTAP_TAPCELL_ROW_35_884 VGND VPWR sky130_fd_sc_hd__tapvpwrvgnd_1
X_06598_ net258 _03016_ _00016_ VGND VGND VPWR VPWR _03026_ sky130_fd_sc_hd__o21a_1
XTAP_TAPCELL_ROW_35_895 VGND VPWR sky130_fd_sc_hd__tapvpwrvgnd_1
X_09386_ mem_rdata_q\[23\] _04791_ VGND VGND VPWR VPWR _04856_ sky130_fd_sc_hd__and2_1
XFILLER_138_725 VPWR VGND VPWR VGND sky130_ef_sc_hd__decap_12
X_08337_ count_cycle\[28\] _04108_ net34 VGND VGND VPWR VPWR _04110_ sky130_fd_sc_hd__o21ai_1
X_05549_ net201 net233 VGND VGND VPWR VPWR _02132_ sky130_fd_sc_hd__nor2_1
X_08268_ count_cycle\[4\] net403 _01549_ VGND VGND VPWR VPWR _04065_ sky130_fd_sc_hd__a21oi_1
X_07219_ cpuregs\[13\]\[3\] _02593_ net251 VGND VGND VPWR VPWR _00167_ sky130_fd_sc_hd__mux2_1
X_08199_ _03575_ _04004_ _04005_ VGND VGND VPWR VPWR _04006_ sky130_fd_sc_hd__a21o_1
XTAP_TAPCELL_ROW_111_2109 VGND VPWR sky130_fd_sc_hd__tapvpwrvgnd_1
XTAP_TAPCELL_ROW_95_1853 VGND VPWR sky130_fd_sc_hd__tapvpwrvgnd_1
XFILLER_4_749 VGND VGND VPWR VPWR sky130_fd_sc_hd__decap_6
X_10230_ clknet_leaf_137_clk _00360_ VGND VGND VPWR VPWR cpuregs\[27\]\[4\] sky130_fd_sc_hd__dfxtp_1
XFILLER_133_441 VGND VGND VPWR VPWR sky130_fd_sc_hd__decap_6
XFILLER_10_53 VPWR VGND VPWR VGND sky130_ef_sc_hd__decap_12
XFILLER_3_237 VPWR VGND VPWR VGND sky130_ef_sc_hd__decap_12
XFILLER_126_53 VGND VGND VPWR VPWR sky130_fd_sc_hd__decap_6
X_10161_ clknet_leaf_17_clk _00291_ VGND VGND VPWR VPWR cpuregs\[21\]\[31\] sky130_fd_sc_hd__dfxtp_1
XFILLER_10_97 VPWR VGND VPWR VGND sky130_ef_sc_hd__decap_12
XFILLER_0_900 VGND VGND VPWR VPWR sky130_fd_sc_hd__decap_6
X_10092_ clknet_leaf_40_clk _00222_ VGND VGND VPWR VPWR cpuregs\[2\]\[26\] sky130_fd_sc_hd__dfxtp_1
XFILLER_120_179 VPWR VGND VPWR VGND sky130_ef_sc_hd__decap_12
XFILLER_120_157 VGND VGND VPWR VPWR sky130_fd_sc_hd__decap_6
XFILLER_47_403 VGND VGND VPWR VPWR sky130_fd_sc_hd__decap_8
XFILLER_142_41 VPWR VGND VPWR VGND sky130_ef_sc_hd__decap_12
XTAP_TAPCELL_ROW_126_2341 VGND VPWR sky130_fd_sc_hd__tapvpwrvgnd_1
XFILLER_101_393 VGND VGND VPWR VPWR sky130_fd_sc_hd__fill_2
XFILLER_59_285 VGND VGND VPWR VPWR sky130_fd_sc_hd__fill_1
XFILLER_19_51 VGND VGND VPWR VPWR sky130_fd_sc_hd__decap_4
XFILLER_142_85 VGND VGND VPWR VPWR sky130_fd_sc_hd__decap_8
XTAP_TAPCELL_ROW_126_2352 VGND VPWR sky130_fd_sc_hd__tapvpwrvgnd_1
XFILLER_75_767 VGND VGND VPWR VPWR sky130_fd_sc_hd__decap_6
XFILLER_74_244 VGND VGND VPWR VPWR sky130_fd_sc_hd__decap_8
X_10994_ clknet_leaf_45_clk _01056_ VGND VGND VPWR VPWR cpuregs\[18\]\[26\] sky130_fd_sc_hd__dfxtp_1
XFILLER_74_277 VGND VGND VPWR VPWR sky130_fd_sc_hd__fill_1
XFILLER_34_119 VGND VGND VPWR VPWR sky130_fd_sc_hd__decap_4
XFILLER_55_491 VGND VGND VPWR VPWR sky130_fd_sc_hd__fill_1
XFILLER_16_867 VGND VGND VPWR VPWR sky130_fd_sc_hd__fill_1
XFILLER_43_653 VGND VGND VPWR VPWR sky130_fd_sc_hd__fill_2
XTAP_TAPCELL_ROW_104_1993 VGND VPWR sky130_fd_sc_hd__tapvpwrvgnd_1
XTAP_TAPCELL_ROW_13_534 VGND VPWR sky130_fd_sc_hd__tapvpwrvgnd_1
XFILLER_30_325 VGND VGND VPWR VPWR sky130_fd_sc_hd__decap_6
XTAP_TAPCELL_ROW_13_545 VGND VPWR sky130_fd_sc_hd__tapvpwrvgnd_1
XFILLER_128_213 VGND VGND VPWR VPWR sky130_fd_sc_hd__decap_8
XFILLER_117_909 VGND VGND VPWR VPWR sky130_fd_sc_hd__decap_3
XFILLER_116_419 VGND VGND VPWR VPWR sky130_fd_sc_hd__fill_1
XFILLER_51_93 VGND VGND VPWR VPWR sky130_fd_sc_hd__decap_3
XFILLER_137_780 VGND VGND VPWR VPWR sky130_fd_sc_hd__decap_4
X_11477_ clknet_leaf_0_clk _01521_ VGND VGND VPWR VPWR cpuregs\[10\]\[11\] sky130_fd_sc_hd__dfxtp_1
X_10428_ clknet_leaf_12_clk _00558_ VGND VGND VPWR VPWR cpuregs\[17\]\[10\] sky130_fd_sc_hd__dfxtp_1
X_10359_ clknet_leaf_140_clk _00489_ VGND VGND VPWR VPWR cpuregs\[25\]\[5\] sky130_fd_sc_hd__dfxtp_1
XFILLER_111_113 VGND VGND VPWR VPWR sky130_fd_sc_hd__decap_4
XFILLER_78_572 VGND VGND VPWR VPWR sky130_fd_sc_hd__fill_1
X_04920_ net171 VGND VGND VPWR VPWR _01553_ sky130_fd_sc_hd__inv_2
XFILLER_93_520 VPWR VGND VPWR VGND sky130_ef_sc_hd__decap_12
XFILLER_66_723 VGND VGND VPWR VPWR sky130_fd_sc_hd__decap_8
XFILLER_18_3 VPWR VGND VPWR VGND sky130_ef_sc_hd__decap_12
XFILLER_81_715 VPWR VGND VPWR VGND sky130_ef_sc_hd__decap_12
XFILLER_53_406 VGND VGND VPWR VPWR sky130_fd_sc_hd__decap_3
X_07570_ cpuregs\[25\]\[21\] _02670_ _03571_ VGND VGND VPWR VPWR _00505_ sky130_fd_sc_hd__mux2_1
XFILLER_93_597 VGND VGND VPWR VPWR sky130_fd_sc_hd__decap_3
XFILLER_80_214 VGND VGND VPWR VPWR sky130_fd_sc_hd__fill_1
XFILLER_53_428 VGND VGND VPWR VPWR sky130_fd_sc_hd__decap_4
XTAP_TAPCELL_ROW_49_1118 VGND VPWR sky130_fd_sc_hd__tapvpwrvgnd_1
X_06521_ decoded_imm\[8\] net201 VGND VGND VPWR VPWR _02951_ sky130_fd_sc_hd__and2_1
X_09240_ cpuregs\[1\]\[19\] _02662_ _04799_ VGND VGND VPWR VPWR _00937_ sky130_fd_sc_hd__mux2_1
XTAP_TAPCELL_ROW_62_1329 VGND VPWR sky130_fd_sc_hd__tapvpwrvgnd_1
XTAP_TAPCELL_ROW_62_1318 VGND VPWR sky130_fd_sc_hd__tapvpwrvgnd_1
XFILLER_61_461 VGND VGND VPWR VPWR sky130_fd_sc_hd__decap_8
XFILLER_22_837 VPWR VGND VPWR VGND sky130_ef_sc_hd__decap_12
X_06452_ cpuregs\[12\]\[5\] cpuregs\[13\]\[5\] cpuregs\[14\]\[5\] cpuregs\[15\]\[5\]
+ net264 net262 VGND VGND VPWR VPWR _02885_ sky130_fd_sc_hd__mux4_1
XFILLER_147_500 VGND VGND VPWR VPWR sky130_fd_sc_hd__decap_4
X_05403_ reg_pc\[27\] decoded_imm\[27\] VGND VGND VPWR VPWR _01991_ sky130_fd_sc_hd__nor2_1
X_09171_ _04782_ _04786_ VGND VGND VPWR VPWR _04787_ sky130_fd_sc_hd__or2_1
X_06383_ _01578_ _02817_ VGND VGND VPWR VPWR _02818_ sky130_fd_sc_hd__or2_1
XTAP_TAPCELL_ROW_32_843 VGND VPWR sky130_fd_sc_hd__tapvpwrvgnd_1
X_08122_ instr_jal _03933_ _03934_ VGND VGND VPWR VPWR _03935_ sky130_fd_sc_hd__or3b_1
X_05334_ count_instr\[21\] instr_rdinstr count_cycle\[53\] instr_rdcycleh VGND VGND
+ VPWR VPWR _01928_ sky130_fd_sc_hd__a22o_1
XFILLER_30_881 VPWR VGND VPWR VGND sky130_ef_sc_hd__decap_12
XFILLER_119_279 VGND VGND VPWR VPWR sky130_fd_sc_hd__fill_1
X_08053_ _03851_ _03870_ _03857_ VGND VGND VPWR VPWR _03871_ sky130_fd_sc_hd__o21ai_1
X_07004_ _00014_ _03411_ _00016_ VGND VGND VPWR VPWR _03417_ sky130_fd_sc_hd__o21a_1
X_05265_ cpu_state\[4\] net177 _01861_ _01864_ VGND VGND VPWR VPWR _01865_ sky130_fd_sc_hd__a211oi_1
XFILLER_150_709 VGND VGND VPWR VPWR sky130_fd_sc_hd__decap_3
XPHY_EDGE_ROW_131_Right_131 VGND VGND VPWR VPWR sky130_fd_sc_hd__decap_3
XTAP_TAPCELL_ROW_77_1561 VGND VPWR sky130_fd_sc_hd__tapvpwrvgnd_1
X_05196_ reg_pc\[11\] decoded_imm\[11\] VGND VGND VPWR VPWR _01800_ sky130_fd_sc_hd__nand2_1
Xpicorv32_296 VGND VGND VPWR VPWR picorv32_296/HI eoi[15] sky130_fd_sc_hd__conb_1
Xpicorv32_285 VGND VGND VPWR VPWR picorv32_285/HI eoi[4] sky130_fd_sc_hd__conb_1
XFILLER_143_783 VGND VGND VPWR VPWR sky130_fd_sc_hd__fill_1
XFILLER_89_837 VGND VGND VPWR VPWR sky130_fd_sc_hd__decap_3
X_08955_ cpuregs\[20\]\[26\] cpuregs\[21\]\[26\] cpuregs\[22\]\[26\] cpuregs\[23\]\[26\]
+ net280 net274 VGND VGND VPWR VPWR _04631_ sky130_fd_sc_hd__mux4_1
XFILLER_130_477 VPWR VGND VPWR VGND sky130_ef_sc_hd__decap_12
XTAP_TAPCELL_ROW_90_1772 VGND VPWR sky130_fd_sc_hd__tapvpwrvgnd_1
X_07906_ _03721_ _03726_ _03725_ VGND VGND VPWR VPWR _03736_ sky130_fd_sc_hd__a21oi_2
X_08886_ cpuregs\[20\]\[22\] cpuregs\[21\]\[22\] cpuregs\[22\]\[22\] cpuregs\[23\]\[22\]
+ net280 net274 VGND VGND VPWR VPWR _04566_ sky130_fd_sc_hd__mux4_1
XFILLER_84_531 VGND VGND VPWR VPWR sky130_fd_sc_hd__fill_1
XFILLER_56_27 VGND VGND VPWR VPWR sky130_fd_sc_hd__fill_1
XTAP_TAPCELL_ROW_108_2060 VGND VPWR sky130_fd_sc_hd__tapvpwrvgnd_1
X_07837_ _02608_ reg_next_pc\[7\] _02482_ VGND VGND VPWR VPWR _03694_ sky130_fd_sc_hd__mux2_2
XFILLER_29_458 VGND VGND VPWR VPWR sky130_fd_sc_hd__decap_6
X_07768_ count_instr\[42\] _03649_ count_instr\[43\] VGND VGND VPWR VPWR _03652_ sky130_fd_sc_hd__a21o_1
XFILLER_16_108 VPWR VGND VPWR VGND sky130_ef_sc_hd__decap_12
X_06719_ cpuregs\[28\]\[15\] cpuregs\[29\]\[15\] cpuregs\[30\]\[15\] cpuregs\[31\]\[15\]
+ net264 net259 VGND VGND VPWR VPWR _03142_ sky130_fd_sc_hd__mux4_1
X_09507_ cpuregs\[31\]\[12\] _02633_ net240 VGND VGND VPWR VPWR _01170_ sky130_fd_sc_hd__mux2_1
XTAP_TAPCELL_ROW_121_2271 VGND VPWR sky130_fd_sc_hd__tapvpwrvgnd_1
XTAP_TAPCELL_ROW_121_2260 VGND VPWR sky130_fd_sc_hd__tapvpwrvgnd_1
X_07699_ count_instr\[17\] _03605_ count_instr\[18\] VGND VGND VPWR VPWR _03608_ sky130_fd_sc_hd__a21o_1
XFILLER_71_269 VGND VGND VPWR VPWR sky130_fd_sc_hd__fill_2
XFILLER_52_461 VGND VGND VPWR VPWR sky130_fd_sc_hd__decap_3
XFILLER_12_325 VPWR VGND VPWR VGND sky130_ef_sc_hd__decap_12
X_09438_ _02621_ cpuregs\[19\]\[9\] _04863_ VGND VGND VPWR VPWR _01071_ sky130_fd_sc_hd__mux2_1
X_09369_ is_beq_bne_blt_bge_bltu_bgeu mem_rdata_q\[7\] decoded_imm_j\[11\] instr_jal
+ _04747_ VGND VGND VPWR VPWR _04847_ sky130_fd_sc_hd__a221o_1
X_11400_ clknet_leaf_29_clk _01444_ VGND VGND VPWR VPWR cpuregs\[7\]\[30\] sky130_fd_sc_hd__dfxtp_1
XFILLER_153_503 VGND VGND VPWR VPWR sky130_fd_sc_hd__fill_1
X_11331_ clknet_leaf_39_clk _01378_ VGND VGND VPWR VPWR cpuregs\[5\]\[28\] sky130_fd_sc_hd__dfxtp_1
XFILLER_122_3 VPWR VGND VPWR VGND sky130_ef_sc_hd__decap_12
XFILLER_125_238 VGND VGND VPWR VPWR sky130_fd_sc_hd__fill_1
XFILLER_134_750 VGND VGND VPWR VPWR sky130_fd_sc_hd__decap_6
X_11262_ clknet_leaf_52_clk _01309_ VGND VGND VPWR VPWR cpuregs\[22\]\[23\] sky130_fd_sc_hd__dfxtp_1
XFILLER_97_23 VPWR VGND VPWR VGND sky130_ef_sc_hd__decap_12
XFILLER_4_557 VPWR VGND VPWR VGND sky130_ef_sc_hd__decap_12
X_10213_ clknet_leaf_70_clk _00343_ VGND VGND VPWR VPWR cpuregs\[14\]\[19\] sky130_fd_sc_hd__dfxtp_1
X_11193_ clknet_leaf_52_clk _01240_ VGND VGND VPWR VPWR cpuregs\[29\]\[18\] sky130_fd_sc_hd__dfxtp_1
XFILLER_106_496 VGND VGND VPWR VPWR sky130_fd_sc_hd__decap_3
X_10144_ clknet_leaf_27_clk _00274_ VGND VGND VPWR VPWR cpuregs\[21\]\[14\] sky130_fd_sc_hd__dfxtp_1
XFILLER_0_741 VGND VGND VPWR VPWR sky130_fd_sc_hd__decap_4
XFILLER_88_881 VGND VGND VPWR VPWR sky130_fd_sc_hd__fill_2
XFILLER_79_369 VGND VGND VPWR VPWR sky130_fd_sc_hd__fill_1
XFILLER_48_701 VGND VGND VPWR VPWR sky130_fd_sc_hd__fill_2
XFILLER_87_391 VGND VGND VPWR VPWR sky130_fd_sc_hd__fill_1
XFILLER_0_785 VGND VGND VPWR VPWR sky130_fd_sc_hd__fill_2
X_10075_ clknet_leaf_151_clk _00205_ VGND VGND VPWR VPWR cpuregs\[2\]\[9\] sky130_fd_sc_hd__dfxtp_1
XFILLER_90_512 VGND VGND VPWR VPWR sky130_fd_sc_hd__fill_1
XFILLER_62_214 VGND VGND VPWR VPWR sky130_fd_sc_hd__fill_2
XTAP_TAPCELL_ROW_18_615 VGND VPWR sky130_fd_sc_hd__tapvpwrvgnd_1
XTAP_TAPCELL_ROW_18_626 VGND VPWR sky130_fd_sc_hd__tapvpwrvgnd_1
X_10977_ clknet_leaf_151_clk _01039_ VGND VGND VPWR VPWR cpuregs\[18\]\[9\] sky130_fd_sc_hd__dfxtp_1
XFILLER_149_809 VPWR VGND VPWR VGND sky130_ef_sc_hd__decap_12
XTAP_TAPCELL_ROW_44_1037 VGND VPWR sky130_fd_sc_hd__tapvpwrvgnd_1
XTAP_TAPCELL_ROW_139_2554 VGND VPWR sky130_fd_sc_hd__tapvpwrvgnd_1
XFILLER_12_881 VPWR VGND VPWR VGND sky130_ef_sc_hd__decap_12
XFILLER_129_577 VPWR VGND VPWR VGND sky130_ef_sc_hd__decap_12
XTAP_TAPCELL_ROW_152_2765 VGND VPWR sky130_fd_sc_hd__tapvpwrvgnd_1
X_05050_ mem_wordsize\[2\] mem_wordsize\[1\] net610 VGND VGND VPWR VPWR _01666_ sky130_fd_sc_hd__o21a_2
XFILLER_125_772 VPWR VGND VPWR VGND sky130_ef_sc_hd__decap_12
XTAP_TAPCELL_ROW_59_1280 VGND VPWR sky130_fd_sc_hd__tapvpwrvgnd_1
XFILLER_140_753 VGND VGND VPWR VPWR sky130_fd_sc_hd__decap_3
XFILLER_112_466 VGND VGND VPWR VPWR sky130_fd_sc_hd__decap_6
XTAP_TAPCELL_ROW_72_1480 VGND VPWR sky130_fd_sc_hd__tapvpwrvgnd_1
X_05952_ net221 _01665_ _02476_ VGND VGND VPWR VPWR net115 sky130_fd_sc_hd__a21o_1
X_08740_ cpuregs\[0\]\[14\] cpuregs\[1\]\[14\] cpuregs\[2\]\[14\] cpuregs\[3\]\[14\]
+ net277 net271 VGND VGND VPWR VPWR _04428_ sky130_fd_sc_hd__mux4_1
XTAP_TAPCELL_ROW_72_1491 VGND VPWR sky130_fd_sc_hd__tapvpwrvgnd_1
XFILLER_39_745 VGND VGND VPWR VPWR sky130_fd_sc_hd__fill_1
X_05883_ _02057_ _02431_ _02208_ VGND VGND VPWR VPWR _02439_ sky130_fd_sc_hd__a21bo_1
XFILLER_94_851 VGND VGND VPWR VPWR sky130_fd_sc_hd__fill_1
XFILLER_66_531 VGND VGND VPWR VPWR sky130_fd_sc_hd__fill_1
X_08671_ net270 _04355_ net269 VGND VGND VPWR VPWR _04363_ sky130_fd_sc_hd__o21a_1
X_07622_ _02607_ cpuregs\[17\]\[6\] _03574_ VGND VGND VPWR VPWR _00554_ sky130_fd_sc_hd__mux2_1
XTAP_TAPCELL_ROW_37_924 VGND VPWR sky130_fd_sc_hd__tapvpwrvgnd_1
XFILLER_53_247 VGND VGND VPWR VPWR sky130_fd_sc_hd__decap_8
XFILLER_53_225 VGND VGND VPWR VPWR sky130_fd_sc_hd__decap_4
X_07553_ cpuregs\[25\]\[4\] _02598_ _03571_ VGND VGND VPWR VPWR _00488_ sky130_fd_sc_hd__mux2_1
X_06504_ cpuregs\[28\]\[7\] cpuregs\[29\]\[7\] cpuregs\[30\]\[7\] cpuregs\[31\]\[7\]
+ net268 net262 VGND VGND VPWR VPWR _02935_ sky130_fd_sc_hd__mux4_1
X_07484_ cpuregs\[26\]\[2\] _02590_ _03568_ VGND VGND VPWR VPWR _00422_ sky130_fd_sc_hd__mux2_1
XFILLER_139_308 VGND VGND VPWR VPWR sky130_fd_sc_hd__decap_4
X_09223_ cpuregs\[1\]\[2\] _02590_ net244 VGND VGND VPWR VPWR _00920_ sky130_fd_sc_hd__mux2_1
XFILLER_22_645 VGND VGND VPWR VPWR sky130_fd_sc_hd__decap_6
X_06435_ net196 _02721_ VGND VGND VPWR VPWR _02869_ sky130_fd_sc_hd__or2_1
XFILLER_42_29 VPWR VGND VPWR VGND sky130_ef_sc_hd__decap_12
XTAP_TAPCELL_ROW_79_1601 VGND VPWR sky130_fd_sc_hd__tapvpwrvgnd_1
X_09154_ instr_or _04748_ _04756_ _04772_ VGND VGND VPWR VPWR _00878_ sky130_fd_sc_hd__a22o_1
XFILLER_108_717 VGND VGND VPWR VPWR sky130_fd_sc_hd__decap_6
X_08105_ _03917_ _03918_ VGND VGND VPWR VPWR _03919_ sky130_fd_sc_hd__nor2_1
X_06366_ _01622_ _02796_ _02797_ _02801_ _02725_ VGND VGND VPWR VPWR _02802_ sky130_fd_sc_hd__a311o_1
X_05317_ _01889_ _01911_ _01910_ _01898_ VGND VGND VPWR VPWR _01912_ sky130_fd_sc_hd__o211a_1
X_06297_ decoded_imm_j\[19\] _02734_ is_lui_auipc_jal VGND VGND VPWR VPWR _02735_
+ sky130_fd_sc_hd__o21ba_4
X_09085_ _04739_ _01099_ _04742_ _02514_ instr_lui VGND VGND VPWR VPWR _00844_ sky130_fd_sc_hd__a32o_1
XFILLER_135_558 VGND VGND VPWR VPWR sky130_fd_sc_hd__fill_2
XFILLER_107_238 VGND VGND VPWR VPWR sky130_fd_sc_hd__decap_3
XTAP_TAPCELL_ROW_92_1801 VGND VPWR sky130_fd_sc_hd__tapvpwrvgnd_1
X_05248_ count_instr\[46\] instr_rdinstrh net257 _01848_ VGND VGND VPWR VPWR _01849_
+ sky130_fd_sc_hd__a211o_1
X_08036_ net34 _03855_ VGND VGND VPWR VPWR _00688_ sky130_fd_sc_hd__and2_1
XFILLER_103_411 VPWR VGND VPWR VGND sky130_ef_sc_hd__decap_12
X_05179_ _01771_ _01784_ cpu_state\[6\] VGND VGND VPWR VPWR _01785_ sky130_fd_sc_hd__o21a_1
X_09987_ clknet_leaf_21_clk _00117_ VGND VGND VPWR VPWR cpuregs\[12\]\[17\] sky130_fd_sc_hd__dfxtp_1
XFILLER_67_37 VPWR VGND VPWR VGND sky130_ef_sc_hd__decap_12
X_08938_ cpuregs\[4\]\[25\] cpuregs\[5\]\[25\] cpuregs\[6\]\[25\] cpuregs\[7\]\[25\]
+ net280 net274 VGND VGND VPWR VPWR _04615_ sky130_fd_sc_hd__mux4_1
XFILLER_131_797 VPWR VGND VPWR VGND sky130_ef_sc_hd__decap_12
XFILLER_103_499 VGND VGND VPWR VPWR sky130_fd_sc_hd__fill_2
X_08869_ _01558_ _04549_ VGND VGND VPWR VPWR _04550_ sky130_fd_sc_hd__or2_1
XTAP_TAPCELL_ROW_123_2300 VGND VPWR sky130_fd_sc_hd__tapvpwrvgnd_1
X_10900_ clknet_leaf_37_clk _00962_ VGND VGND VPWR VPWR net163 sky130_fd_sc_hd__dfxtp_1
XFILLER_72_523 VGND VGND VPWR VPWR sky130_fd_sc_hd__fill_2
XTAP_TAPCELL_ROW_4_398 VGND VPWR sky130_fd_sc_hd__tapvpwrvgnd_1
XFILLER_29_277 VGND VGND VPWR VPWR sky130_fd_sc_hd__decap_3
XFILLER_44_247 VGND VGND VPWR VPWR sky130_fd_sc_hd__decap_4
X_10831_ clknet_leaf_88_clk _00896_ VGND VGND VPWR VPWR decoded_imm_j\[19\] sky130_fd_sc_hd__dfxtp_1
XFILLER_72_589 VPWR VGND VPWR VGND sky130_ef_sc_hd__decap_12
XFILLER_72_567 VGND VGND VPWR VPWR sky130_fd_sc_hd__fill_1
XFILLER_16_41 VPWR VGND VPWR VGND sky130_ef_sc_hd__decap_12
X_10762_ clknet_leaf_18_clk alu_out\[15\] VGND VGND VPWR VPWR alu_out_q\[15\] sky130_fd_sc_hd__dfxtp_1
XFILLER_53_781 VGND VGND VPWR VPWR sky130_fd_sc_hd__decap_3
XPHY_EDGE_ROW_11_Right_11 VGND VGND VPWR VPWR sky130_fd_sc_hd__decap_3
XFILLER_16_85 VPWR VGND VPWR VGND sky130_ef_sc_hd__decap_12
XTAP_TAPCELL_ROW_101_1952 VGND VPWR sky130_fd_sc_hd__tapvpwrvgnd_1
XTAP_TAPCELL_ROW_101_1941 VGND VPWR sky130_fd_sc_hd__tapvpwrvgnd_1
XFILLER_139_853 VPWR VGND VPWR VGND sky130_ef_sc_hd__decap_12
X_10693_ clknet_leaf_78_clk _00791_ VGND VGND VPWR VPWR net46 sky130_fd_sc_hd__dfxtp_1
XTAP_TAPCELL_ROW_23_695 VGND VPWR sky130_fd_sc_hd__tapvpwrvgnd_1
XFILLER_153_322 VGND VGND VPWR VPWR sky130_fd_sc_hd__fill_1
XFILLER_139_897 VPWR VGND VPWR VGND sky130_ef_sc_hd__decap_12
XFILLER_5_833 VGND VGND VPWR VPWR sky130_fd_sc_hd__decap_6
XTAP_TAPCELL_ROW_134_2473 VGND VPWR sky130_fd_sc_hd__tapvpwrvgnd_1
XFILLER_4_321 VPWR VGND VPWR VGND sky130_ef_sc_hd__decap_12
X_11314_ clknet_leaf_149_clk _01361_ VGND VGND VPWR VPWR cpuregs\[5\]\[11\] sky130_fd_sc_hd__dfxtp_1
XFILLER_141_517 VPWR VGND VPWR VGND sky130_ef_sc_hd__decap_12
XFILLER_5_877 VPWR VGND VPWR VGND sky130_ef_sc_hd__decap_12
XFILLER_4_365 VPWR VGND VPWR VGND sky130_ef_sc_hd__decap_12
X_11245_ clknet_leaf_151_clk _01292_ VGND VGND VPWR VPWR cpuregs\[22\]\[6\] sky130_fd_sc_hd__dfxtp_1
XFILLER_153_399 VGND VGND VPWR VPWR sky130_fd_sc_hd__decap_3
XPHY_EDGE_ROW_20_Right_20 VGND VGND VPWR VPWR sky130_fd_sc_hd__decap_3
XFILLER_68_829 VGND VGND VPWR VPWR sky130_fd_sc_hd__fill_1
X_11176_ clknet_leaf_115_clk _01223_ VGND VGND VPWR VPWR cpuregs\[29\]\[1\] sky130_fd_sc_hd__dfxtp_1
XFILLER_121_263 VGND VGND VPWR VPWR sky130_fd_sc_hd__fill_1
X_10127_ clknet_leaf_23_clk _00257_ VGND VGND VPWR VPWR cpuregs\[28\]\[29\] sky130_fd_sc_hd__dfxtp_1
XFILLER_94_114 VGND VGND VPWR VPWR sky130_fd_sc_hd__fill_1
XFILLER_67_317 VGND VGND VPWR VPWR sky130_fd_sc_hd__fill_1
X_10058_ clknet_leaf_67_clk _00188_ VGND VGND VPWR VPWR cpuregs\[13\]\[24\] sky130_fd_sc_hd__dfxtp_1
XFILLER_82_309 VPWR VGND VPWR VGND sky130_ef_sc_hd__decap_12
XFILLER_76_895 VGND VGND VPWR VPWR sky130_fd_sc_hd__fill_1
XFILLER_76_884 VGND VGND VPWR VPWR sky130_fd_sc_hd__fill_1
XFILLER_75_361 VGND VGND VPWR VPWR sky130_fd_sc_hd__decap_8
XFILLER_63_556 VGND VGND VPWR VPWR sky130_fd_sc_hd__fill_1
XFILLER_35_225 VGND VGND VPWR VPWR sky130_fd_sc_hd__decap_6
XFILLER_44_781 VGND VGND VPWR VPWR sky130_fd_sc_hd__decap_3
X_06220_ _02667_ _02668_ VGND VGND VPWR VPWR _02669_ sky130_fd_sc_hd__nor2_1
XFILLER_85_3 VGND VGND VPWR VPWR sky130_fd_sc_hd__decap_3
X_06151_ reg_out\[8\] alu_out_q\[8\] net590 VGND VGND VPWR VPWR _02613_ sky130_fd_sc_hd__mux2_1
XFILLER_105_709 VGND VGND VPWR VPWR sky130_fd_sc_hd__fill_1
XFILLER_7_181 VPWR VGND VPWR VGND sky130_ef_sc_hd__decap_12
X_06082_ _02552_ _02553_ _01558_ VGND VGND VPWR VPWR _02554_ sky130_fd_sc_hd__mux2_1
X_05102_ cpu_state\[4\] net196 _01710_ cpu_state\[6\] _01713_ VGND VGND VPWR VPWR
+ _01714_ sky130_fd_sc_hd__a221o_1
XFILLER_145_889 VGND VGND VPWR VPWR sky130_fd_sc_hd__decap_6
XFILLER_104_219 VGND VGND VPWR VPWR sky130_fd_sc_hd__fill_1
XTAP_TAPCELL_ROW_74_1520 VGND VPWR sky130_fd_sc_hd__tapvpwrvgnd_1
X_05033_ is_jalr_addi_slti_sltiu_xori_ori_andi is_lui_auipc_jal VGND VGND VPWR VPWR
+ _01654_ sky130_fd_sc_hd__or2_4
XTAP_TAPCELL_ROW_57_1239 VGND VPWR sky130_fd_sc_hd__tapvpwrvgnd_1
X_09910_ clknet_leaf_13_clk _00045_ VGND VGND VPWR VPWR cpuregs\[11\]\[8\] sky130_fd_sc_hd__dfxtp_1
XFILLER_113_720 VGND VGND VPWR VPWR sky130_fd_sc_hd__decap_8
XFILLER_98_475 VGND VGND VPWR VPWR sky130_fd_sc_hd__fill_1
XFILLER_98_442 VPWR VGND VPWR VGND sky130_ef_sc_hd__decap_12
X_09841_ _02646_ cpuregs\[10\]\[15\] _04876_ VGND VGND VPWR VPWR _01525_ sky130_fd_sc_hd__mux2_1
XFILLER_112_263 VGND VGND VPWR VPWR sky130_fd_sc_hd__decap_3
X_06984_ decoded_imm\[25\] net188 VGND VGND VPWR VPWR _03397_ sky130_fd_sc_hd__or2_1
XFILLER_86_637 VGND VGND VPWR VPWR sky130_fd_sc_hd__decap_6
X_09772_ _02633_ cpuregs\[7\]\[12\] _04874_ VGND VGND VPWR VPWR _01426_ sky130_fd_sc_hd__mux2_1
XFILLER_100_436 VGND VGND VPWR VPWR sky130_fd_sc_hd__fill_2
X_08723_ cpuregs\[0\]\[13\] cpuregs\[1\]\[13\] cpuregs\[2\]\[13\] cpuregs\[3\]\[13\]
+ net277 net271 VGND VGND VPWR VPWR _04412_ sky130_fd_sc_hd__mux4_1
X_05935_ mem_wordsize\[1\] net123 net206 _01672_ VGND VGND VPWR VPWR net100 sky130_fd_sc_hd__a22o_1
XFILLER_94_681 VPWR VGND VPWR VGND sky130_ef_sc_hd__decap_12
X_05866_ _02058_ _02419_ VGND VGND VPWR VPWR _02424_ sky130_fd_sc_hd__nor2_1
XFILLER_81_320 VGND VGND VPWR VPWR sky130_fd_sc_hd__decap_8
XTAP_TAPCELL_ROW_1_346 VGND VPWR sky130_fd_sc_hd__tapvpwrvgnd_1
X_08654_ _04337_ _04345_ _04346_ _01560_ _00010_ VGND VGND VPWR VPWR _04347_ sky130_fd_sc_hd__a221o_1
XFILLER_39_597 VGND VGND VPWR VPWR sky130_fd_sc_hd__decap_4
X_07605_ cpuregs\[20\]\[22\] _02675_ net245 VGND VGND VPWR VPWR _00538_ sky130_fd_sc_hd__mux2_1
X_05797_ _02110_ _02113_ _02348_ VGND VGND VPWR VPWR _02362_ sky130_fd_sc_hd__and3_1
XFILLER_82_876 VGND VGND VPWR VPWR sky130_fd_sc_hd__decap_4
XFILLER_54_589 VGND VGND VPWR VPWR sky130_fd_sc_hd__fill_1
XFILLER_54_567 VGND VGND VPWR VPWR sky130_fd_sc_hd__decap_6
XFILLER_26_269 VGND VGND VPWR VPWR sky130_fd_sc_hd__decap_8
X_08585_ cpuregs\[20\]\[6\] cpuregs\[21\]\[6\] cpuregs\[22\]\[6\] cpuregs\[23\]\[6\]
+ net278 net273 VGND VGND VPWR VPWR _04281_ sky130_fd_sc_hd__mux4_1
X_07536_ _02665_ cpuregs\[16\]\[20\] _03570_ VGND VGND VPWR VPWR _00472_ sky130_fd_sc_hd__mux2_1
XTAP_TAPCELL_ROW_85_1693 VGND VPWR sky130_fd_sc_hd__tapvpwrvgnd_1
X_07467_ cpuregs\[15\]\[18\] _02657_ net246 VGND VGND VPWR VPWR _00406_ sky130_fd_sc_hd__mux2_1
XFILLER_22_464 VGND VGND VPWR VPWR sky130_fd_sc_hd__decap_4
XFILLER_22_475 VGND VGND VPWR VPWR sky130_fd_sc_hd__fill_1
X_09206_ is_sb_sh_sw mem_rdata_q\[7\] _04791_ mem_rdata_q\[20\] _04747_ VGND VGND
+ VPWR VPWR _04792_ sky130_fd_sc_hd__a221o_1
X_07398_ cpuregs\[14\]\[16\] _02649_ net247 VGND VGND VPWR VPWR _00340_ sky130_fd_sc_hd__mux2_1
Xrebuffer212 latched_store VGND VGND VPWR VPWR net598 sky130_fd_sc_hd__dlygate4sd1_1
X_06418_ net259 _02851_ VGND VGND VPWR VPWR _02852_ sky130_fd_sc_hd__or2_1
Xrebuffer223 net608 VGND VGND VPWR VPWR net609 sky130_fd_sc_hd__dlymetal6s2s_1
XFILLER_148_683 VGND VGND VPWR VPWR sky130_fd_sc_hd__fill_1
X_09137_ mem_rdata_q\[28\] mem_rdata_q\[27\] mem_rdata_q\[26\] mem_rdata_q\[25\] VGND
+ VGND VPWR VPWR _04768_ sky130_fd_sc_hd__or4_1
X_06349_ net262 _02784_ _02783_ net258 VGND VGND VPWR VPWR _02785_ sky130_fd_sc_hd__o211a_1
XTAP_TAPCELL_ROW_20_654 VGND VPWR sky130_fd_sc_hd__tapvpwrvgnd_1
XFILLER_147_193 VPWR VGND VPWR VGND sky130_ef_sc_hd__decap_12
XFILLER_136_867 VGND VGND VPWR VPWR sky130_fd_sc_hd__fill_1
X_09068_ _01543_ _01547_ _04731_ _04734_ _04735_ VGND VGND VPWR VPWR _04736_ sky130_fd_sc_hd__a221o_1
XTAP_TAPCELL_ROW_116_2192 VGND VPWR sky130_fd_sc_hd__tapvpwrvgnd_1
XTAP_TAPCELL_ROW_116_2181 VGND VPWR sky130_fd_sc_hd__tapvpwrvgnd_1
X_08019_ _03700_ _03834_ VGND VGND VPWR VPWR _03839_ sky130_fd_sc_hd__and2_1
XFILLER_2_825 VPWR VGND VPWR VGND sky130_ef_sc_hd__decap_12
XFILLER_118_76 VGND VGND VPWR VPWR sky130_fd_sc_hd__decap_8
XFILLER_116_580 VGND VGND VPWR VPWR sky130_fd_sc_hd__decap_8
XFILLER_89_431 VGND VGND VPWR VPWR sky130_fd_sc_hd__decap_3
XTAP_TAPCELL_ROW_9_468 VGND VPWR sky130_fd_sc_hd__tapvpwrvgnd_1
XFILLER_131_561 VGND VGND VPWR VPWR sky130_fd_sc_hd__decap_3
X_11030_ clknet_leaf_30_clk _01092_ VGND VGND VPWR VPWR cpuregs\[19\]\[30\] sky130_fd_sc_hd__dfxtp_1
XTAP_TAPCELL_ROW_9_479 VGND VPWR sky130_fd_sc_hd__tapvpwrvgnd_1
XFILLER_2_869 VPWR VGND VPWR VGND sky130_ef_sc_hd__decap_12
XFILLER_1_368 VGND VGND VPWR VPWR sky130_fd_sc_hd__decap_4
XFILLER_134_53 VPWR VGND VPWR VGND sky130_ef_sc_hd__decap_12
XFILLER_76_136 VGND VGND VPWR VPWR sky130_fd_sc_hd__decap_4
XFILLER_85_670 VGND VGND VPWR VPWR sky130_fd_sc_hd__fill_2
XFILLER_73_810 VGND VGND VPWR VPWR sky130_fd_sc_hd__fill_2
XFILLER_64_309 VGND VGND VPWR VPWR sky130_fd_sc_hd__decap_3
XFILLER_57_350 VGND VGND VPWR VPWR sky130_fd_sc_hd__fill_1
XFILLER_45_512 VGND VGND VPWR VPWR sky130_fd_sc_hd__decap_8
XFILLER_27_51 VGND VGND VPWR VPWR sky130_fd_sc_hd__decap_4
XFILLER_150_41 VPWR VGND VPWR VGND sky130_ef_sc_hd__decap_12
XTAP_TAPCELL_ROW_28_776 VGND VPWR sky130_fd_sc_hd__tapvpwrvgnd_1
XFILLER_33_718 VGND VGND VPWR VPWR sky130_fd_sc_hd__fill_1
XFILLER_150_85 VPWR VGND VPWR VGND sky130_ef_sc_hd__decap_12
X_10814_ clknet_leaf_98_clk _00879_ VGND VGND VPWR VPWR instr_and sky130_fd_sc_hd__dfxtp_1
XFILLER_26_792 VPWR VGND VPWR VGND sky130_ef_sc_hd__decap_12
XTAP_TAPCELL_ROW_28_787 VGND VPWR sky130_fd_sc_hd__tapvpwrvgnd_1
XTAP_TAPCELL_ROW_136_2513 VGND VPWR sky130_fd_sc_hd__tapvpwrvgnd_1
XTAP_TAPCELL_ROW_136_2502 VGND VPWR sky130_fd_sc_hd__tapvpwrvgnd_1
X_10745_ clknet_leaf_104_clk _00842_ VGND VGND VPWR VPWR latched_is_lh sky130_fd_sc_hd__dfxtp_1
XFILLER_9_402 VGND VGND VPWR VPWR sky130_fd_sc_hd__decap_6
XFILLER_139_661 VGND VGND VPWR VPWR sky130_fd_sc_hd__fill_1
X_10676_ clknet_leaf_123_clk _00774_ VGND VGND VPWR VPWR net59 sky130_fd_sc_hd__dfxtp_1
XFILLER_43_94 VGND VGND VPWR VPWR sky130_fd_sc_hd__decap_8
XFILLER_5_641 VPWR VGND VPWR VGND sky130_ef_sc_hd__decap_12
XFILLER_153_141 VPWR VGND VPWR VGND sky130_ef_sc_hd__decap_12
XFILLER_142_837 VPWR VGND VPWR VGND sky130_ef_sc_hd__decap_12
XFILLER_127_889 VGND VGND VPWR VPWR sky130_fd_sc_hd__decap_6
XFILLER_114_517 VPWR VGND VPWR VGND sky130_ef_sc_hd__decap_12
Xoutput209 net209 VGND VGND VPWR VPWR pcpi_rs2[15] sky130_fd_sc_hd__buf_2
XFILLER_107_580 VGND VGND VPWR VPWR sky130_fd_sc_hd__decap_6
X_11228_ clknet_leaf_75_clk _01275_ VGND VGND VPWR VPWR cpuregs\[3\]\[21\] sky130_fd_sc_hd__dfxtp_1
XFILLER_110_701 VGND VGND VPWR VPWR sky130_fd_sc_hd__fill_2
XFILLER_4_195 VGND VGND VPWR VPWR sky130_fd_sc_hd__fill_1
XFILLER_4_77 VGND VGND VPWR VPWR sky130_fd_sc_hd__decap_6
XFILLER_150_881 VPWR VGND VPWR VGND sky130_ef_sc_hd__decap_12
X_11159_ clknet_leaf_54_clk _01206_ VGND VGND VPWR VPWR cpuregs\[23\]\[16\] sky130_fd_sc_hd__dfxtp_1
XTAP_TAPCELL_ROW_52_1158 VGND VPWR sky130_fd_sc_hd__tapvpwrvgnd_1
XFILLER_67_125 VGND VGND VPWR VPWR sky130_fd_sc_hd__decap_8
XTAP_TAPCELL_ROW_52_1169 VGND VPWR sky130_fd_sc_hd__tapvpwrvgnd_1
XTAP_TAPCELL_ROW_147_2686 VGND VPWR sky130_fd_sc_hd__tapvpwrvgnd_1
XFILLER_83_629 VPWR VGND VPWR VGND sky130_ef_sc_hd__decap_12
XFILLER_82_106 VPWR VGND VPWR VGND sky130_ef_sc_hd__decap_12
XFILLER_67_169 VGND VGND VPWR VPWR sky130_fd_sc_hd__decap_3
XFILLER_49_884 VGND VGND VPWR VPWR sky130_fd_sc_hd__decap_3
XFILLER_36_512 VGND VGND VPWR VPWR sky130_fd_sc_hd__fill_1
XFILLER_82_139 VGND VGND VPWR VPWR sky130_fd_sc_hd__fill_1
X_05720_ _02137_ _02240_ _02293_ VGND VGND VPWR VPWR _02294_ sky130_fd_sc_hd__a21o_1
X_05651_ _01544_ _02175_ _02048_ VGND VGND VPWR VPWR _02234_ sky130_fd_sc_hd__o21ai_1
XFILLER_63_386 VGND VGND VPWR VPWR sky130_fd_sc_hd__decap_3
X_08370_ _04129_ _04130_ VGND VGND VPWR VPWR _00747_ sky130_fd_sc_hd__nor2_1
X_07321_ cpuregs\[21\]\[5\] _02603_ net248 VGND VGND VPWR VPWR _00265_ sky130_fd_sc_hd__mux2_1
X_05582_ net193 net119 VGND VGND VPWR VPWR _02165_ sky130_fd_sc_hd__and2_1
XFILLER_118_801 VGND VGND VPWR VPWR sky130_fd_sc_hd__decap_8
X_07252_ cpuregs\[2\]\[3\] _02593_ net250 VGND VGND VPWR VPWR _00199_ sky130_fd_sc_hd__mux2_1
X_06203_ reg_out\[18\] alu_out_q\[18\] net587 VGND VGND VPWR VPWR _02655_ sky130_fd_sc_hd__mux2_1
X_07183_ cpuregs\[30\]\[1\] _02588_ net252 VGND VGND VPWR VPWR _00133_ sky130_fd_sc_hd__mux2_1
XFILLER_118_845 VPWR VGND VPWR VGND sky130_ef_sc_hd__decap_12
X_06134_ reg_out\[5\] alu_out_q\[5\] net589 VGND VGND VPWR VPWR _02599_ sky130_fd_sc_hd__mux2_2
XFILLER_144_141 VPWR VGND VPWR VGND sky130_ef_sc_hd__decap_12
XFILLER_105_517 VGND VGND VPWR VPWR sky130_fd_sc_hd__decap_6
XFILLER_105_539 VGND VGND VPWR VPWR sky130_fd_sc_hd__fill_2
XFILLER_99_740 VGND VGND VPWR VPWR sky130_fd_sc_hd__fill_1
X_06065_ _02516_ _02537_ _01554_ VGND VGND VPWR VPWR _00004_ sky130_fd_sc_hd__mux2_1
X_05016_ reg_sh\[4\] _01638_ VGND VGND VPWR VPWR _01639_ sky130_fd_sc_hd__nor2_4
XFILLER_113_572 VGND VGND VPWR VPWR sky130_fd_sc_hd__fill_2
XFILLER_101_712 VGND VGND VPWR VPWR sky130_fd_sc_hd__fill_1
XFILLER_59_615 VGND VGND VPWR VPWR sky130_fd_sc_hd__fill_1
X_09824_ _02712_ cpuregs\[8\]\[31\] _04875_ VGND VGND VPWR VPWR _01477_ sky130_fd_sc_hd__mux2_1
XTAP_TAPCELL_ROW_6_427 VGND VPWR sky130_fd_sc_hd__tapvpwrvgnd_1
X_06967_ cpuregs\[20\]\[24\] cpuregs\[21\]\[24\] cpuregs\[22\]\[24\] cpuregs\[23\]\[24\]
+ net267 net261 VGND VGND VPWR VPWR _03381_ sky130_fd_sc_hd__mux4_1
X_09755_ _02699_ cpuregs\[6\]\[28\] _04873_ VGND VGND VPWR VPWR _01410_ sky130_fd_sc_hd__mux2_1
XFILLER_46_309 VPWR VGND VPWR VGND sky130_ef_sc_hd__decap_12
X_09686_ cpuregs\[4\]\[25\] _02688_ net238 VGND VGND VPWR VPWR _01343_ sky130_fd_sc_hd__mux2_1
X_06898_ _03305_ _03306_ _03309_ _03310_ _00014_ _01581_ VGND VGND VPWR VPWR _03315_
+ sky130_fd_sc_hd__mux4_1
X_05918_ _02067_ _02469_ VGND VGND VPWR VPWR _02470_ sky130_fd_sc_hd__xor2_1
XTAP_TAPCELL_ROW_87_1722 VGND VPWR sky130_fd_sc_hd__tapvpwrvgnd_1
X_08706_ _01558_ _04386_ net269 VGND VGND VPWR VPWR _04396_ sky130_fd_sc_hd__o21a_1
XFILLER_55_832 VGND VGND VPWR VPWR sky130_fd_sc_hd__decap_8
XFILLER_55_821 VGND VGND VPWR VPWR sky130_fd_sc_hd__decap_4
X_05849_ _02085_ _02408_ VGND VGND VPWR VPWR _02409_ sky130_fd_sc_hd__nand2_1
XFILLER_82_662 VPWR VGND VPWR VGND sky130_ef_sc_hd__decap_12
XFILLER_70_813 VGND VGND VPWR VPWR sky130_fd_sc_hd__fill_1
X_08637_ net270 _04326_ _04325_ _01560_ VGND VGND VPWR VPWR _04331_ sky130_fd_sc_hd__o211a_1
XFILLER_14_206 VGND VGND VPWR VPWR sky130_fd_sc_hd__fill_1
XTAP_TAPCELL_ROW_25_724 VGND VPWR sky130_fd_sc_hd__tapvpwrvgnd_1
X_08568_ cpuregs\[16\]\[5\] cpuregs\[17\]\[5\] cpuregs\[18\]\[5\] cpuregs\[19\]\[5\]
+ net279 _00008_ VGND VGND VPWR VPWR _04265_ sky130_fd_sc_hd__mux4_1
XTAP_TAPCELL_ROW_25_735 VGND VPWR sky130_fd_sc_hd__tapvpwrvgnd_1
X_08499_ net83 net52 _04208_ VGND VGND VPWR VPWR _00797_ sky130_fd_sc_hd__mux2_1
XFILLER_10_401 VPWR VGND VPWR VGND sky130_ef_sc_hd__decap_12
X_07519_ _02593_ cpuregs\[16\]\[3\] _03570_ VGND VGND VPWR VPWR _00455_ sky130_fd_sc_hd__mux2_1
XTAP_TAPCELL_ROW_118_2221 VGND VPWR sky130_fd_sc_hd__tapvpwrvgnd_1
X_10530_ clknet_leaf_93_clk _00660_ VGND VGND VPWR VPWR reg_pc\[16\] sky130_fd_sc_hd__dfxtp_2
X_10461_ clknet_leaf_105_clk _00591_ VGND VGND VPWR VPWR count_instr\[10\] sky130_fd_sc_hd__dfxtp_1
XFILLER_136_631 VPWR VGND VPWR VGND sky130_ef_sc_hd__decap_12
XFILLER_10_489 VGND VGND VPWR VPWR sky130_fd_sc_hd__decap_4
XFILLER_6_438 VGND VGND VPWR VPWR sky130_fd_sc_hd__decap_3
XTAP_TAPCELL_ROW_131_2432 VGND VPWR sky130_fd_sc_hd__tapvpwrvgnd_1
XTAP_TAPCELL_ROW_131_2421 VGND VPWR sky130_fd_sc_hd__tapvpwrvgnd_1
XFILLER_108_377 VPWR VGND VPWR VGND sky130_ef_sc_hd__decap_12
XTAP_TAPCELL_ROW_98_1895 VGND VPWR sky130_fd_sc_hd__tapvpwrvgnd_1
XFILLER_89_57 VGND VGND VPWR VPWR sky130_fd_sc_hd__decap_8
X_10392_ clknet_leaf_0_clk _00522_ VGND VGND VPWR VPWR cpuregs\[20\]\[6\] sky130_fd_sc_hd__dfxtp_1
XFILLER_124_837 VPWR VGND VPWR VGND sky130_ef_sc_hd__decap_12
XFILLER_150_133 VGND VGND VPWR VPWR sky130_fd_sc_hd__decap_6
XFILLER_111_509 VGND VGND VPWR VPWR sky130_fd_sc_hd__fill_2
XFILLER_150_177 VPWR VGND VPWR VGND sky130_ef_sc_hd__decap_12
XFILLER_132_881 VPWR VGND VPWR VGND sky130_ef_sc_hd__decap_12
XFILLER_89_272 VGND VGND VPWR VPWR sky130_fd_sc_hd__decap_8
X_11013_ clknet_leaf_8_clk _01075_ VGND VGND VPWR VPWR cpuregs\[19\]\[13\] sky130_fd_sc_hd__dfxtp_1
XFILLER_2_699 VGND VGND VPWR VPWR sky130_fd_sc_hd__fill_1
XFILLER_49_147 VGND VGND VPWR VPWR sky130_fd_sc_hd__decap_3
XTAP_TAPCELL_ROW_129_2394 VGND VPWR sky130_fd_sc_hd__tapvpwrvgnd_1
XFILLER_65_629 VGND VGND VPWR VPWR sky130_fd_sc_hd__fill_1
XFILLER_49_169 VGND VGND VPWR VPWR sky130_fd_sc_hd__decap_6
XFILLER_18_501 VGND VGND VPWR VPWR sky130_fd_sc_hd__decap_8
XFILLER_38_83 VGND VGND VPWR VPWR sky130_fd_sc_hd__fill_1
XFILLER_73_651 VGND VGND VPWR VPWR sky130_fd_sc_hd__decap_3
XFILLER_18_556 VGND VGND VPWR VPWR sky130_fd_sc_hd__decap_3
XFILLER_45_353 VGND VGND VPWR VPWR sky130_fd_sc_hd__fill_1
XFILLER_72_150 VGND VGND VPWR VPWR sky130_fd_sc_hd__decap_4
XFILLER_61_857 VGND VGND VPWR VPWR sky130_fd_sc_hd__fill_2
X_10728_ clknet_leaf_64_clk _00825_ VGND VGND VPWR VPWR net213 sky130_fd_sc_hd__dfxtp_4
XFILLER_9_221 VGND VGND VPWR VPWR sky130_fd_sc_hd__decap_3
XFILLER_127_642 VPWR VGND VPWR VGND sky130_ef_sc_hd__decap_12
X_10659_ clknet_leaf_89_clk _04886_ VGND VGND VPWR VPWR reg_out\[17\] sky130_fd_sc_hd__dfxtp_1
Xclkload24 clknet_leaf_9_clk VGND VGND VPWR VPWR clkload24/Y sky130_fd_sc_hd__inv_8
Xclkload35 clknet_leaf_144_clk VGND VGND VPWR VPWR clkload35/Y sky130_fd_sc_hd__inv_8
Xclkload13 clknet_leaf_1_clk VGND VGND VPWR VPWR clkload13/Y sky130_fd_sc_hd__bufinv_16
Xclkload57 clknet_leaf_35_clk VGND VGND VPWR VPWR clkload57/Y sky130_fd_sc_hd__clkinvlp_4
Xclkload68 clknet_leaf_56_clk VGND VGND VPWR VPWR clkload68/Y sky130_fd_sc_hd__clkinv_8
Xclkload46 clknet_leaf_21_clk VGND VGND VPWR VPWR clkload46/Y sky130_fd_sc_hd__clkinvlp_4
XFILLER_141_111 VGND VGND VPWR VPWR sky130_fd_sc_hd__fill_1
Xclkload79 clknet_leaf_51_clk VGND VGND VPWR VPWR clkload79/Y sky130_fd_sc_hd__inv_8
XFILLER_115_837 VGND VGND VPWR VPWR sky130_fd_sc_hd__decap_3
XFILLER_5_482 VGND VGND VPWR VPWR sky130_fd_sc_hd__decap_6
XTAP_TAPCELL_ROW_149_2715 VGND VPWR sky130_fd_sc_hd__tapvpwrvgnd_1
XFILLER_142_689 VGND VGND VPWR VPWR sky130_fd_sc_hd__decap_8
X_07870_ reg_pc\[23\] _01624_ _01628_ _03710_ VGND VGND VPWR VPWR _00667_ sky130_fd_sc_hd__a22o_1
XFILLER_68_456 VGND VGND VPWR VPWR sky130_fd_sc_hd__fill_1
X_06821_ _03238_ _03239_ VGND VGND VPWR VPWR _03240_ sky130_fd_sc_hd__nand2_1
XFILLER_28_309 VGND VGND VPWR VPWR sky130_fd_sc_hd__decap_4
X_06752_ cpuregs\[24\]\[16\] cpuregs\[25\]\[16\] cpuregs\[26\]\[16\] cpuregs\[27\]\[16\]
+ net265 net260 VGND VGND VPWR VPWR _03174_ sky130_fd_sc_hd__mux4_1
XTAP_TAPCELL_ROW_69_1430 VGND VPWR sky130_fd_sc_hd__tapvpwrvgnd_1
X_09540_ cpuregs\[23\]\[12\] _02633_ _04866_ VGND VGND VPWR VPWR _01202_ sky130_fd_sc_hd__mux2_1
XTAP_TAPCELL_ROW_69_1441 VGND VPWR sky130_fd_sc_hd__tapvpwrvgnd_1
X_05703_ _02163_ _02279_ VGND VGND VPWR VPWR _02280_ sky130_fd_sc_hd__nor2_1
XFILLER_48_191 VGND VGND VPWR VPWR sky130_fd_sc_hd__decap_4
X_09471_ cpuregs\[24\]\[9\] _02621_ net242 VGND VGND VPWR VPWR _01135_ sky130_fd_sc_hd__mux2_1
XFILLER_37_865 VPWR VGND VPWR VGND sky130_ef_sc_hd__decap_12
X_08422_ _04159_ count_cycle\[60\] count_cycle\[59\] VGND VGND VPWR VPWR _04163_ sky130_fd_sc_hd__and3_1
XFILLER_91_470 VGND VGND VPWR VPWR sky130_fd_sc_hd__decap_3
X_06683_ net175 _03107_ net236 VGND VGND VPWR VPWR _00082_ sky130_fd_sc_hd__mux2_1
X_05634_ net215 net183 VGND VGND VPWR VPWR _02217_ sky130_fd_sc_hd__and2b_1
XTAP_TAPCELL_ROW_82_1641 VGND VPWR sky130_fd_sc_hd__tapvpwrvgnd_1
XFILLER_51_334 VGND VGND VPWR VPWR sky130_fd_sc_hd__fill_2
X_05565_ net177 net209 VGND VGND VPWR VPWR _02148_ sky130_fd_sc_hd__nor2_1
X_08353_ count_cycle\[34\] _04118_ net34 VGND VGND VPWR VPWR _04120_ sky130_fd_sc_hd__o21ai_1
X_07304_ cpuregs\[28\]\[22\] _02675_ net249 VGND VGND VPWR VPWR _00250_ sky130_fd_sc_hd__mux2_1
X_08284_ count_cycle\[10\] net451 _01549_ VGND VGND VPWR VPWR _04075_ sky130_fd_sc_hd__a21oi_1
X_07235_ cpuregs\[13\]\[19\] _02662_ net251 VGND VGND VPWR VPWR _00183_ sky130_fd_sc_hd__mux2_1
XFILLER_137_417 VGND VGND VPWR VPWR sky130_fd_sc_hd__decap_3
X_05496_ _02078_ VGND VGND VPWR VPWR _02079_ sky130_fd_sc_hd__inv_2
XFILLER_50_29 VPWR VGND VPWR VGND sky130_ef_sc_hd__decap_12
Xclkload7 clknet_4_9_0_clk VGND VGND VPWR VPWR clkload7/Y sky130_fd_sc_hd__clkinvlp_4
X_07166_ cpuregs\[12\]\[20\] _02665_ net253 VGND VGND VPWR VPWR _00120_ sky130_fd_sc_hd__mux2_1
XFILLER_117_152 VPWR VGND VPWR VGND sky130_ef_sc_hd__decap_12
XFILLER_132_111 VPWR VGND VPWR VGND sky130_ef_sc_hd__decap_12
XTAP_TAPCELL_ROW_113_2140 VGND VPWR sky130_fd_sc_hd__tapvpwrvgnd_1
X_07097_ _03503_ _03504_ _03505_ VGND VGND VPWR VPWR _03506_ sky130_fd_sc_hd__o21a_1
X_06117_ _02586_ cpuregs\[11\]\[0\] _02582_ VGND VGND VPWR VPWR _00037_ sky130_fd_sc_hd__mux2_1
X_06048_ cpuregs\[12\]\[2\] cpuregs\[13\]\[2\] cpuregs\[14\]\[2\] cpuregs\[15\]\[2\]
+ net279 _00008_ VGND VGND VPWR VPWR _02521_ sky130_fd_sc_hd__mux4_1
XFILLER_133_689 VGND VGND VPWR VPWR sky130_fd_sc_hd__fill_2
XFILLER_114_881 VPWR VGND VPWR VGND sky130_ef_sc_hd__decap_12
XFILLER_113_391 VGND VGND VPWR VPWR sky130_fd_sc_hd__fill_1
XFILLER_59_445 VGND VGND VPWR VPWR sky130_fd_sc_hd__decap_3
XFILLER_59_423 VPWR VGND VPWR VGND sky130_ef_sc_hd__decap_12
XFILLER_115_66 VGND VGND VPWR VPWR sky130_fd_sc_hd__decap_4
X_09807_ _02641_ cpuregs\[8\]\[14\] _04875_ VGND VGND VPWR VPWR _01460_ sky130_fd_sc_hd__mux2_1
X_07999_ _03801_ _03820_ VGND VGND VPWR VPWR _03821_ sky130_fd_sc_hd__or2_1
XFILLER_46_106 VGND VGND VPWR VPWR sky130_fd_sc_hd__fill_2
X_09738_ _02630_ cpuregs\[6\]\[11\] _04873_ VGND VGND VPWR VPWR _01393_ sky130_fd_sc_hd__mux2_1
XFILLER_46_139 VGND VGND VPWR VPWR sky130_fd_sc_hd__fill_1
XFILLER_74_459 VGND VGND VPWR VPWR sky130_fd_sc_hd__fill_2
XFILLER_55_673 VGND VGND VPWR VPWR sky130_fd_sc_hd__decap_6
X_09669_ cpuregs\[4\]\[8\] _02616_ net238 VGND VGND VPWR VPWR _01326_ sky130_fd_sc_hd__mux2_1
XFILLER_43_835 VGND VGND VPWR VPWR sky130_fd_sc_hd__decap_4
XFILLER_152_3 VPWR VGND VPWR VGND sky130_ef_sc_hd__decap_12
XFILLER_70_643 VGND VGND VPWR VPWR sky130_fd_sc_hd__fill_1
XFILLER_15_559 VGND VGND VPWR VPWR sky130_fd_sc_hd__fill_1
XFILLER_27_397 VGND VGND VPWR VPWR sky130_fd_sc_hd__fill_1
XFILLER_42_345 VGND VGND VPWR VPWR sky130_fd_sc_hd__fill_2
XFILLER_24_41 VPWR VGND VPWR VGND sky130_ef_sc_hd__decap_12
XPHY_EDGE_ROW_145_Right_145 VGND VGND VPWR VPWR sky130_fd_sc_hd__decap_3
XFILLER_23_570 VGND VGND VPWR VPWR sky130_fd_sc_hd__decap_4
X_10513_ clknet_leaf_81_clk _00643_ VGND VGND VPWR VPWR count_instr\[62\] sky130_fd_sc_hd__dfxtp_1
X_11493_ clknet_leaf_35_clk _01537_ VGND VGND VPWR VPWR cpuregs\[10\]\[27\] sky130_fd_sc_hd__dfxtp_1
X_10444_ clknet_leaf_46_clk _00574_ VGND VGND VPWR VPWR cpuregs\[17\]\[26\] sky130_fd_sc_hd__dfxtp_1
XFILLER_136_450 VGND VGND VPWR VPWR sky130_fd_sc_hd__decap_4
X_10375_ clknet_leaf_79_clk _00505_ VGND VGND VPWR VPWR cpuregs\[25\]\[21\] sky130_fd_sc_hd__dfxtp_1
XFILLER_108_174 VGND VGND VPWR VPWR sky130_fd_sc_hd__fill_1
XFILLER_151_442 VGND VGND VPWR VPWR sky130_fd_sc_hd__decap_6
XFILLER_123_122 VGND VGND VPWR VPWR sky130_fd_sc_hd__fill_1
XFILLER_78_798 VGND VGND VPWR VPWR sky130_fd_sc_hd__decap_6
XTAP_TAPCELL_ROW_144_2634 VGND VPWR sky130_fd_sc_hd__tapvpwrvgnd_1
XFILLER_19_821 VPWR VGND VPWR VGND sky130_ef_sc_hd__decap_12
XFILLER_19_865 VPWR VGND VPWR VGND sky130_ef_sc_hd__decap_12
XFILLER_46_662 VGND VGND VPWR VPWR sky130_fd_sc_hd__decap_6
XFILLER_80_429 VGND VGND VPWR VPWR sky130_fd_sc_hd__decap_3
XFILLER_34_813 VPWR VGND VPWR VGND sky130_ef_sc_hd__decap_12
XFILLER_61_632 VGND VGND VPWR VPWR sky130_fd_sc_hd__decap_3
XTAP_TAPCELL_ROW_64_1360 VGND VPWR sky130_fd_sc_hd__tapvpwrvgnd_1
XTAP_TAPCELL_ROW_47_1079 VGND VPWR sky130_fd_sc_hd__tapvpwrvgnd_1
X_05350_ reg_pc\[23\] decoded_imm\[23\] VGND VGND VPWR VPWR _01942_ sky130_fd_sc_hd__or2_1
XFILLER_60_197 VPWR VGND VPWR VGND sky130_ef_sc_hd__decap_12
XTAP_TAPCELL_ROW_16_587 VGND VPWR sky130_fd_sc_hd__tapvpwrvgnd_1
XPHY_EDGE_ROW_112_Right_112 VGND VGND VPWR VPWR sky130_fd_sc_hd__decap_3
Xclkload113 clknet_leaf_63_clk VGND VGND VPWR VPWR clkload113/Y sky130_fd_sc_hd__clkinv_2
X_05281_ _01869_ _01876_ _01878_ VGND VGND VPWR VPWR _01879_ sky130_fd_sc_hd__a21oi_1
Xclkload102 clknet_leaf_101_clk VGND VGND VPWR VPWR clkload102/Y sky130_fd_sc_hd__clkinv_4
X_07020_ cpuregs\[20\]\[26\] cpuregs\[21\]\[26\] cpuregs\[22\]\[26\] cpuregs\[23\]\[26\]
+ net266 net261 VGND VGND VPWR VPWR _03432_ sky130_fd_sc_hd__mux4_1
Xclkload135 clknet_leaf_75_clk VGND VGND VPWR VPWR clkload135/X sky130_fd_sc_hd__clkbuf_8
Xclkload124 clknet_leaf_73_clk VGND VGND VPWR VPWR clkload124/Y sky130_fd_sc_hd__inv_6
XFILLER_115_612 VGND VGND VPWR VPWR sky130_fd_sc_hd__fill_1
XPHY_EDGE_ROW_49_Right_49 VGND VGND VPWR VPWR sky130_fd_sc_hd__decap_3
XFILLER_142_453 VGND VGND VPWR VPWR sky130_fd_sc_hd__decap_6
XFILLER_114_122 VGND VGND VPWR VPWR sky130_fd_sc_hd__fill_1
XFILLER_142_475 VGND VGND VPWR VPWR sky130_fd_sc_hd__fill_1
X_08971_ net221 _01585_ _04645_ _04646_ VGND VGND VPWR VPWR _00832_ sky130_fd_sc_hd__o22a_1
XFILLER_130_637 VGND VGND VPWR VPWR sky130_fd_sc_hd__decap_6
X_07922_ _03749_ _03750_ net34 VGND VGND VPWR VPWR _00679_ sky130_fd_sc_hd__o21a_1
XFILLER_96_573 VGND VGND VPWR VPWR sky130_fd_sc_hd__fill_1
X_07853_ _02642_ reg_next_pc\[15\] _02482_ VGND VGND VPWR VPWR _03702_ sky130_fd_sc_hd__mux2_2
X_06804_ _01579_ _03223_ VGND VGND VPWR VPWR _03224_ sky130_fd_sc_hd__or2_1
XFILLER_83_223 VGND VGND VPWR VPWR sky130_fd_sc_hd__fill_1
XFILLER_56_437 VGND VGND VPWR VPWR sky130_fd_sc_hd__decap_8
X_07784_ count_instr\[48\] net586 count_instr\[49\] VGND VGND VPWR VPWR _03662_ sky130_fd_sc_hd__a21o_1
XPHY_EDGE_ROW_58_Right_58 VGND VGND VPWR VPWR sky130_fd_sc_hd__decap_3
X_04996_ net387 _01549_ VGND VGND VPWR VPWR _01624_ sky130_fd_sc_hd__nor2_8
X_09523_ cpuregs\[31\]\[28\] _02699_ net240 VGND VGND VPWR VPWR _01186_ sky130_fd_sc_hd__mux2_1
X_06735_ decoded_imm\[16\] net178 VGND VGND VPWR VPWR _03157_ sky130_fd_sc_hd__xnor2_1
XFILLER_24_301 VGND VGND VPWR VPWR sky130_fd_sc_hd__decap_6
XFILLER_37_673 VPWR VGND VPWR VGND sky130_ef_sc_hd__decap_12
X_09454_ _02688_ cpuregs\[19\]\[25\] _04863_ VGND VGND VPWR VPWR _01087_ sky130_fd_sc_hd__mux2_1
X_06666_ _01641_ _03013_ _03090_ _03089_ VGND VGND VPWR VPWR _03091_ sky130_fd_sc_hd__a31o_1
XFILLER_101_57 VGND VGND VPWR VPWR sky130_fd_sc_hd__fill_2
X_08405_ count_cycle\[53\] _04149_ count_cycle\[54\] VGND VGND VPWR VPWR _04152_ sky130_fd_sc_hd__a21o_1
X_05617_ _02146_ _02198_ VGND VGND VPWR VPWR _02200_ sky130_fd_sc_hd__nand2b_1
XFILLER_12_518 VPWR VGND VPWR VGND sky130_ef_sc_hd__decap_12
X_09385_ decoded_imm\[4\] _04746_ _04854_ _04855_ VGND VGND VPWR VPWR _01026_ sky130_fd_sc_hd__o22a_1
X_08336_ _04104_ count_cycle\[27\] count_cycle\[28\] count_cycle\[26\] VGND VGND VPWR
+ VPWR _04109_ sky130_fd_sc_hd__and4_1
X_06597_ _03019_ _03020_ _03023_ _03024_ _01579_ _01581_ VGND VGND VPWR VPWR _03025_
+ sky130_fd_sc_hd__mux4_1
XPHY_EDGE_ROW_49_Left_203 VGND VGND VPWR VPWR sky130_fd_sc_hd__decap_3
XTAP_TAPCELL_ROW_35_885 VGND VPWR sky130_fd_sc_hd__tapvpwrvgnd_1
XTAP_TAPCELL_ROW_35_896 VGND VPWR sky130_fd_sc_hd__tapvpwrvgnd_1
XFILLER_138_737 VGND VGND VPWR VPWR sky130_fd_sc_hd__decap_4
X_05548_ net201 net233 VGND VGND VPWR VPWR _02131_ sky130_fd_sc_hd__and2_1
X_05479_ net190 net222 VGND VGND VPWR VPWR _02062_ sky130_fd_sc_hd__and2_1
Xclkbuf_leaf_140_clk clknet_4_2_0_clk VGND VGND VPWR VPWR clknet_leaf_140_clk sky130_fd_sc_hd__clkbuf_8
X_08267_ net401 _04064_ VGND VGND VPWR VPWR _00710_ sky130_fd_sc_hd__nor2_1
XFILLER_153_729 VGND VGND VPWR VPWR sky130_fd_sc_hd__fill_2
X_08198_ _01547_ reg_next_pc\[26\] _01645_ _03713_ VGND VGND VPWR VPWR _04005_ sky130_fd_sc_hd__a22o_1
XPHY_EDGE_ROW_67_Right_67 VGND VGND VPWR VPWR sky130_fd_sc_hd__decap_3
X_07218_ cpuregs\[13\]\[2\] _02590_ net251 VGND VGND VPWR VPWR _00166_ sky130_fd_sc_hd__mux2_1
XFILLER_118_461 VPWR VGND VPWR VGND sky130_ef_sc_hd__decap_12
XTAP_TAPCELL_ROW_95_1854 VGND VPWR sky130_fd_sc_hd__tapvpwrvgnd_1
XFILLER_3_205 VPWR VGND VPWR VGND sky130_ef_sc_hd__decap_12
X_07149_ cpuregs\[12\]\[3\] _02593_ net253 VGND VGND VPWR VPWR _00103_ sky130_fd_sc_hd__mux2_1
XFILLER_3_249 VPWR VGND VPWR VGND sky130_ef_sc_hd__decap_12
XFILLER_105_166 VGND VGND VPWR VPWR sky130_fd_sc_hd__fill_2
X_10160_ clknet_leaf_33_clk _00290_ VGND VGND VPWR VPWR cpuregs\[21\]\[30\] sky130_fd_sc_hd__dfxtp_1
XPHY_EDGE_ROW_58_Left_212 VGND VGND VPWR VPWR sky130_fd_sc_hd__decap_3
XFILLER_10_65 VPWR VGND VPWR VGND sky130_ef_sc_hd__decap_12
X_10091_ clknet_leaf_47_clk _00221_ VGND VGND VPWR VPWR cpuregs\[2\]\[25\] sky130_fd_sc_hd__dfxtp_1
XFILLER_126_76 VGND VGND VPWR VPWR sky130_fd_sc_hd__decap_8
XFILLER_75_713 VPWR VGND VPWR VGND sky130_ef_sc_hd__decap_12
XTAP_TAPCELL_ROW_126_2342 VGND VPWR sky130_fd_sc_hd__tapvpwrvgnd_1
XFILLER_87_584 VGND VGND VPWR VPWR sky130_fd_sc_hd__decap_6
XPHY_EDGE_ROW_76_Right_76 VGND VGND VPWR VPWR sky130_fd_sc_hd__decap_3
XFILLER_75_746 VGND VGND VPWR VPWR sky130_fd_sc_hd__fill_2
XFILLER_74_212 VGND VGND VPWR VPWR sky130_fd_sc_hd__decap_4
XFILLER_142_53 VPWR VGND VPWR VGND sky130_ef_sc_hd__decap_12
XTAP_TAPCELL_ROW_126_2353 VGND VPWR sky130_fd_sc_hd__tapvpwrvgnd_1
XFILLER_28_640 VGND VGND VPWR VPWR sky130_fd_sc_hd__decap_4
X_10993_ clknet_leaf_47_clk _01055_ VGND VGND VPWR VPWR cpuregs\[18\]\[25\] sky130_fd_sc_hd__dfxtp_1
XFILLER_16_813 VPWR VGND VPWR VGND sky130_ef_sc_hd__decap_12
XFILLER_28_662 VGND VGND VPWR VPWR sky130_fd_sc_hd__decap_8
XFILLER_35_51 VGND VGND VPWR VPWR sky130_fd_sc_hd__decap_4
XPHY_EDGE_ROW_67_Left_221 VGND VGND VPWR VPWR sky130_fd_sc_hd__decap_3
XFILLER_15_356 VGND VGND VPWR VPWR sky130_fd_sc_hd__decap_3
XTAP_TAPCELL_ROW_104_1994 VGND VPWR sky130_fd_sc_hd__tapvpwrvgnd_1
XFILLER_30_315 VGND VGND VPWR VPWR sky130_fd_sc_hd__fill_1
XFILLER_42_186 VGND VGND VPWR VPWR sky130_fd_sc_hd__fill_2
XFILLER_42_197 VGND VGND VPWR VPWR sky130_fd_sc_hd__decap_3
XFILLER_11_551 VGND VGND VPWR VPWR sky130_fd_sc_hd__decap_8
XTAP_TAPCELL_ROW_13_535 VGND VPWR sky130_fd_sc_hd__tapvpwrvgnd_1
XTAP_TAPCELL_ROW_13_546 VGND VPWR sky130_fd_sc_hd__tapvpwrvgnd_1
XFILLER_129_759 VPWR VGND VPWR VGND sky130_ef_sc_hd__decap_12
XPHY_EDGE_ROW_85_Right_85 VGND VGND VPWR VPWR sky130_fd_sc_hd__decap_3
Xclkbuf_leaf_131_clk clknet_4_9_0_clk VGND VGND VPWR VPWR clknet_leaf_131_clk sky130_fd_sc_hd__clkbuf_8
X_11476_ clknet_leaf_12_clk _01520_ VGND VGND VPWR VPWR cpuregs\[10\]\[10\] sky130_fd_sc_hd__dfxtp_1
XFILLER_7_577 VGND VGND VPWR VPWR sky130_fd_sc_hd__decap_8
X_10427_ clknet_leaf_151_clk _00557_ VGND VGND VPWR VPWR cpuregs\[17\]\[9\] sky130_fd_sc_hd__dfxtp_1
XPHY_EDGE_ROW_76_Left_230 VGND VGND VPWR VPWR sky130_fd_sc_hd__decap_3
XFILLER_151_261 VPWR VGND VPWR VGND sky130_ef_sc_hd__decap_12
XFILLER_98_838 VPWR VGND VPWR VGND sky130_ef_sc_hd__decap_12
XFILLER_97_315 VGND VGND VPWR VPWR sky130_fd_sc_hd__fill_2
X_10358_ clknet_leaf_139_clk _00488_ VGND VGND VPWR VPWR cpuregs\[25\]\[4\] sky130_fd_sc_hd__dfxtp_1
XFILLER_97_337 VGND VGND VPWR VPWR sky130_fd_sc_hd__fill_2
X_10289_ clknet_leaf_14_clk _00419_ VGND VGND VPWR VPWR cpuregs\[15\]\[31\] sky130_fd_sc_hd__dfxtp_1
XFILLER_3_783 VGND VGND VPWR VPWR sky130_fd_sc_hd__fill_1
XFILLER_111_169 VPWR VGND VPWR VGND sky130_ef_sc_hd__decap_12
XPHY_EDGE_ROW_94_Right_94 VGND VGND VPWR VPWR sky130_fd_sc_hd__decap_3
XFILLER_93_532 VPWR VGND VPWR VGND sky130_ef_sc_hd__decap_12
XFILLER_38_437 VPWR VGND VPWR VGND sky130_ef_sc_hd__decap_12
XFILLER_93_565 VGND VGND VPWR VPWR sky130_fd_sc_hd__fill_1
XFILLER_66_757 VGND VGND VPWR VPWR sky130_fd_sc_hd__fill_1
XTAP_TAPCELL_ROW_49_1108 VGND VPWR sky130_fd_sc_hd__tapvpwrvgnd_1
XFILLER_81_727 VGND VGND VPWR VPWR sky130_fd_sc_hd__fill_1
XTAP_TAPCELL_ROW_49_1119 VGND VPWR sky130_fd_sc_hd__tapvpwrvgnd_1
XFILLER_25_109 VGND VGND VPWR VPWR sky130_fd_sc_hd__decap_3
XFILLER_46_470 VGND VGND VPWR VPWR sky130_fd_sc_hd__decap_6
X_06520_ decoded_imm\[8\] net201 VGND VGND VPWR VPWR _02950_ sky130_fd_sc_hd__nor2_1
XTAP_TAPCELL_ROW_62_1319 VGND VPWR sky130_fd_sc_hd__tapvpwrvgnd_1
X_06451_ cpuregs\[28\]\[5\] cpuregs\[29\]\[5\] cpuregs\[30\]\[5\] cpuregs\[31\]\[5\]
+ net268 net262 VGND VGND VPWR VPWR _02884_ sky130_fd_sc_hd__mux4_1
X_05402_ cpu_state\[3\] _01983_ _01984_ _01990_ VGND VGND VPWR VPWR _04896_ sky130_fd_sc_hd__a31o_1
XFILLER_21_337 VGND VGND VPWR VPWR sky130_fd_sc_hd__decap_4
XFILLER_22_849 VPWR VGND VPWR VGND sky130_ef_sc_hd__decap_12
X_09170_ mem_rdata_q\[23\] mem_rdata_q\[22\] mem_rdata_q\[20\] mem_rdata_q\[21\] VGND
+ VGND VPWR VPWR _04786_ sky130_fd_sc_hd__or4b_1
X_06382_ cpuregs\[22\]\[3\] cpuregs\[23\]\[3\] net268 VGND VGND VPWR VPWR _02817_
+ sky130_fd_sc_hd__mux2_1
XTAP_TAPCELL_ROW_32_844 VGND VPWR sky130_fd_sc_hd__tapvpwrvgnd_1
XFILLER_119_225 VPWR VGND VPWR VGND sky130_ef_sc_hd__decap_12
X_08121_ _03705_ _03706_ _03902_ _03707_ VGND VGND VPWR VPWR _03934_ sky130_fd_sc_hd__a31o_1
X_05333_ net14 _01665_ _01856_ VGND VGND VPWR VPWR _01927_ sky130_fd_sc_hd__a21o_1
Xclkbuf_leaf_122_clk clknet_4_8_0_clk VGND VGND VPWR VPWR clknet_leaf_122_clk sky130_fd_sc_hd__clkbuf_8
XFILLER_30_893 VPWR VGND VPWR VGND sky130_ef_sc_hd__decap_12
X_05264_ count_cycle\[15\] _01588_ net256 _01863_ VGND VGND VPWR VPWR _01864_ sky130_fd_sc_hd__o211a_1
X_08052_ _03843_ _03856_ VGND VGND VPWR VPWR _03870_ sky130_fd_sc_hd__nand2_1
X_07003_ _03407_ _03408_ _03414_ _03415_ _01579_ _01581_ VGND VGND VPWR VPWR _03416_
+ sky130_fd_sc_hd__mux4_1
XFILLER_135_729 VPWR VGND VPWR VGND sky130_ef_sc_hd__decap_12
XTAP_TAPCELL_ROW_77_1562 VGND VPWR sky130_fd_sc_hd__tapvpwrvgnd_1
X_05195_ reg_pc\[11\] decoded_imm\[11\] VGND VGND VPWR VPWR _01799_ sky130_fd_sc_hd__or2_1
XFILLER_1_709 VPWR VGND VPWR VGND sky130_ef_sc_hd__decap_12
Xpicorv32_286 VGND VGND VPWR VPWR picorv32_286/HI eoi[5] sky130_fd_sc_hd__conb_1
XFILLER_142_261 VGND VGND VPWR VPWR sky130_fd_sc_hd__decap_3
XFILLER_142_250 VGND VGND VPWR VPWR sky130_fd_sc_hd__fill_2
XFILLER_115_475 VGND VGND VPWR VPWR sky130_fd_sc_hd__decap_8
XFILLER_89_849 VGND VGND VPWR VPWR sky130_fd_sc_hd__decap_3
Xpicorv32_297 VGND VGND VPWR VPWR picorv32_297/HI eoi[16] sky130_fd_sc_hd__conb_1
X_08954_ cpuregs\[28\]\[26\] cpuregs\[29\]\[26\] cpuregs\[30\]\[26\] cpuregs\[31\]\[26\]
+ net277 net272 VGND VGND VPWR VPWR _04630_ sky130_fd_sc_hd__mux4_1
XFILLER_88_359 VGND VGND VPWR VPWR sky130_fd_sc_hd__decap_4
XTAP_TAPCELL_ROW_90_1773 VGND VPWR sky130_fd_sc_hd__tapvpwrvgnd_1
X_07905_ _03734_ VGND VGND VPWR VPWR _03735_ sky130_fd_sc_hd__inv_2
X_08885_ cpuregs\[0\]\[22\] cpuregs\[1\]\[22\] cpuregs\[2\]\[22\] cpuregs\[3\]\[22\]
+ net280 net272 VGND VGND VPWR VPWR _04565_ sky130_fd_sc_hd__mux4_1
XFILLER_130_489 VGND VGND VPWR VPWR sky130_fd_sc_hd__decap_3
XFILLER_111_670 VGND VGND VPWR VPWR sky130_fd_sc_hd__fill_2
XFILLER_57_746 VGND VGND VPWR VPWR sky130_fd_sc_hd__decap_4
XFILLER_29_426 VGND VGND VPWR VPWR sky130_fd_sc_hd__fill_1
XTAP_TAPCELL_ROW_108_2061 VGND VPWR sky130_fd_sc_hd__tapvpwrvgnd_1
XFILLER_57_768 VPWR VGND VPWR VGND sky130_ef_sc_hd__decap_12
X_07836_ reg_pc\[6\] _01624_ _01628_ _03693_ VGND VGND VPWR VPWR _00650_ sky130_fd_sc_hd__a22o_1
XFILLER_112_23 VGND VGND VPWR VPWR sky130_fd_sc_hd__decap_4
X_07767_ count_instr\[42\] _03649_ _03651_ VGND VGND VPWR VPWR _00623_ sky130_fd_sc_hd__o21a_1
X_04979_ _01585_ _01603_ _01607_ _00580_ VGND VGND VPWR VPWR _00017_ sky130_fd_sc_hd__a211o_1
X_06718_ cpuregs\[16\]\[15\] cpuregs\[17\]\[15\] cpuregs\[18\]\[15\] cpuregs\[19\]\[15\]
+ net265 net260 VGND VGND VPWR VPWR _03141_ sky130_fd_sc_hd__mux4_1
X_09506_ cpuregs\[31\]\[11\] _02630_ net240 VGND VGND VPWR VPWR _01169_ sky130_fd_sc_hd__mux2_1
XFILLER_37_481 VGND VGND VPWR VPWR sky130_fd_sc_hd__decap_3
XTAP_TAPCELL_ROW_121_2272 VGND VPWR sky130_fd_sc_hd__tapvpwrvgnd_1
XTAP_TAPCELL_ROW_121_2261 VGND VPWR sky130_fd_sc_hd__tapvpwrvgnd_1
X_07698_ count_instr\[17\] _03605_ _03607_ VGND VGND VPWR VPWR _00598_ sky130_fd_sc_hd__o21a_1
XFILLER_72_49 VGND VGND VPWR VPWR sky130_fd_sc_hd__decap_3
X_06649_ _03066_ _03067_ _03070_ _03071_ _01579_ _00016_ VGND VGND VPWR VPWR _03075_
+ sky130_fd_sc_hd__mux4_1
XFILLER_9_809 VPWR VGND VPWR VGND sky130_ef_sc_hd__decap_12
X_09437_ _02616_ cpuregs\[19\]\[8\] _04863_ VGND VGND VPWR VPWR _01070_ sky130_fd_sc_hd__mux2_1
X_09368_ is_sb_sh_sw _04791_ mem_rdata_q\[31\] VGND VGND VPWR VPWR _04846_ sky130_fd_sc_hd__o21a_1
XFILLER_12_337 VGND VGND VPWR VPWR sky130_fd_sc_hd__decap_8
XFILLER_138_512 VGND VGND VPWR VPWR sky130_fd_sc_hd__decap_8
X_08319_ _04092_ count_cycle\[21\] count_cycle\[22\] count_cycle\[20\] VGND VGND VPWR
+ VPWR _04098_ sky130_fd_sc_hd__and4_1
X_09299_ net156 net118 _04206_ VGND VGND VPWR VPWR _00985_ sky130_fd_sc_hd__mux2_1
Xclkbuf_leaf_113_clk clknet_4_10_0_clk VGND VGND VPWR VPWR clknet_leaf_113_clk sky130_fd_sc_hd__clkbuf_8
X_11330_ clknet_leaf_35_clk _01377_ VGND VGND VPWR VPWR cpuregs\[5\]\[27\] sky130_fd_sc_hd__dfxtp_1
X_11261_ clknet_leaf_46_clk _01308_ VGND VGND VPWR VPWR cpuregs\[22\]\[22\] sky130_fd_sc_hd__dfxtp_1
XFILLER_137_97 VPWR VGND VPWR VGND sky130_ef_sc_hd__decap_12
XFILLER_133_250 VPWR VGND VPWR VGND sky130_ef_sc_hd__decap_12
XFILLER_106_464 VPWR VGND VPWR VGND sky130_ef_sc_hd__decap_12
X_10212_ clknet_leaf_54_clk _00342_ VGND VGND VPWR VPWR cpuregs\[14\]\[18\] sky130_fd_sc_hd__dfxtp_1
XFILLER_97_35 VPWR VGND VPWR VGND sky130_ef_sc_hd__decap_12
X_11192_ clknet_leaf_22_clk _01239_ VGND VGND VPWR VPWR cpuregs\[29\]\[17\] sky130_fd_sc_hd__dfxtp_1
XFILLER_4_569 VPWR VGND VPWR VGND sky130_ef_sc_hd__decap_12
XFILLER_97_57 VGND VGND VPWR VPWR sky130_fd_sc_hd__decap_4
XFILLER_79_337 VGND VGND VPWR VPWR sky130_fd_sc_hd__decap_6
X_10143_ clknet_leaf_10_clk _00273_ VGND VGND VPWR VPWR cpuregs\[21\]\[13\] sky130_fd_sc_hd__dfxtp_1
XFILLER_0_720 VGND VGND VPWR VPWR sky130_fd_sc_hd__decap_8
XFILLER_153_41 VPWR VGND VPWR VGND sky130_ef_sc_hd__decap_12
XFILLER_153_85 VPWR VGND VPWR VGND sky130_ef_sc_hd__decap_12
XFILLER_87_370 VGND VGND VPWR VPWR sky130_fd_sc_hd__decap_6
XFILLER_0_797 VGND VGND VPWR VPWR sky130_fd_sc_hd__decap_4
X_10074_ clknet_leaf_146_clk _00204_ VGND VGND VPWR VPWR cpuregs\[2\]\[8\] sky130_fd_sc_hd__dfxtp_1
XFILLER_47_234 VGND VGND VPWR VPWR sky130_fd_sc_hd__decap_3
XTAP_TAPCELL_ROW_18_616 VGND VPWR sky130_fd_sc_hd__tapvpwrvgnd_1
XFILLER_90_546 VGND VGND VPWR VPWR sky130_fd_sc_hd__fill_1
XTAP_TAPCELL_ROW_18_627 VGND VPWR sky130_fd_sc_hd__tapvpwrvgnd_1
XFILLER_46_83 VGND VGND VPWR VPWR sky130_fd_sc_hd__fill_1
X_10976_ clknet_leaf_1_clk _01038_ VGND VGND VPWR VPWR cpuregs\[18\]\[8\] sky130_fd_sc_hd__dfxtp_1
XFILLER_43_462 VGND VGND VPWR VPWR sky130_fd_sc_hd__decap_8
XTAP_TAPCELL_ROW_44_1038 VGND VPWR sky130_fd_sc_hd__tapvpwrvgnd_1
XTAP_TAPCELL_ROW_139_2555 VGND VPWR sky130_fd_sc_hd__tapvpwrvgnd_1
Xclkbuf_leaf_104_clk clknet_4_11_0_clk VGND VGND VPWR VPWR clknet_leaf_104_clk sky130_fd_sc_hd__clkbuf_8
Xwire250 _03559_ VGND VGND VPWR VPWR net250 sky130_fd_sc_hd__buf_12
XFILLER_7_55 VGND VGND VPWR VPWR sky130_fd_sc_hd__fill_1
XFILLER_12_893 VPWR VGND VPWR VGND sky130_ef_sc_hd__decap_12
XTAP_TAPCELL_ROW_152_2766 VGND VPWR sky130_fd_sc_hd__tapvpwrvgnd_1
XFILLER_129_589 VGND VGND VPWR VPWR sky130_fd_sc_hd__decap_8
XFILLER_117_729 VGND VGND VPWR VPWR sky130_fd_sc_hd__decap_4
XFILLER_116_206 VPWR VGND VPWR VGND sky130_ef_sc_hd__decap_12
X_11459_ clknet_leaf_47_clk _01503_ VGND VGND VPWR VPWR cpuregs\[0\]\[25\] sky130_fd_sc_hd__dfxtp_1
XFILLER_144_548 VPWR VGND VPWR VGND sky130_ef_sc_hd__decap_12
XTAP_TAPCELL_ROW_59_1281 VGND VPWR sky130_fd_sc_hd__tapvpwrvgnd_1
XTAP_TAPCELL_ROW_59_1270 VGND VPWR sky130_fd_sc_hd__tapvpwrvgnd_1
XFILLER_97_167 VGND VGND VPWR VPWR sky130_fd_sc_hd__fill_1
XFILLER_30_3 VPWR VGND VPWR VGND sky130_ef_sc_hd__decap_12
X_05951_ net220 _01665_ _02475_ VGND VGND VPWR VPWR net114 sky130_fd_sc_hd__a21o_1
XFILLER_79_882 VGND VGND VPWR VPWR sky130_fd_sc_hd__fill_1
XTAP_TAPCELL_ROW_72_1481 VGND VPWR sky130_fd_sc_hd__tapvpwrvgnd_1
X_05882_ _02063_ _02240_ _02237_ VGND VGND VPWR VPWR _02438_ sky130_fd_sc_hd__a21oi_1
X_08670_ cpuregs\[8\]\[10\] cpuregs\[9\]\[10\] cpuregs\[10\]\[10\] cpuregs\[11\]\[10\]
+ net277 net271 VGND VGND VPWR VPWR _04362_ sky130_fd_sc_hd__mux4_1
XFILLER_66_587 VGND VGND VPWR VPWR sky130_fd_sc_hd__fill_1
XFILLER_66_565 VGND VGND VPWR VPWR sky130_fd_sc_hd__decap_8
X_07621_ _02603_ cpuregs\[17\]\[5\] _03574_ VGND VGND VPWR VPWR _00553_ sky130_fd_sc_hd__mux2_1
XTAP_TAPCELL_ROW_37_925 VGND VPWR sky130_fd_sc_hd__tapvpwrvgnd_1
X_07552_ cpuregs\[25\]\[3\] _02593_ _03571_ VGND VGND VPWR VPWR _00487_ sky130_fd_sc_hd__mux2_1
X_06503_ cpuregs\[16\]\[7\] cpuregs\[17\]\[7\] cpuregs\[18\]\[7\] cpuregs\[19\]\[7\]
+ net268 net259 VGND VGND VPWR VPWR _02934_ sky130_fd_sc_hd__mux4_1
X_07483_ cpuregs\[26\]\[1\] _02588_ _03568_ VGND VGND VPWR VPWR _00421_ sky130_fd_sc_hd__mux2_1
XFILLER_34_473 VGND VGND VPWR VPWR sky130_fd_sc_hd__decap_3
X_09222_ cpuregs\[1\]\[1\] _02588_ net244 VGND VGND VPWR VPWR _00919_ sky130_fd_sc_hd__mux2_1
XFILLER_22_668 VPWR VGND VPWR VGND sky130_ef_sc_hd__decap_12
X_06434_ net171 _02721_ _02744_ _02867_ VGND VGND VPWR VPWR _02868_ sky130_fd_sc_hd__o211a_1
XTAP_TAPCELL_ROW_79_1602 VGND VPWR sky130_fd_sc_hd__tapvpwrvgnd_1
X_09153_ instr_sra _04748_ _04755_ _04774_ VGND VGND VPWR VPWR _00877_ sky130_fd_sc_hd__a22o_1
X_06365_ reg_pc\[2\] _02714_ _02751_ _02799_ _02800_ VGND VGND VPWR VPWR _02801_ sky130_fd_sc_hd__a32o_1
X_05316_ _01886_ _01899_ _01887_ VGND VGND VPWR VPWR _01911_ sky130_fd_sc_hd__or3b_1
X_08104_ decoded_imm_j\[19\] _03706_ VGND VGND VPWR VPWR _03918_ sky130_fd_sc_hd__nor2_1
XFILLER_135_537 VGND VGND VPWR VPWR sky130_fd_sc_hd__decap_4
XFILLER_135_526 VGND VGND VPWR VPWR sky130_fd_sc_hd__decap_3
XFILLER_107_217 VGND VGND VPWR VPWR sky130_fd_sc_hd__fill_1
X_06296_ decoded_imm_j\[18\] decoded_imm_j\[17\] decoded_imm_j\[16\] decoded_imm_j\[15\]
+ VGND VGND VPWR VPWR _02734_ sky130_fd_sc_hd__or4_1
X_09084_ _01100_ _01098_ _02513_ VGND VGND VPWR VPWR _04742_ sky130_fd_sc_hd__and3b_1
XTAP_TAPCELL_ROW_92_1802 VGND VPWR sky130_fd_sc_hd__tapvpwrvgnd_1
X_05247_ count_instr\[14\] instr_rdinstr count_cycle\[46\] instr_rdcycleh VGND VGND
+ VPWR VPWR _01848_ sky130_fd_sc_hd__a22o_1
X_08035_ _03575_ _03853_ _03854_ VGND VGND VPWR VPWR _03855_ sky130_fd_sc_hd__a21o_1
X_05178_ net32 _01666_ _01667_ net18 _01772_ VGND VGND VPWR VPWR _01784_ sky130_fd_sc_hd__o221a_1
XFILLER_115_261 VGND VGND VPWR VPWR sky130_fd_sc_hd__decap_8
XFILLER_103_423 VGND VGND VPWR VPWR sky130_fd_sc_hd__decap_8
XFILLER_130_253 VGND VGND VPWR VPWR sky130_fd_sc_hd__decap_8
X_09986_ clknet_leaf_19_clk _00116_ VGND VGND VPWR VPWR cpuregs\[12\]\[16\] sky130_fd_sc_hd__dfxtp_1
XFILLER_76_307 VGND VGND VPWR VPWR sky130_fd_sc_hd__fill_1
X_08937_ cpuregs\[16\]\[25\] cpuregs\[17\]\[25\] cpuregs\[18\]\[25\] cpuregs\[19\]\[25\]
+ net280 net274 VGND VGND VPWR VPWR _04614_ sky130_fd_sc_hd__mux4_1
XFILLER_130_286 VGND VGND VPWR VPWR sky130_fd_sc_hd__decap_4
XFILLER_67_49 VGND VGND VPWR VPWR sky130_fd_sc_hd__decap_6
XFILLER_29_201 VGND VGND VPWR VPWR sky130_fd_sc_hd__fill_2
X_08868_ cpuregs\[12\]\[21\] cpuregs\[13\]\[21\] cpuregs\[14\]\[21\] cpuregs\[15\]\[21\]
+ _00007_ net274 VGND VGND VPWR VPWR _04549_ sky130_fd_sc_hd__mux4_1
XFILLER_85_841 VGND VGND VPWR VPWR sky130_fd_sc_hd__decap_8
XFILLER_57_543 VGND VGND VPWR VPWR sky130_fd_sc_hd__fill_1
XTAP_TAPCELL_ROW_123_2301 VGND VPWR sky130_fd_sc_hd__tapvpwrvgnd_1
XFILLER_123_55 VGND VGND VPWR VPWR sky130_fd_sc_hd__fill_1
X_07819_ _03679_ count_instr\[61\] count_instr\[60\] count_instr\[62\] VGND VGND VPWR
+ VPWR _03684_ sky130_fd_sc_hd__and4_1
XTAP_TAPCELL_ROW_4_399 VGND VPWR sky130_fd_sc_hd__tapvpwrvgnd_1
XTAP_TAPCELL_ROW_4_388 VGND VPWR sky130_fd_sc_hd__tapvpwrvgnd_1
X_08799_ cpuregs\[16\]\[17\] cpuregs\[17\]\[17\] cpuregs\[18\]\[17\] cpuregs\[19\]\[17\]
+ net277 net272 VGND VGND VPWR VPWR _04484_ sky130_fd_sc_hd__mux4_1
XFILLER_38_790 VPWR VGND VPWR VGND sky130_ef_sc_hd__decap_12
X_10830_ clknet_leaf_93_clk _00895_ VGND VGND VPWR VPWR decoded_imm_j\[14\] sky130_fd_sc_hd__dfxtp_1
XFILLER_60_708 VGND VGND VPWR VPWR sky130_fd_sc_hd__decap_4
XFILLER_16_53 VPWR VGND VPWR VGND sky130_ef_sc_hd__decap_12
X_10761_ clknet_leaf_59_clk alu_out\[14\] VGND VGND VPWR VPWR alu_out_q\[14\] sky130_fd_sc_hd__dfxtp_1
XFILLER_52_270 VGND VGND VPWR VPWR sky130_fd_sc_hd__decap_8
XFILLER_13_635 VGND VGND VPWR VPWR sky130_fd_sc_hd__fill_2
X_10692_ clknet_leaf_82_clk _00790_ VGND VGND VPWR VPWR net45 sky130_fd_sc_hd__dfxtp_1
XTAP_TAPCELL_ROW_101_1942 VGND VPWR sky130_fd_sc_hd__tapvpwrvgnd_1
XFILLER_9_617 VPWR VGND VPWR VGND sky130_ef_sc_hd__decap_12
XFILLER_16_97 VGND VGND VPWR VPWR sky130_fd_sc_hd__fill_2
XFILLER_139_821 VPWR VGND VPWR VGND sky130_ef_sc_hd__decap_12
XTAP_TAPCELL_ROW_101_1953 VGND VPWR sky130_fd_sc_hd__tapvpwrvgnd_1
XFILLER_40_465 VGND VGND VPWR VPWR sky130_fd_sc_hd__decap_8
XFILLER_148_41 VPWR VGND VPWR VGND sky130_ef_sc_hd__decap_12
XFILLER_139_865 VPWR VGND VPWR VGND sky130_ef_sc_hd__decap_12
XTAP_TAPCELL_ROW_23_696 VGND VPWR sky130_fd_sc_hd__tapvpwrvgnd_1
XFILLER_32_41 VPWR VGND VPWR VGND sky130_ef_sc_hd__decap_12
XFILLER_32_85 VGND VGND VPWR VPWR sky130_fd_sc_hd__decap_4
XFILLER_148_85 VPWR VGND VPWR VGND sky130_ef_sc_hd__decap_12
XTAP_TAPCELL_ROW_134_2474 VGND VPWR sky130_fd_sc_hd__tapvpwrvgnd_1
XFILLER_126_559 VGND VGND VPWR VPWR sky130_fd_sc_hd__fill_2
X_11313_ clknet_leaf_2_clk _01360_ VGND VGND VPWR VPWR cpuregs\[5\]\[10\] sky130_fd_sc_hd__dfxtp_1
XFILLER_4_333 VPWR VGND VPWR VGND sky130_ef_sc_hd__decap_12
XFILLER_153_378 VGND VGND VPWR VPWR sky130_fd_sc_hd__decap_3
XFILLER_141_529 VGND VGND VPWR VPWR sky130_fd_sc_hd__fill_1
X_11244_ clknet_leaf_142_clk _01291_ VGND VGND VPWR VPWR cpuregs\[22\]\[5\] sky130_fd_sc_hd__dfxtp_1
XFILLER_5_889 VGND VGND VPWR VPWR sky130_fd_sc_hd__decap_6
XFILLER_134_570 VPWR VGND VPWR VGND sky130_ef_sc_hd__decap_12
XFILLER_107_795 VPWR VGND VPWR VGND sky130_ef_sc_hd__decap_12
XFILLER_4_377 VPWR VGND VPWR VGND sky130_ef_sc_hd__decap_12
X_11175_ clknet_leaf_116_clk _01222_ VGND VGND VPWR VPWR cpuregs\[29\]\[0\] sky130_fd_sc_hd__dfxtp_1
X_10126_ clknet_leaf_41_clk _00256_ VGND VGND VPWR VPWR cpuregs\[28\]\[28\] sky130_fd_sc_hd__dfxtp_1
XFILLER_0_561 VGND VGND VPWR VPWR sky130_fd_sc_hd__fill_2
X_10057_ clknet_leaf_50_clk _00187_ VGND VGND VPWR VPWR cpuregs\[13\]\[23\] sky130_fd_sc_hd__dfxtp_1
XFILLER_57_71 VGND VGND VPWR VPWR sky130_fd_sc_hd__decap_8
XFILLER_91_811 VGND VGND VPWR VPWR sky130_fd_sc_hd__decap_8
XFILLER_48_587 VGND VGND VPWR VPWR sky130_fd_sc_hd__fill_1
XFILLER_90_365 VGND VGND VPWR VPWR sky130_fd_sc_hd__decap_6
XFILLER_16_451 VGND VGND VPWR VPWR sky130_fd_sc_hd__decap_6
XFILLER_90_387 VPWR VGND VPWR VGND sky130_ef_sc_hd__decap_12
X_10959_ clknet_leaf_97_clk _01021_ VGND VGND VPWR VPWR decoded_imm\[9\] sky130_fd_sc_hd__dfxtp_2
XFILLER_16_473 VGND VGND VPWR VPWR sky130_fd_sc_hd__decap_3
XFILLER_43_281 VGND VGND VPWR VPWR sky130_fd_sc_hd__decap_8
XFILLER_148_139 VGND VGND VPWR VPWR sky130_fd_sc_hd__fill_1
XFILLER_8_661 VGND VGND VPWR VPWR sky130_fd_sc_hd__fill_1
X_06150_ _02612_ cpuregs\[11\]\[7\] _02582_ VGND VGND VPWR VPWR _00044_ sky130_fd_sc_hd__mux2_1
XFILLER_117_559 VGND VGND VPWR VPWR sky130_fd_sc_hd__fill_1
XFILLER_8_694 VGND VGND VPWR VPWR sky130_fd_sc_hd__decap_6
XFILLER_7_193 VPWR VGND VPWR VGND sky130_ef_sc_hd__decap_12
X_06081_ cpuregs\[24\]\[3\] cpuregs\[25\]\[3\] cpuregs\[26\]\[3\] cpuregs\[27\]\[3\]
+ net279 _00008_ VGND VGND VPWR VPWR _02553_ sky130_fd_sc_hd__mux4_1
X_05101_ count_cycle\[3\] _01588_ net256 _01712_ VGND VGND VPWR VPWR _01713_ sky130_fd_sc_hd__o211a_1
XFILLER_132_529 VGND VGND VPWR VPWR sky130_fd_sc_hd__decap_3
XTAP_TAPCELL_ROW_74_1521 VGND VPWR sky130_fd_sc_hd__tapvpwrvgnd_1
XTAP_TAPCELL_ROW_74_1510 VGND VPWR sky130_fd_sc_hd__tapvpwrvgnd_1
X_05032_ is_jalr_addi_slti_sltiu_xori_ori_andi is_lui_auipc_jal VGND VGND VPWR VPWR
+ _01653_ sky130_fd_sc_hd__nor2_4
XFILLER_98_432 VGND VGND VPWR VPWR sky130_fd_sc_hd__fill_2
XFILLER_98_454 VGND VGND VPWR VPWR sky130_fd_sc_hd__decap_6
X_09840_ _02641_ cpuregs\[10\]\[14\] _04876_ VGND VGND VPWR VPWR _01524_ sky130_fd_sc_hd__mux2_1
XFILLER_112_253 VGND VGND VPWR VPWR sky130_fd_sc_hd__fill_1
X_06983_ net187 _03396_ net237 VGND VGND VPWR VPWR _00093_ sky130_fd_sc_hd__mux2_1
XFILLER_98_498 VGND VGND VPWR VPWR sky130_fd_sc_hd__decap_6
XFILLER_58_307 VGND VGND VPWR VPWR sky130_fd_sc_hd__fill_1
X_09771_ _02630_ cpuregs\[7\]\[11\] _04874_ VGND VGND VPWR VPWR _01425_ sky130_fd_sc_hd__mux2_1
X_05934_ mem_wordsize\[1\] net123 net206 mem_wordsize\[2\] VGND VGND VPWR VPWR _02478_
+ sky130_fd_sc_hd__a22o_1
X_08722_ cpuregs\[4\]\[13\] cpuregs\[5\]\[13\] cpuregs\[6\]\[13\] cpuregs\[7\]\[13\]
+ net277 net271 VGND VGND VPWR VPWR _04411_ sky130_fd_sc_hd__mux4_1
XPHY_EDGE_ROW_13_Left_167 VGND VGND VPWR VPWR sky130_fd_sc_hd__decap_3
X_05865_ _02242_ _02421_ _02423_ VGND VGND VPWR VPWR alu_out\[24\] sky130_fd_sc_hd__o21ai_1
XTAP_TAPCELL_ROW_1_347 VGND VPWR sky130_fd_sc_hd__tapvpwrvgnd_1
X_08653_ _04340_ _04341_ _01558_ VGND VGND VPWR VPWR _04346_ sky130_fd_sc_hd__mux2_1
X_07604_ cpuregs\[20\]\[21\] _02670_ _03573_ VGND VGND VPWR VPWR _00537_ sky130_fd_sc_hd__mux2_1
X_05796_ _02358_ _02359_ _02361_ VGND VGND VPWR VPWR alu_out\[17\] sky130_fd_sc_hd__a21o_1
XFILLER_81_354 VGND VGND VPWR VPWR sky130_fd_sc_hd__decap_6
XFILLER_54_579 VGND VGND VPWR VPWR sky130_fd_sc_hd__decap_8
XFILLER_53_18 VGND VGND VPWR VPWR sky130_fd_sc_hd__decap_8
X_08584_ net124 _01585_ _04279_ _04280_ VGND VGND VPWR VPWR _00811_ sky130_fd_sc_hd__o22a_1
X_07535_ _02662_ cpuregs\[16\]\[19\] _03570_ VGND VGND VPWR VPWR _00471_ sky130_fd_sc_hd__mux2_1
XTAP_TAPCELL_ROW_85_1694 VGND VPWR sky130_fd_sc_hd__tapvpwrvgnd_1
X_07466_ cpuregs\[15\]\[17\] _02654_ net246 VGND VGND VPWR VPWR _00405_ sky130_fd_sc_hd__mux2_1
XFILLER_22_421 VGND VGND VPWR VPWR sky130_fd_sc_hd__decap_6
X_09205_ instr_jalr is_lb_lh_lw_lbu_lhu is_alu_reg_imm VGND VGND VPWR VPWR _04791_
+ sky130_fd_sc_hd__or3_2
XPHY_EDGE_ROW_22_Left_176 VGND VGND VPWR VPWR sky130_fd_sc_hd__decap_3
X_06417_ cpuregs\[0\]\[4\] cpuregs\[1\]\[4\] net263 VGND VGND VPWR VPWR _02851_ sky130_fd_sc_hd__mux2_1
Xrebuffer213 net598 VGND VGND VPWR VPWR net599 sky130_fd_sc_hd__dlygate4sd1_1
X_07397_ cpuregs\[14\]\[15\] _02646_ net247 VGND VGND VPWR VPWR _00339_ sky130_fd_sc_hd__mux2_1
Xrebuffer202 latched_stalu VGND VGND VPWR VPWR net588 sky130_fd_sc_hd__dlygate4sd1_1
XFILLER_147_161 VGND VGND VPWR VPWR sky130_fd_sc_hd__decap_6
XFILLER_136_813 VPWR VGND VPWR VGND sky130_ef_sc_hd__decap_12
Xrebuffer224 net608 VGND VGND VPWR VPWR net610 sky130_fd_sc_hd__dlymetal6s2s_1
X_09136_ mem_rdata_q\[31\] mem_rdata_q\[30\] mem_rdata_q\[29\] VGND VGND VPWR VPWR
+ _04767_ sky130_fd_sc_hd__nor3_1
X_06348_ cpuregs\[20\]\[2\] cpuregs\[21\]\[2\] net268 VGND VGND VPWR VPWR _02784_
+ sky130_fd_sc_hd__mux2_1
XTAP_TAPCELL_ROW_20_644 VGND VPWR sky130_fd_sc_hd__tapvpwrvgnd_1
XTAP_TAPCELL_ROW_20_655 VGND VPWR sky130_fd_sc_hd__tapvpwrvgnd_1
XFILLER_108_548 VPWR VGND VPWR VGND sky130_ef_sc_hd__decap_12
X_06279_ cpu_state\[2\] _02715_ VGND VGND VPWR VPWR _02717_ sky130_fd_sc_hd__nor2_1
X_09067_ _01543_ instr_jal net404 VGND VGND VPWR VPWR _04735_ sky130_fd_sc_hd__and3_1
XTAP_TAPCELL_ROW_116_2193 VGND VPWR sky130_fd_sc_hd__tapvpwrvgnd_1
XTAP_TAPCELL_ROW_116_2182 VGND VPWR sky130_fd_sc_hd__tapvpwrvgnd_1
X_08018_ _03837_ _03838_ net34 VGND VGND VPWR VPWR _00687_ sky130_fd_sc_hd__o21a_1
XFILLER_2_837 VPWR VGND VPWR VGND sky130_ef_sc_hd__decap_12
XTAP_TAPCELL_ROW_9_469 VGND VPWR sky130_fd_sc_hd__tapvpwrvgnd_1
XPHY_EDGE_ROW_31_Left_185 VGND VGND VPWR VPWR sky130_fd_sc_hd__decap_3
XFILLER_131_573 VPWR VGND VPWR VGND sky130_ef_sc_hd__decap_12
X_09969_ clknet_leaf_58_clk _00099_ VGND VGND VPWR VPWR net194 sky130_fd_sc_hd__dfxtp_4
XFILLER_134_65 VGND VGND VPWR VPWR sky130_fd_sc_hd__decap_8
XFILLER_150_53 VPWR VGND VPWR VGND sky130_ef_sc_hd__decap_12
XFILLER_72_365 VPWR VGND VPWR VGND sky130_ef_sc_hd__decap_12
XFILLER_72_354 VGND VGND VPWR VPWR sky130_fd_sc_hd__decap_8
XFILLER_27_74 VPWR VGND VPWR VGND sky130_ef_sc_hd__decap_12
XFILLER_150_97 VPWR VGND VPWR VGND sky130_ef_sc_hd__decap_12
X_10813_ clknet_leaf_97_clk _00878_ VGND VGND VPWR VPWR instr_or sky130_fd_sc_hd__dfxtp_1
XTAP_TAPCELL_ROW_28_777 VGND VPWR sky130_fd_sc_hd__tapvpwrvgnd_1
XFILLER_60_549 VPWR VGND VPWR VGND sky130_ef_sc_hd__decap_12
XFILLER_25_281 VGND VGND VPWR VPWR sky130_fd_sc_hd__decap_6
XPHY_EDGE_ROW_40_Left_194 VGND VGND VPWR VPWR sky130_fd_sc_hd__decap_3
XTAP_TAPCELL_ROW_136_2503 VGND VPWR sky130_fd_sc_hd__tapvpwrvgnd_1
X_10744_ clknet_leaf_102_clk _00841_ VGND VGND VPWR VPWR decoder_pseudo_trigger sky130_fd_sc_hd__dfxtp_1
XFILLER_41_763 VPWR VGND VPWR VGND sky130_ef_sc_hd__decap_12
XFILLER_41_785 VGND VGND VPWR VPWR sky130_fd_sc_hd__fill_2
XTAP_TAPCELL_ROW_136_2514 VGND VPWR sky130_fd_sc_hd__tapvpwrvgnd_1
XFILLER_9_436 VGND VGND VPWR VPWR sky130_fd_sc_hd__fill_1
X_10675_ clknet_leaf_121_clk _00773_ VGND VGND VPWR VPWR net58 sky130_fd_sc_hd__dfxtp_1
XFILLER_13_487 VGND VGND VPWR VPWR sky130_fd_sc_hd__fill_2
XFILLER_139_673 VGND VGND VPWR VPWR sky130_fd_sc_hd__fill_2
XFILLER_153_153 VPWR VGND VPWR VGND sky130_ef_sc_hd__decap_12
XFILLER_5_653 VPWR VGND VPWR VGND sky130_ef_sc_hd__decap_12
XFILLER_4_141 VPWR VGND VPWR VGND sky130_ef_sc_hd__decap_12
XFILLER_153_197 VPWR VGND VPWR VGND sky130_ef_sc_hd__decap_12
XFILLER_142_849 VPWR VGND VPWR VGND sky130_ef_sc_hd__decap_12
XFILLER_141_337 VGND VGND VPWR VPWR sky130_fd_sc_hd__fill_1
XFILLER_114_529 VGND VGND VPWR VPWR sky130_fd_sc_hd__decap_3
X_11227_ clknet_leaf_76_clk _01274_ VGND VGND VPWR VPWR cpuregs\[3\]\[20\] sky130_fd_sc_hd__dfxtp_1
XFILLER_150_893 VPWR VGND VPWR VGND sky130_ef_sc_hd__decap_12
XFILLER_110_724 VPWR VGND VPWR VGND sky130_ef_sc_hd__decap_12
X_11158_ clknet_leaf_16_clk _01205_ VGND VGND VPWR VPWR cpuregs\[23\]\[15\] sky130_fd_sc_hd__dfxtp_1
XFILLER_68_627 VPWR VGND VPWR VGND sky130_ef_sc_hd__decap_12
XFILLER_110_757 VGND VGND VPWR VPWR sky130_fd_sc_hd__fill_1
XFILLER_95_435 VGND VGND VPWR VPWR sky130_fd_sc_hd__decap_6
XTAP_TAPCELL_ROW_52_1159 VGND VPWR sky130_fd_sc_hd__tapvpwrvgnd_1
XFILLER_49_841 VPWR VGND VPWR VGND sky130_ef_sc_hd__decap_12
X_10109_ clknet_leaf_148_clk _00239_ VGND VGND VPWR VPWR cpuregs\[28\]\[11\] sky130_fd_sc_hd__dfxtp_1
XTAP_TAPCELL_ROW_147_2687 VGND VPWR sky130_fd_sc_hd__tapvpwrvgnd_1
XTAP_TAPCELL_ROW_147_2676 VGND VPWR sky130_fd_sc_hd__tapvpwrvgnd_1
X_11089_ clknet_leaf_75_clk _01146_ VGND VGND VPWR VPWR cpuregs\[24\]\[20\] sky130_fd_sc_hd__dfxtp_1
XFILLER_49_863 VGND VGND VPWR VPWR sky130_fd_sc_hd__fill_1
XFILLER_82_118 VPWR VGND VPWR VGND sky130_ef_sc_hd__decap_12
XFILLER_36_524 VGND VGND VPWR VPWR sky130_fd_sc_hd__fill_1
XFILLER_75_192 VGND VGND VPWR VPWR sky130_fd_sc_hd__decap_6
X_05650_ instr_bgeu is_sltiu_bltu_sltu _02230_ VGND VGND VPWR VPWR _02233_ sky130_fd_sc_hd__mux2_1
XFILLER_51_505 VGND VGND VPWR VPWR sky130_fd_sc_hd__fill_1
XFILLER_36_579 VGND VGND VPWR VPWR sky130_fd_sc_hd__fill_1
X_05581_ _02161_ _02163_ VGND VGND VPWR VPWR _02164_ sky130_fd_sc_hd__or2_1
XFILLER_90_195 VGND VGND VPWR VPWR sky130_fd_sc_hd__fill_1
X_07320_ cpuregs\[21\]\[4\] _02598_ net248 VGND VGND VPWR VPWR _00264_ sky130_fd_sc_hd__mux2_1
XFILLER_32_774 VGND VGND VPWR VPWR sky130_fd_sc_hd__decap_4
X_07251_ cpuregs\[2\]\[2\] _02590_ net250 VGND VGND VPWR VPWR _00198_ sky130_fd_sc_hd__mux2_1
XFILLER_31_273 VGND VGND VPWR VPWR sky130_fd_sc_hd__decap_6
XFILLER_31_295 VGND VGND VPWR VPWR sky130_fd_sc_hd__decap_4
XFILLER_118_813 VGND VGND VPWR VPWR sky130_fd_sc_hd__decap_4
X_06202_ _02654_ cpuregs\[11\]\[17\] _02582_ VGND VGND VPWR VPWR _00054_ sky130_fd_sc_hd__mux2_1
X_07182_ cpuregs\[30\]\[0\] _02586_ net252 VGND VGND VPWR VPWR _00132_ sky130_fd_sc_hd__mux2_1
XFILLER_118_857 VGND VGND VPWR VPWR sky130_fd_sc_hd__decap_8
X_06133_ _02598_ cpuregs\[11\]\[4\] _02582_ VGND VGND VPWR VPWR _00041_ sky130_fd_sc_hd__mux2_1
XFILLER_144_153 VPWR VGND VPWR VGND sky130_ef_sc_hd__decap_12
XFILLER_144_197 VGND VGND VPWR VPWR sky130_fd_sc_hd__decap_8
X_06064_ _02536_ decoded_imm_j\[2\] is_slli_srli_srai VGND VGND VPWR VPWR _02537_
+ sky130_fd_sc_hd__mux2_1
X_05015_ reg_sh\[3\] reg_sh\[2\] VGND VGND VPWR VPWR _01638_ sky130_fd_sc_hd__or2_2
X_09823_ _02709_ cpuregs\[8\]\[30\] _04875_ VGND VGND VPWR VPWR _01476_ sky130_fd_sc_hd__mux2_1
XFILLER_98_251 VGND VGND VPWR VPWR sky130_fd_sc_hd__fill_1
XFILLER_48_29 VPWR VGND VPWR VGND sky130_ef_sc_hd__decap_12
XTAP_TAPCELL_ROW_6_428 VGND VPWR sky130_fd_sc_hd__tapvpwrvgnd_1
XFILLER_86_446 VGND VGND VPWR VPWR sky130_fd_sc_hd__decap_8
X_09754_ _02696_ cpuregs\[6\]\[27\] _04873_ VGND VGND VPWR VPWR _01409_ sky130_fd_sc_hd__mux2_1
X_06966_ net186 _02721_ _03303_ _01641_ VGND VGND VPWR VPWR _03380_ sky130_fd_sc_hd__o211a_1
XFILLER_67_671 VGND VGND VPWR VPWR sky130_fd_sc_hd__fill_1
XFILLER_27_502 VGND VGND VPWR VPWR sky130_fd_sc_hd__fill_2
X_09685_ cpuregs\[4\]\[24\] _02683_ net238 VGND VGND VPWR VPWR _01342_ sky130_fd_sc_hd__mux2_1
X_06897_ _00015_ _03313_ VGND VGND VPWR VPWR _03314_ sky130_fd_sc_hd__or2_1
X_05917_ instr_sub _02466_ _02467_ _02468_ VGND VGND VPWR VPWR _02469_ sky130_fd_sc_hd__a22o_1
XTAP_TAPCELL_ROW_87_1723 VGND VPWR sky130_fd_sc_hd__tapvpwrvgnd_1
XFILLER_82_630 VGND VGND VPWR VPWR sky130_fd_sc_hd__decap_6
X_08705_ cpuregs\[8\]\[12\] cpuregs\[9\]\[12\] cpuregs\[10\]\[12\] cpuregs\[11\]\[12\]
+ net277 net271 VGND VGND VPWR VPWR _04395_ sky130_fd_sc_hd__mux4_1
XFILLER_54_321 VGND VGND VPWR VPWR sky130_fd_sc_hd__decap_4
XPHY_EDGE_ROW_126_Right_126 VGND VGND VPWR VPWR sky130_fd_sc_hd__decap_3
X_05848_ instr_sub _02086_ _02407_ _02406_ VGND VGND VPWR VPWR _02408_ sky130_fd_sc_hd__o31a_1
Xclkbuf_leaf_93_clk clknet_4_14_0_clk VGND VGND VPWR VPWR clknet_leaf_93_clk sky130_fd_sc_hd__clkbuf_8
X_08636_ _04320_ _04321_ _01558_ VGND VGND VPWR VPWR _04330_ sky130_fd_sc_hd__mux2_1
XFILLER_82_674 VPWR VGND VPWR VGND sky130_ef_sc_hd__decap_12
XFILLER_81_151 VGND VGND VPWR VPWR sky130_fd_sc_hd__decap_8
XFILLER_54_365 VGND VGND VPWR VPWR sky130_fd_sc_hd__decap_8
XTAP_TAPCELL_ROW_25_725 VGND VPWR sky130_fd_sc_hd__tapvpwrvgnd_1
X_05779_ _02241_ _02343_ _02344_ _02346_ VGND VGND VPWR VPWR alu_out\[15\] sky130_fd_sc_hd__a31o_1
XFILLER_70_869 VGND VGND VPWR VPWR sky130_fd_sc_hd__decap_3
X_08567_ cpuregs\[20\]\[5\] cpuregs\[21\]\[5\] cpuregs\[22\]\[5\] cpuregs\[23\]\[5\]
+ net279 _00008_ VGND VGND VPWR VPWR _04264_ sky130_fd_sc_hd__mux4_1
XTAP_TAPCELL_ROW_25_736 VGND VPWR sky130_fd_sc_hd__tapvpwrvgnd_1
X_08498_ net82 net51 _04208_ VGND VGND VPWR VPWR _00796_ sky130_fd_sc_hd__mux2_1
XFILLER_80_27 VGND VGND VPWR VPWR sky130_fd_sc_hd__fill_1
X_07518_ _02590_ cpuregs\[16\]\[2\] _03570_ VGND VGND VPWR VPWR _00454_ sky130_fd_sc_hd__mux2_1
XFILLER_23_774 VGND VGND VPWR VPWR sky130_fd_sc_hd__decap_8
XFILLER_23_785 VPWR VGND VPWR VGND sky130_ef_sc_hd__decap_12
XTAP_TAPCELL_ROW_118_2222 VGND VPWR sky130_fd_sc_hd__tapvpwrvgnd_1
XFILLER_80_49 VGND VGND VPWR VPWR sky130_fd_sc_hd__fill_1
XFILLER_10_413 VGND VGND VPWR VPWR sky130_fd_sc_hd__decap_6
XFILLER_22_262 VGND VGND VPWR VPWR sky130_fd_sc_hd__fill_1
X_07449_ cpuregs\[15\]\[0\] _02586_ net246 VGND VGND VPWR VPWR _00388_ sky130_fd_sc_hd__mux2_1
X_10460_ clknet_leaf_106_clk _00590_ VGND VGND VPWR VPWR count_instr\[9\] sky130_fd_sc_hd__dfxtp_1
XFILLER_136_643 VGND VGND VPWR VPWR sky130_fd_sc_hd__fill_1
X_09119_ mem_rdata_q\[14\] mem_rdata_q\[12\] mem_rdata_q\[13\] VGND VGND VPWR VPWR
+ _04762_ sky130_fd_sc_hd__or3b_1
XTAP_TAPCELL_ROW_131_2433 VGND VPWR sky130_fd_sc_hd__tapvpwrvgnd_1
XTAP_TAPCELL_ROW_131_2422 VGND VPWR sky130_fd_sc_hd__tapvpwrvgnd_1
XTAP_TAPCELL_ROW_98_1896 VGND VPWR sky130_fd_sc_hd__tapvpwrvgnd_1
X_10391_ clknet_leaf_140_clk _00521_ VGND VGND VPWR VPWR cpuregs\[20\]\[5\] sky130_fd_sc_hd__dfxtp_1
XFILLER_124_849 VPWR VGND VPWR VGND sky130_ef_sc_hd__decap_12
XFILLER_117_890 VGND VGND VPWR VPWR sky130_fd_sc_hd__decap_6
XFILLER_108_389 VPWR VGND VPWR VGND sky130_ef_sc_hd__decap_12
XFILLER_2_601 VGND VGND VPWR VPWR sky130_fd_sc_hd__decap_4
XFILLER_8_3 VPWR VGND VPWR VGND sky130_ef_sc_hd__decap_12
XFILLER_2_645 VPWR VGND VPWR VGND sky130_ef_sc_hd__decap_12
XFILLER_1_111 VGND VGND VPWR VPWR sky130_fd_sc_hd__fill_1
XFILLER_150_189 VGND VGND VPWR VPWR sky130_fd_sc_hd__decap_6
XFILLER_132_893 VPWR VGND VPWR VGND sky130_ef_sc_hd__decap_12
X_11012_ clknet_leaf_6_clk _01074_ VGND VGND VPWR VPWR cpuregs\[19\]\[12\] sky130_fd_sc_hd__dfxtp_1
XFILLER_131_381 VGND VGND VPWR VPWR sky130_fd_sc_hd__decap_8
XFILLER_92_405 VPWR VGND VPWR VGND sky130_ef_sc_hd__decap_12
XTAP_TAPCELL_ROW_129_2395 VGND VPWR sky130_fd_sc_hd__tapvpwrvgnd_1
XFILLER_92_427 VGND VGND VPWR VPWR sky130_fd_sc_hd__fill_1
Xclkbuf_leaf_84_clk clknet_4_14_0_clk VGND VGND VPWR VPWR clknet_leaf_84_clk sky130_fd_sc_hd__clkbuf_8
XFILLER_18_546 VGND VGND VPWR VPWR sky130_fd_sc_hd__fill_1
XFILLER_72_195 VGND VGND VPWR VPWR sky130_fd_sc_hd__fill_1
XFILLER_45_398 VGND VGND VPWR VPWR sky130_fd_sc_hd__decap_6
X_10727_ clknet_leaf_54_clk _00824_ VGND VGND VPWR VPWR net212 sky130_fd_sc_hd__dfxtp_4
XFILLER_139_492 VPWR VGND VPWR VGND sky130_ef_sc_hd__decap_12
XFILLER_139_481 VGND VGND VPWR VPWR sky130_fd_sc_hd__fill_2
X_10658_ clknet_leaf_89_clk _04885_ VGND VGND VPWR VPWR reg_out\[16\] sky130_fd_sc_hd__dfxtp_1
Xclkload25 clknet_leaf_10_clk VGND VGND VPWR VPWR clkload25/X sky130_fd_sc_hd__clkbuf_4
Xclkload14 clknet_leaf_2_clk VGND VGND VPWR VPWR clkload14/Y sky130_fd_sc_hd__inv_6
XFILLER_127_654 VPWR VGND VPWR VGND sky130_ef_sc_hd__decap_12
Xclkload58 clknet_leaf_36_clk VGND VGND VPWR VPWR clkload58/Y sky130_fd_sc_hd__inv_6
Xclkload47 clknet_leaf_23_clk VGND VGND VPWR VPWR clkload47/X sky130_fd_sc_hd__clkbuf_4
Xclkload69 clknet_leaf_57_clk VGND VGND VPWR VPWR clkload69/Y sky130_fd_sc_hd__inv_6
X_10589_ clknet_leaf_105_clk _00719_ VGND VGND VPWR VPWR count_cycle\[12\] sky130_fd_sc_hd__dfxtp_1
Xclkload36 clknet_leaf_145_clk VGND VGND VPWR VPWR clkload36/Y sky130_fd_sc_hd__clkinvlp_4
XFILLER_141_101 VGND VGND VPWR VPWR sky130_fd_sc_hd__fill_1
XFILLER_115_849 VGND VGND VPWR VPWR sky130_fd_sc_hd__fill_1
XFILLER_5_461 VGND VGND VPWR VPWR sky130_fd_sc_hd__decap_4
XTAP_TAPCELL_ROW_149_2716 VGND VPWR sky130_fd_sc_hd__tapvpwrvgnd_1
XFILLER_126_197 VGND VGND VPWR VPWR sky130_fd_sc_hd__decap_6
X_06820_ decoded_imm\[19\] net181 VGND VGND VPWR VPWR _03239_ sky130_fd_sc_hd__nand2_1
XFILLER_56_619 VGND VGND VPWR VPWR sky130_fd_sc_hd__fill_1
XFILLER_83_449 VGND VGND VPWR VPWR sky130_fd_sc_hd__fill_1
X_06751_ cpuregs\[28\]\[16\] cpuregs\[29\]\[16\] cpuregs\[30\]\[16\] cpuregs\[31\]\[16\]
+ net265 net260 VGND VGND VPWR VPWR _03173_ sky130_fd_sc_hd__mux4_1
XTAP_TAPCELL_ROW_69_1431 VGND VPWR sky130_fd_sc_hd__tapvpwrvgnd_1
Xclkbuf_leaf_75_clk clknet_4_15_0_clk VGND VGND VPWR VPWR clknet_leaf_75_clk sky130_fd_sc_hd__clkbuf_8
X_06682_ _02714_ _03087_ _03091_ _03106_ VGND VGND VPWR VPWR _03107_ sky130_fd_sc_hd__o31a_1
XTAP_TAPCELL_ROW_69_1442 VGND VPWR sky130_fd_sc_hd__tapvpwrvgnd_1
X_05702_ _02162_ _02240_ _02237_ VGND VGND VPWR VPWR _02279_ sky130_fd_sc_hd__a21oi_1
XFILLER_37_877 VPWR VGND VPWR VGND sky130_ef_sc_hd__decap_12
X_09470_ cpuregs\[24\]\[8\] _02616_ net242 VGND VGND VPWR VPWR _01134_ sky130_fd_sc_hd__mux2_1
X_08421_ _04161_ _04162_ VGND VGND VPWR VPWR _00766_ sky130_fd_sc_hd__nor2_1
XFILLER_91_482 VGND VGND VPWR VPWR sky130_fd_sc_hd__decap_6
XFILLER_36_365 VGND VGND VPWR VPWR sky130_fd_sc_hd__decap_4
X_05633_ net216 net184 VGND VGND VPWR VPWR _02216_ sky130_fd_sc_hd__and2b_1
XTAP_TAPCELL_ROW_82_1642 VGND VPWR sky130_fd_sc_hd__tapvpwrvgnd_1
XFILLER_52_869 VGND VGND VPWR VPWR sky130_fd_sc_hd__decap_6
X_05564_ net177 net209 VGND VGND VPWR VPWR _02147_ sky130_fd_sc_hd__and2_1
X_08352_ count_cycle\[32\] _04114_ count_cycle\[34\] count_cycle\[33\] VGND VGND VPWR
+ VPWR _04119_ sky130_fd_sc_hd__and4_1
XFILLER_149_234 VGND VGND VPWR VPWR sky130_fd_sc_hd__decap_4
XFILLER_149_223 VGND VGND VPWR VPWR sky130_fd_sc_hd__fill_1
X_07303_ cpuregs\[28\]\[21\] _02670_ _03560_ VGND VGND VPWR VPWR _00249_ sky130_fd_sc_hd__mux2_1
X_05495_ _02076_ _02077_ VGND VGND VPWR VPWR _02078_ sky130_fd_sc_hd__and2_1
X_08283_ net445 _04074_ VGND VGND VPWR VPWR _00716_ sky130_fd_sc_hd__nor2_1
X_07234_ cpuregs\[13\]\[18\] _02657_ net251 VGND VGND VPWR VPWR _00182_ sky130_fd_sc_hd__mux2_1
XFILLER_20_755 VGND VGND VPWR VPWR sky130_fd_sc_hd__fill_1
Xclkload8 clknet_4_10_0_clk VGND VGND VPWR VPWR clkload8/Y sky130_fd_sc_hd__inv_6
XFILLER_118_643 VGND VGND VPWR VPWR sky130_fd_sc_hd__fill_1
X_07165_ cpuregs\[12\]\[19\] _02662_ net253 VGND VGND VPWR VPWR _00119_ sky130_fd_sc_hd__mux2_1
XFILLER_133_613 VGND VGND VPWR VPWR sky130_fd_sc_hd__decap_3
XFILLER_132_101 VGND VGND VPWR VPWR sky130_fd_sc_hd__fill_1
XFILLER_117_164 VGND VGND VPWR VPWR sky130_fd_sc_hd__decap_4
XTAP_TAPCELL_ROW_113_2141 VGND VPWR sky130_fd_sc_hd__tapvpwrvgnd_1
X_07096_ _03503_ _03504_ _01621_ VGND VGND VPWR VPWR _03505_ sky130_fd_sc_hd__a21oi_1
X_06116_ _02583_ _02585_ VGND VGND VPWR VPWR _02586_ sky130_fd_sc_hd__and2_4
XFILLER_105_348 VGND VGND VPWR VPWR sky130_fd_sc_hd__decap_6
XFILLER_59_39 VGND VGND VPWR VPWR sky130_fd_sc_hd__fill_1
X_06047_ _01558_ _02517_ _01559_ VGND VGND VPWR VPWR _02520_ sky130_fd_sc_hd__o21a_1
XFILLER_120_318 VGND VGND VPWR VPWR sky130_fd_sc_hd__decap_8
XFILLER_115_23 VPWR VGND VPWR VGND sky130_ef_sc_hd__decap_12
XFILLER_114_893 VGND VGND VPWR VPWR sky130_fd_sc_hd__fill_2
XFILLER_86_232 VGND VGND VPWR VPWR sky130_fd_sc_hd__fill_1
XFILLER_59_435 VGND VGND VPWR VPWR sky130_fd_sc_hd__decap_3
X_09806_ _02638_ cpuregs\[8\]\[13\] _04875_ VGND VGND VPWR VPWR _01459_ sky130_fd_sc_hd__mux2_1
X_07998_ decoded_imm_j\[9\] _03696_ _03697_ decoded_imm_j\[10\] VGND VGND VPWR VPWR
+ _03820_ sky130_fd_sc_hd__a22o_1
X_06949_ _00014_ _03362_ _01581_ VGND VGND VPWR VPWR _03364_ sky130_fd_sc_hd__o21a_1
X_09737_ _02624_ cpuregs\[6\]\[10\] _04873_ VGND VGND VPWR VPWR _01392_ sky130_fd_sc_hd__mux2_1
Xclkbuf_leaf_66_clk clknet_4_13_0_clk VGND VGND VPWR VPWR clknet_leaf_66_clk sky130_fd_sc_hd__clkbuf_8
XFILLER_39_181 VGND VGND VPWR VPWR sky130_fd_sc_hd__decap_3
XFILLER_131_55 VGND VGND VPWR VPWR sky130_fd_sc_hd__fill_1
XFILLER_91_15 VPWR VGND VPWR VGND sky130_ef_sc_hd__decap_12
X_09668_ cpuregs\[4\]\[7\] _02612_ net238 VGND VGND VPWR VPWR _01325_ sky130_fd_sc_hd__mux2_1
XFILLER_15_505 VPWR VGND VPWR VGND sky130_ef_sc_hd__decap_12
XFILLER_54_195 VGND VGND VPWR VPWR sky130_fd_sc_hd__fill_1
X_09599_ _02603_ cpuregs\[3\]\[5\] _04868_ VGND VGND VPWR VPWR _01259_ sky130_fd_sc_hd__mux2_1
X_08619_ net269 _04312_ _01559_ VGND VGND VPWR VPWR _04314_ sky130_fd_sc_hd__a21o_1
XFILLER_145_3 VPWR VGND VPWR VGND sky130_ef_sc_hd__decap_12
XFILLER_24_53 VGND VGND VPWR VPWR sky130_fd_sc_hd__decap_6
XFILLER_24_75 VGND VGND VPWR VPWR sky130_fd_sc_hd__decap_8
X_10512_ clknet_leaf_81_clk _00642_ VGND VGND VPWR VPWR count_instr\[61\] sky130_fd_sc_hd__dfxtp_1
XFILLER_11_755 VPWR VGND VPWR VGND sky130_ef_sc_hd__decap_12
X_11492_ clknet_leaf_44_clk _01536_ VGND VGND VPWR VPWR cpuregs\[10\]\[26\] sky130_fd_sc_hd__dfxtp_1
X_10443_ clknet_leaf_68_clk _00573_ VGND VGND VPWR VPWR cpuregs\[17\]\[25\] sky130_fd_sc_hd__dfxtp_1
XFILLER_40_41 VGND VGND VPWR VPWR sky130_fd_sc_hd__fill_2
X_10374_ clknet_leaf_74_clk _00504_ VGND VGND VPWR VPWR cpuregs\[25\]\[20\] sky130_fd_sc_hd__dfxtp_1
XFILLER_123_101 VGND VGND VPWR VPWR sky130_fd_sc_hd__decap_3
XFILLER_151_465 VGND VGND VPWR VPWR sky130_fd_sc_hd__decap_6
XFILLER_123_178 VGND VGND VPWR VPWR sky130_fd_sc_hd__decap_4
XFILLER_97_519 VGND VGND VPWR VPWR sky130_fd_sc_hd__fill_2
XFILLER_111_329 VGND VGND VPWR VPWR sky130_fd_sc_hd__decap_6
XFILLER_104_392 VGND VGND VPWR VPWR sky130_fd_sc_hd__fill_1
XFILLER_78_755 VGND VGND VPWR VPWR sky130_fd_sc_hd__fill_1
XFILLER_78_733 VGND VGND VPWR VPWR sky130_fd_sc_hd__fill_1
XFILLER_2_497 VGND VGND VPWR VPWR sky130_fd_sc_hd__decap_3
XFILLER_93_703 VGND VGND VPWR VPWR sky130_fd_sc_hd__fill_1
XFILLER_78_777 VGND VGND VPWR VPWR sky130_fd_sc_hd__decap_4
XTAP_TAPCELL_ROW_144_2635 VGND VPWR sky130_fd_sc_hd__tapvpwrvgnd_1
XFILLER_93_725 VGND VGND VPWR VPWR sky130_fd_sc_hd__decap_3
XFILLER_19_833 VGND VGND VPWR VPWR sky130_fd_sc_hd__decap_6
XFILLER_37_129 VGND VGND VPWR VPWR sky130_fd_sc_hd__fill_1
Xclkbuf_leaf_57_clk clknet_4_6_0_clk VGND VGND VPWR VPWR clknet_leaf_57_clk sky130_fd_sc_hd__clkbuf_8
XFILLER_65_449 VGND VGND VPWR VPWR sky130_fd_sc_hd__fill_2
XFILLER_1_57 VPWR VGND VPWR VGND sky130_ef_sc_hd__decap_12
XFILLER_19_877 VPWR VGND VPWR VGND sky130_ef_sc_hd__decap_12
XFILLER_33_302 VGND VGND VPWR VPWR sky130_fd_sc_hd__decap_4
XFILLER_34_825 VPWR VGND VPWR VGND sky130_ef_sc_hd__decap_12
XFILLER_61_622 VGND VGND VPWR VPWR sky130_fd_sc_hd__decap_4
XFILLER_60_121 VGND VGND VPWR VPWR sky130_fd_sc_hd__decap_3
XTAP_TAPCELL_ROW_64_1361 VGND VPWR sky130_fd_sc_hd__tapvpwrvgnd_1
XTAP_TAPCELL_ROW_64_1350 VGND VPWR sky130_fd_sc_hd__tapvpwrvgnd_1
XTAP_TAPCELL_ROW_16_588 VGND VPWR sky130_fd_sc_hd__tapvpwrvgnd_1
XFILLER_119_418 VGND VGND VPWR VPWR sky130_fd_sc_hd__decap_8
X_05280_ reg_pc\[16\] decoded_imm\[16\] _01876_ VGND VGND VPWR VPWR _01878_ sky130_fd_sc_hd__and3_1
Xclkload103 clknet_leaf_103_clk VGND VGND VPWR VPWR clkload103/Y sky130_fd_sc_hd__clkinv_1
Xclkload136 clknet_leaf_77_clk VGND VGND VPWR VPWR clkload136/Y sky130_fd_sc_hd__clkinv_8
Xclkload125 clknet_leaf_74_clk VGND VGND VPWR VPWR clkload125/X sky130_fd_sc_hd__clkbuf_8
Xclkload114 clknet_leaf_92_clk VGND VGND VPWR VPWR clkload114/Y sky130_fd_sc_hd__clkinv_2
XFILLER_6_781 VPWR VGND VPWR VGND sky130_ef_sc_hd__decap_12
XFILLER_142_421 VGND VGND VPWR VPWR sky130_fd_sc_hd__decap_8
XFILLER_103_808 VPWR VGND VPWR VGND sky130_ef_sc_hd__decap_12
X_08970_ decoded_imm\[26\] _01654_ _01586_ VGND VGND VPWR VPWR _04646_ sky130_fd_sc_hd__a21o_1
XFILLER_142_498 VGND VGND VPWR VPWR sky130_fd_sc_hd__decap_4
XFILLER_96_530 VGND VGND VPWR VPWR sky130_fd_sc_hd__fill_2
X_07921_ _01547_ reg_next_pc\[4\] _01645_ _03691_ VGND VGND VPWR VPWR _03750_ sky130_fd_sc_hd__a22o_1
X_07852_ reg_pc\[14\] _01624_ _01628_ _03701_ VGND VGND VPWR VPWR _00658_ sky130_fd_sc_hd__a22o_1
X_06803_ cpuregs\[28\]\[18\] cpuregs\[29\]\[18\] cpuregs\[30\]\[18\] cpuregs\[31\]\[18\]
+ net265 net260 VGND VGND VPWR VPWR _03223_ sky130_fd_sc_hd__mux4_1
Xinput1 mem_rdata[0] VGND VGND VPWR VPWR net1 sky130_fd_sc_hd__buf_1
Xclkbuf_leaf_48_clk clknet_4_7_0_clk VGND VGND VPWR VPWR clknet_leaf_48_clk sky130_fd_sc_hd__clkbuf_8
X_09522_ cpuregs\[31\]\[27\] _02696_ net240 VGND VGND VPWR VPWR _01185_ sky130_fd_sc_hd__mux2_1
X_07783_ count_instr\[48\] _03659_ _03661_ VGND VGND VPWR VPWR _00629_ sky130_fd_sc_hd__o21a_1
X_04995_ _01547_ _01621_ _01549_ VGND VGND VPWR VPWR _01623_ sky130_fd_sc_hd__a21o_1
XFILLER_45_19 VPWR VGND VPWR VGND sky130_ef_sc_hd__decap_12
X_06734_ net178 _02725_ VGND VGND VPWR VPWR _03156_ sky130_fd_sc_hd__and2_1
XFILLER_71_408 VGND VGND VPWR VPWR sky130_fd_sc_hd__decap_4
XFILLER_37_685 VGND VGND VPWR VPWR sky130_fd_sc_hd__decap_6
X_09453_ _02683_ cpuregs\[19\]\[24\] _04863_ VGND VGND VPWR VPWR _01086_ sky130_fd_sc_hd__mux2_1
XFILLER_91_290 VGND VGND VPWR VPWR sky130_fd_sc_hd__decap_8
X_06665_ net174 _02721_ VGND VGND VPWR VPWR _03090_ sky130_fd_sc_hd__or2_1
X_08404_ count_cycle\[53\] _04149_ _04151_ VGND VGND VPWR VPWR _00760_ sky130_fd_sc_hd__o21a_1
X_05616_ net208 net176 VGND VGND VPWR VPWR _02199_ sky130_fd_sc_hd__nand2b_1
X_09384_ instr_jal decoded_imm_j\[4\] _04791_ mem_rdata_q\[24\] _04747_ VGND VGND
+ VPWR VPWR _04855_ sky130_fd_sc_hd__a221o_1
XFILLER_40_806 VGND VGND VPWR VPWR sky130_fd_sc_hd__fill_1
X_08335_ _04108_ net34 _04107_ VGND VGND VPWR VPWR _00734_ sky130_fd_sc_hd__and3b_1
XFILLER_52_699 VGND VGND VPWR VPWR sky130_fd_sc_hd__fill_1
X_06596_ cpuregs\[0\]\[10\] cpuregs\[1\]\[10\] cpuregs\[2\]\[10\] cpuregs\[3\]\[10\]
+ net263 net259 VGND VGND VPWR VPWR _03024_ sky130_fd_sc_hd__mux4_1
XTAP_TAPCELL_ROW_35_886 VGND VPWR sky130_fd_sc_hd__tapvpwrvgnd_1
XTAP_TAPCELL_ROW_35_897 VGND VPWR sky130_fd_sc_hd__tapvpwrvgnd_1
X_05547_ _02128_ _02129_ VGND VGND VPWR VPWR _02130_ sky130_fd_sc_hd__and2_1
X_05478_ _02058_ _02059_ VGND VGND VPWR VPWR _02061_ sky130_fd_sc_hd__or2_1
X_08266_ count_cycle\[3\] _04062_ net34 VGND VGND VPWR VPWR _04064_ sky130_fd_sc_hd__o21ai_1
X_08197_ _04000_ _04001_ _04002_ _04003_ VGND VGND VPWR VPWR _04004_ sky130_fd_sc_hd__a22o_1
X_07217_ cpuregs\[13\]\[1\] _02588_ net251 VGND VGND VPWR VPWR _00165_ sky130_fd_sc_hd__mux2_1
XFILLER_118_473 VGND VGND VPWR VPWR sky130_fd_sc_hd__decap_3
XFILLER_118_484 VGND VGND VPWR VPWR sky130_fd_sc_hd__fill_1
XTAP_TAPCELL_ROW_95_1855 VGND VPWR sky130_fd_sc_hd__tapvpwrvgnd_1
XTAP_TAPCELL_ROW_95_1844 VGND VPWR sky130_fd_sc_hd__tapvpwrvgnd_1
XFILLER_3_217 VGND VGND VPWR VPWR sky130_fd_sc_hd__decap_6
X_07148_ cpuregs\[12\]\[2\] _02590_ net253 VGND VGND VPWR VPWR _00102_ sky130_fd_sc_hd__mux2_1
XFILLER_145_281 VGND VGND VPWR VPWR sky130_fd_sc_hd__fill_1
XFILLER_106_635 VGND VGND VPWR VPWR sky130_fd_sc_hd__decap_8
X_07079_ _01579_ _03488_ VGND VGND VPWR VPWR _03489_ sky130_fd_sc_hd__or2_1
XFILLER_121_605 VGND VGND VPWR VPWR sky130_fd_sc_hd__decap_3
XFILLER_10_77 VGND VGND VPWR VPWR sky130_fd_sc_hd__decap_6
XPHY_EDGE_ROW_5_Left_159 VGND VGND VPWR VPWR sky130_fd_sc_hd__decap_3
X_10090_ clknet_leaf_69_clk _00220_ VGND VGND VPWR VPWR cpuregs\[2\]\[24\] sky130_fd_sc_hd__dfxtp_1
XFILLER_101_384 VGND VGND VPWR VPWR sky130_fd_sc_hd__fill_2
XFILLER_75_725 VGND VGND VPWR VPWR sky130_fd_sc_hd__decap_3
XFILLER_47_416 VPWR VGND VPWR VGND sky130_ef_sc_hd__decap_12
XFILLER_142_65 VPWR VGND VPWR VGND sky130_ef_sc_hd__decap_12
Xclkbuf_leaf_39_clk clknet_4_5_0_clk VGND VGND VPWR VPWR clknet_leaf_39_clk sky130_fd_sc_hd__clkbuf_8
XTAP_TAPCELL_ROW_126_2354 VGND VPWR sky130_fd_sc_hd__tapvpwrvgnd_1
XTAP_TAPCELL_ROW_126_2343 VGND VPWR sky130_fd_sc_hd__tapvpwrvgnd_1
XFILLER_47_449 VGND VGND VPWR VPWR sky130_fd_sc_hd__decap_8
X_10992_ clknet_leaf_69_clk _01054_ VGND VGND VPWR VPWR cpuregs\[18\]\[24\] sky130_fd_sc_hd__dfxtp_1
XFILLER_90_717 VPWR VGND VPWR VGND sky130_ef_sc_hd__decap_12
XFILLER_16_803 VGND VGND VPWR VPWR sky130_fd_sc_hd__decap_8
XFILLER_16_825 VPWR VGND VPWR VGND sky130_ef_sc_hd__decap_12
XFILLER_43_611 VGND VGND VPWR VPWR sky130_fd_sc_hd__decap_4
XFILLER_70_452 VGND VGND VPWR VPWR sky130_fd_sc_hd__fill_1
XFILLER_16_869 VPWR VGND VPWR VGND sky130_ef_sc_hd__decap_12
XTAP_TAPCELL_ROW_104_1995 VGND VPWR sky130_fd_sc_hd__tapvpwrvgnd_1
XFILLER_31_839 VGND VGND VPWR VPWR sky130_fd_sc_hd__fill_1
XFILLER_129_727 VGND VGND VPWR VPWR sky130_fd_sc_hd__fill_1
XTAP_TAPCELL_ROW_13_536 VGND VPWR sky130_fd_sc_hd__tapvpwrvgnd_1
XTAP_TAPCELL_ROW_13_547 VGND VPWR sky130_fd_sc_hd__tapvpwrvgnd_1
XFILLER_7_534 VGND VGND VPWR VPWR sky130_fd_sc_hd__fill_1
X_11475_ clknet_leaf_0_clk _01519_ VGND VGND VPWR VPWR cpuregs\[10\]\[9\] sky130_fd_sc_hd__dfxtp_1
X_10426_ clknet_leaf_146_clk _00556_ VGND VGND VPWR VPWR cpuregs\[17\]\[8\] sky130_fd_sc_hd__dfxtp_1
XFILLER_152_741 VPWR VGND VPWR VGND sky130_ef_sc_hd__decap_12
XFILLER_124_421 VGND VGND VPWR VPWR sky130_fd_sc_hd__decap_6
X_10357_ clknet_leaf_124_clk _00487_ VGND VGND VPWR VPWR cpuregs\[25\]\[3\] sky130_fd_sc_hd__dfxtp_1
XFILLER_151_273 VGND VGND VPWR VPWR sky130_fd_sc_hd__decap_6
XFILLER_111_104 VGND VGND VPWR VPWR sky130_fd_sc_hd__decap_8
X_10288_ clknet_leaf_27_clk _00418_ VGND VGND VPWR VPWR cpuregs\[15\]\[30\] sky130_fd_sc_hd__dfxtp_1
XFILLER_93_544 VGND VGND VPWR VPWR sky130_fd_sc_hd__decap_6
XTAP_TAPCELL_ROW_49_1109 VGND VPWR sky130_fd_sc_hd__tapvpwrvgnd_1
XFILLER_18_162 VPWR VGND VPWR VGND sky130_ef_sc_hd__decap_12
XFILLER_92_80 VGND VGND VPWR VPWR sky130_fd_sc_hd__decap_4
XFILLER_61_430 VGND VGND VPWR VPWR sky130_fd_sc_hd__decap_4
X_06450_ cpuregs\[24\]\[5\] cpuregs\[25\]\[5\] cpuregs\[26\]\[5\] cpuregs\[27\]\[5\]
+ net264 net262 VGND VGND VPWR VPWR _02883_ sky130_fd_sc_hd__mux4_1
XFILLER_34_655 VGND VGND VPWR VPWR sky130_fd_sc_hd__decap_6
X_05401_ cpu_state\[6\] _01860_ _01985_ _01989_ VGND VGND VPWR VPWR _01990_ sky130_fd_sc_hd__a31o_1
X_06381_ cpuregs\[20\]\[3\] cpuregs\[21\]\[3\] net268 VGND VGND VPWR VPWR _02816_
+ sky130_fd_sc_hd__mux2_1
XTAP_TAPCELL_ROW_32_845 VGND VPWR sky130_fd_sc_hd__tapvpwrvgnd_1
XFILLER_119_237 VGND VGND VPWR VPWR sky130_fd_sc_hd__fill_1
X_05332_ _01908_ _01914_ _01923_ VGND VGND VPWR VPWR _01926_ sky130_fd_sc_hd__nand3_1
X_08120_ _03902_ _03706_ _03707_ _03705_ VGND VGND VPWR VPWR _03933_ sky130_fd_sc_hd__and4_1
XFILLER_30_861 VGND VGND VPWR VPWR sky130_fd_sc_hd__decap_6
XFILLER_119_259 VPWR VGND VPWR VGND sky130_ef_sc_hd__decap_12
X_05263_ count_instr\[47\] instr_rdinstrh net257 _01862_ VGND VGND VPWR VPWR _01863_
+ sky130_fd_sc_hd__a211o_1
X_08051_ _03867_ _03868_ VGND VGND VPWR VPWR _03869_ sky130_fd_sc_hd__and2b_1
X_07002_ cpuregs\[0\]\[25\] cpuregs\[1\]\[25\] cpuregs\[2\]\[25\] cpuregs\[3\]\[25\]
+ net267 net261 VGND VGND VPWR VPWR _03415_ sky130_fd_sc_hd__mux4_1
XFILLER_143_752 VGND VGND VPWR VPWR sky130_fd_sc_hd__decap_8
XFILLER_115_443 VGND VGND VPWR VPWR sky130_fd_sc_hd__decap_4
XTAP_TAPCELL_ROW_77_1563 VGND VPWR sky130_fd_sc_hd__tapvpwrvgnd_1
X_05194_ _01543_ _01791_ _01792_ _01798_ VGND VGND VPWR VPWR _04879_ sky130_fd_sc_hd__o31ai_1
XFILLER_130_402 VGND VGND VPWR VPWR sky130_fd_sc_hd__fill_1
Xpicorv32_287 VGND VGND VPWR VPWR picorv32_287/HI eoi[6] sky130_fd_sc_hd__conb_1
XFILLER_0_209 VPWR VGND VPWR VGND sky130_ef_sc_hd__decap_12
X_08953_ cpuregs\[24\]\[26\] cpuregs\[25\]\[26\] cpuregs\[26\]\[26\] cpuregs\[27\]\[26\]
+ net276 net272 VGND VGND VPWR VPWR _04629_ sky130_fd_sc_hd__mux4_1
Xpicorv32_298 VGND VGND VPWR VPWR picorv32_298/HI eoi[17] sky130_fd_sc_hd__conb_1
XFILLER_103_627 VGND VGND VPWR VPWR sky130_fd_sc_hd__decap_8
XFILLER_102_137 VGND VGND VPWR VPWR sky130_fd_sc_hd__decap_3
XTAP_TAPCELL_ROW_90_1774 VGND VPWR sky130_fd_sc_hd__tapvpwrvgnd_1
X_07904_ _03732_ _03733_ VGND VGND VPWR VPWR _03734_ sky130_fd_sc_hd__and2_1
X_08884_ cpuregs\[4\]\[22\] cpuregs\[5\]\[22\] cpuregs\[6\]\[22\] cpuregs\[7\]\[22\]
+ net276 net272 VGND VGND VPWR VPWR _04564_ sky130_fd_sc_hd__mux4_1
XFILLER_111_660 VGND VGND VPWR VPWR sky130_fd_sc_hd__decap_6
XFILLER_56_29 VPWR VGND VPWR VGND sky130_ef_sc_hd__decap_12
XFILLER_84_533 VGND VGND VPWR VPWR sky130_fd_sc_hd__decap_8
XFILLER_56_224 VGND VGND VPWR VPWR sky130_fd_sc_hd__decap_6
X_07835_ _02604_ reg_next_pc\[6\] _02482_ VGND VGND VPWR VPWR _03693_ sky130_fd_sc_hd__mux2_2
XTAP_TAPCELL_ROW_108_2062 VGND VPWR sky130_fd_sc_hd__tapvpwrvgnd_1
X_07766_ count_instr\[42\] _03649_ _01549_ VGND VGND VPWR VPWR _03651_ sky130_fd_sc_hd__a21oi_1
X_04978_ net34 cpu_state\[0\] VGND VGND VPWR VPWR _00580_ sky130_fd_sc_hd__and2_1
XFILLER_44_408 VGND VGND VPWR VPWR sky130_fd_sc_hd__decap_4
XFILLER_44_419 VGND VGND VPWR VPWR sky130_fd_sc_hd__fill_1
X_06717_ cpuregs\[20\]\[15\] cpuregs\[21\]\[15\] cpuregs\[22\]\[15\] cpuregs\[23\]\[15\]
+ net265 net260 VGND VGND VPWR VPWR _03140_ sky130_fd_sc_hd__mux4_1
X_09505_ cpuregs\[31\]\[10\] _02624_ net240 VGND VGND VPWR VPWR _01168_ sky130_fd_sc_hd__mux2_1
XFILLER_25_633 VGND VGND VPWR VPWR sky130_fd_sc_hd__decap_8
XTAP_TAPCELL_ROW_121_2262 VGND VPWR sky130_fd_sc_hd__tapvpwrvgnd_1
X_07697_ count_instr\[17\] _03605_ _01549_ VGND VGND VPWR VPWR _03607_ sky130_fd_sc_hd__a21oi_1
X_09436_ _02612_ cpuregs\[19\]\[7\] _04863_ VGND VGND VPWR VPWR _01069_ sky130_fd_sc_hd__mux2_1
XTAP_TAPCELL_ROW_121_2273 VGND VPWR sky130_fd_sc_hd__tapvpwrvgnd_1
X_06648_ cpuregs\[24\]\[12\] cpuregs\[25\]\[12\] cpuregs\[26\]\[12\] cpuregs\[27\]\[12\]
+ net263 net259 VGND VGND VPWR VPWR _03074_ sky130_fd_sc_hd__mux4_1
XFILLER_52_474 VGND VGND VPWR VPWR sky130_fd_sc_hd__fill_2
XFILLER_13_839 VGND VGND VPWR VPWR sky130_fd_sc_hd__fill_1
X_09367_ decoded_imm\[12\] _04746_ _04824_ _04845_ VGND VGND VPWR VPWR _01018_ sky130_fd_sc_hd__o22a_1
X_06579_ _03004_ _03005_ VGND VGND VPWR VPWR _03007_ sky130_fd_sc_hd__nand2_1
XFILLER_8_309 VGND VGND VPWR VPWR sky130_fd_sc_hd__fill_2
XFILLER_40_658 VGND VGND VPWR VPWR sky130_fd_sc_hd__decap_6
XFILLER_40_669 VGND VGND VPWR VPWR sky130_fd_sc_hd__decap_6
X_09298_ net155 net117 _04206_ VGND VGND VPWR VPWR _00984_ sky130_fd_sc_hd__mux2_1
X_08318_ _04096_ _04097_ VGND VGND VPWR VPWR _00728_ sky130_fd_sc_hd__nor2_1
X_08249_ _04050_ _04051_ net34 VGND VGND VPWR VPWR _00705_ sky130_fd_sc_hd__o21a_1
X_11260_ clknet_leaf_75_clk _01307_ VGND VGND VPWR VPWR cpuregs\[22\]\[21\] sky130_fd_sc_hd__dfxtp_1
XFILLER_137_87 VGND VGND VPWR VPWR sky130_fd_sc_hd__fill_1
XFILLER_97_47 VGND VGND VPWR VPWR sky130_fd_sc_hd__decap_8
X_10211_ clknet_leaf_25_clk _00341_ VGND VGND VPWR VPWR cpuregs\[14\]\[17\] sky130_fd_sc_hd__dfxtp_1
X_11191_ clknet_leaf_19_clk _01238_ VGND VGND VPWR VPWR cpuregs\[29\]\[16\] sky130_fd_sc_hd__dfxtp_1
XFILLER_133_262 VGND VGND VPWR VPWR sky130_fd_sc_hd__decap_4
X_10142_ clknet_leaf_3_clk _00272_ VGND VGND VPWR VPWR cpuregs\[21\]\[12\] sky130_fd_sc_hd__dfxtp_1
Xoutput190 net190 VGND VGND VPWR VPWR pcpi_rs1[27] sky130_fd_sc_hd__buf_2
X_10073_ clknet_leaf_144_clk _00203_ VGND VGND VPWR VPWR cpuregs\[2\]\[7\] sky130_fd_sc_hd__dfxtp_1
XFILLER_153_53 VGND VGND VPWR VPWR sky130_fd_sc_hd__decap_3
XFILLER_0_776 VGND VGND VPWR VPWR sky130_fd_sc_hd__decap_4
XFILLER_153_97 VPWR VGND VPWR VGND sky130_ef_sc_hd__decap_12
XFILLER_87_393 VPWR VGND VPWR VGND sky130_ef_sc_hd__decap_12
XTAP_TAPCELL_ROW_18_617 VGND VPWR sky130_fd_sc_hd__tapvpwrvgnd_1
X_10975_ clknet_leaf_144_clk _01037_ VGND VGND VPWR VPWR cpuregs\[18\]\[7\] sky130_fd_sc_hd__dfxtp_1
XTAP_TAPCELL_ROW_44_1028 VGND VPWR sky130_fd_sc_hd__tapvpwrvgnd_1
XTAP_TAPCELL_ROW_139_2556 VGND VPWR sky130_fd_sc_hd__tapvpwrvgnd_1
XTAP_TAPCELL_ROW_44_1039 VGND VPWR sky130_fd_sc_hd__tapvpwrvgnd_1
XFILLER_62_94 VPWR VGND VPWR VGND sky130_ef_sc_hd__decap_12
XFILLER_12_861 VGND VGND VPWR VPWR sky130_fd_sc_hd__decap_6
XTAP_TAPCELL_ROW_152_2767 VGND VPWR sky130_fd_sc_hd__tapvpwrvgnd_1
XTAP_TAPCELL_ROW_152_2756 VGND VPWR sky130_fd_sc_hd__tapvpwrvgnd_1
XFILLER_7_353 VGND VGND VPWR VPWR sky130_fd_sc_hd__decap_8
X_11458_ clknet_leaf_69_clk _01502_ VGND VGND VPWR VPWR cpuregs\[0\]\[24\] sky130_fd_sc_hd__dfxtp_1
XFILLER_109_281 VGND VGND VPWR VPWR sky130_fd_sc_hd__decap_6
X_11389_ clknet_leaf_70_clk _01433_ VGND VGND VPWR VPWR cpuregs\[7\]\[19\] sky130_fd_sc_hd__dfxtp_1
X_10409_ clknet_leaf_52_clk _00539_ VGND VGND VPWR VPWR cpuregs\[20\]\[23\] sky130_fd_sc_hd__dfxtp_1
XTAP_TAPCELL_ROW_59_1282 VGND VPWR sky130_fd_sc_hd__tapvpwrvgnd_1
XTAP_TAPCELL_ROW_59_1271 VGND VPWR sky130_fd_sc_hd__tapvpwrvgnd_1
XFILLER_152_593 VGND VGND VPWR VPWR sky130_fd_sc_hd__decap_3
XFILLER_125_796 VPWR VGND VPWR VGND sky130_ef_sc_hd__decap_12
X_05950_ net219 _01665_ _02474_ VGND VGND VPWR VPWR net113 sky130_fd_sc_hd__a21o_1
XFILLER_79_894 VGND VGND VPWR VPWR sky130_fd_sc_hd__fill_2
XTAP_TAPCELL_ROW_72_1482 VGND VPWR sky130_fd_sc_hd__tapvpwrvgnd_1
XFILLER_23_3 VPWR VGND VPWR VGND sky130_ef_sc_hd__decap_12
X_05881_ net255 _02435_ _02437_ VGND VGND VPWR VPWR alu_out\[26\] sky130_fd_sc_hd__a21o_1
XFILLER_94_886 VGND VGND VPWR VPWR sky130_fd_sc_hd__decap_6
XFILLER_38_257 VGND VGND VPWR VPWR sky130_fd_sc_hd__fill_1
X_07620_ _02598_ cpuregs\[17\]\[4\] _03574_ VGND VGND VPWR VPWR _00552_ sky130_fd_sc_hd__mux2_1
X_07551_ cpuregs\[25\]\[2\] _02590_ _03571_ VGND VGND VPWR VPWR _00486_ sky130_fd_sc_hd__mux2_1
XTAP_TAPCELL_ROW_37_926 VGND VPWR sky130_fd_sc_hd__tapvpwrvgnd_1
XFILLER_62_761 VGND VGND VPWR VPWR sky130_fd_sc_hd__fill_1
X_06502_ cpuregs\[20\]\[7\] cpuregs\[21\]\[7\] cpuregs\[22\]\[7\] cpuregs\[23\]\[7\]
+ net268 net262 VGND VGND VPWR VPWR _02933_ sky130_fd_sc_hd__mux4_1
XFILLER_62_783 VGND VGND VPWR VPWR sky130_fd_sc_hd__decap_6
XFILLER_61_271 VGND VGND VPWR VPWR sky130_fd_sc_hd__decap_8
X_07482_ cpuregs\[26\]\[0\] _02586_ _03568_ VGND VGND VPWR VPWR _00420_ sky130_fd_sc_hd__mux2_1
X_09221_ cpuregs\[1\]\[0\] _02586_ net244 VGND VGND VPWR VPWR _00918_ sky130_fd_sc_hd__mux2_1
XFILLER_21_113 VPWR VGND VPWR VGND sky130_ef_sc_hd__decap_12
X_06433_ net201 _02720_ VGND VGND VPWR VPWR _02867_ sky130_fd_sc_hd__or2_1
X_09152_ instr_srl _04748_ _04755_ _04772_ VGND VGND VPWR VPWR _00876_ sky130_fd_sc_hd__a22o_1
X_06364_ cpu_state\[4\] net199 _02721_ _01641_ VGND VGND VPWR VPWR _02800_ sky130_fd_sc_hd__a31o_1
XFILLER_147_343 VGND VGND VPWR VPWR sky130_fd_sc_hd__fill_1
X_05315_ _01887_ _01897_ VGND VGND VPWR VPWR _01910_ sky130_fd_sc_hd__nand2b_1
X_08103_ decoded_imm_j\[19\] _03706_ VGND VGND VPWR VPWR _03917_ sky130_fd_sc_hd__and2_1
XTAP_TAPCELL_ROW_79_1603 VGND VPWR sky130_fd_sc_hd__tapvpwrvgnd_1
X_09083_ mem_rdata_q\[4\] net27 _01609_ VGND VGND VPWR VPWR _01098_ sky130_fd_sc_hd__mux2_1
X_06295_ _01580_ _02728_ _02732_ _00016_ VGND VGND VPWR VPWR _02733_ sky130_fd_sc_hd__a211o_1
XTAP_TAPCELL_ROW_92_1803 VGND VPWR sky130_fd_sc_hd__tapvpwrvgnd_1
X_08034_ _01547_ reg_next_pc\[13\] _01645_ _03700_ VGND VGND VPWR VPWR _03854_ sky130_fd_sc_hd__a22o_1
X_05246_ _01771_ _01846_ cpu_state\[6\] VGND VGND VPWR VPWR _01847_ sky130_fd_sc_hd__o21a_1
X_05177_ _01767_ _01770_ _01781_ VGND VGND VPWR VPWR _01783_ sky130_fd_sc_hd__nand3_1
XFILLER_131_711 VGND VGND VPWR VPWR sky130_fd_sc_hd__fill_1
XFILLER_116_785 VPWR VGND VPWR VGND sky130_ef_sc_hd__decap_12
XFILLER_107_57 VGND VGND VPWR VPWR sky130_fd_sc_hd__decap_8
XFILLER_103_446 VGND VGND VPWR VPWR sky130_fd_sc_hd__fill_2
X_09985_ clknet_leaf_15_clk _00115_ VGND VGND VPWR VPWR cpuregs\[12\]\[15\] sky130_fd_sc_hd__dfxtp_1
X_08936_ cpuregs\[20\]\[25\] cpuregs\[21\]\[25\] cpuregs\[22\]\[25\] cpuregs\[23\]\[25\]
+ net280 net274 VGND VGND VPWR VPWR _04613_ sky130_fd_sc_hd__mux4_1
X_08867_ cpuregs\[0\]\[21\] cpuregs\[1\]\[21\] cpuregs\[2\]\[21\] cpuregs\[3\]\[21\]
+ _00007_ net274 VGND VGND VPWR VPWR _04548_ sky130_fd_sc_hd__mux4_1
XPHY_EDGE_ROW_95_Left_249 VGND VGND VPWR VPWR sky130_fd_sc_hd__decap_3
XTAP_TAPCELL_ROW_123_2302 VGND VPWR sky130_fd_sc_hd__tapvpwrvgnd_1
X_07818_ _03683_ net34 _03682_ VGND VGND VPWR VPWR _00642_ sky130_fd_sc_hd__and3b_1
XFILLER_85_897 VGND VGND VPWR VPWR sky130_fd_sc_hd__decap_3
XFILLER_85_864 VGND VGND VPWR VPWR sky130_fd_sc_hd__decap_8
XFILLER_84_363 VGND VGND VPWR VPWR sky130_fd_sc_hd__fill_1
XFILLER_57_566 VGND VGND VPWR VPWR sky130_fd_sc_hd__decap_8
XTAP_TAPCELL_ROW_4_389 VGND VPWR sky130_fd_sc_hd__tapvpwrvgnd_1
X_08798_ cpuregs\[20\]\[17\] cpuregs\[21\]\[17\] cpuregs\[22\]\[17\] cpuregs\[23\]\[17\]
+ net277 net272 VGND VGND VPWR VPWR _04483_ sky130_fd_sc_hd__mux4_1
X_07749_ _03639_ _03640_ VGND VGND VPWR VPWR _00616_ sky130_fd_sc_hd__nor2_1
X_10760_ clknet_leaf_18_clk alu_out\[13\] VGND VGND VPWR VPWR alu_out_q\[13\] sky130_fd_sc_hd__dfxtp_1
XFILLER_16_65 VPWR VGND VPWR VGND sky130_ef_sc_hd__decap_12
XFILLER_25_474 VGND VGND VPWR VPWR sky130_fd_sc_hd__decap_3
XFILLER_40_411 VGND VGND VPWR VPWR sky130_fd_sc_hd__fill_2
X_09419_ _02678_ cpuregs\[18\]\[23\] _04862_ VGND VGND VPWR VPWR _01053_ sky130_fd_sc_hd__mux2_1
X_10691_ clknet_leaf_83_clk _00789_ VGND VGND VPWR VPWR net44 sky130_fd_sc_hd__dfxtp_1
XTAP_TAPCELL_ROW_101_1943 VGND VPWR sky130_fd_sc_hd__tapvpwrvgnd_1
XFILLER_12_135 VGND VGND VPWR VPWR sky130_fd_sc_hd__decap_4
XFILLER_139_833 VGND VGND VPWR VPWR sky130_fd_sc_hd__decap_6
XTAP_TAPCELL_ROW_101_1954 VGND VPWR sky130_fd_sc_hd__tapvpwrvgnd_1
XFILLER_9_629 VPWR VGND VPWR VGND sky130_ef_sc_hd__decap_12
XFILLER_139_877 VPWR VGND VPWR VGND sky130_ef_sc_hd__decap_12
XFILLER_8_139 VGND VGND VPWR VPWR sky130_fd_sc_hd__fill_1
XTAP_TAPCELL_ROW_23_697 VGND VPWR sky130_fd_sc_hd__tapvpwrvgnd_1
XFILLER_148_53 VPWR VGND VPWR VGND sky130_ef_sc_hd__decap_12
XFILLER_138_365 VGND VGND VPWR VPWR sky130_fd_sc_hd__decap_4
XFILLER_138_354 VGND VGND VPWR VPWR sky130_fd_sc_hd__fill_1
XFILLER_126_505 VPWR VGND VPWR VGND sky130_ef_sc_hd__decap_12
XFILLER_148_97 VPWR VGND VPWR VGND sky130_ef_sc_hd__decap_12
XFILLER_138_398 VGND VGND VPWR VPWR sky130_fd_sc_hd__fill_2
XTAP_TAPCELL_ROW_134_2475 VGND VPWR sky130_fd_sc_hd__tapvpwrvgnd_1
X_11312_ clknet_leaf_150_clk _01359_ VGND VGND VPWR VPWR cpuregs\[5\]\[9\] sky130_fd_sc_hd__dfxtp_1
XFILLER_153_357 VGND VGND VPWR VPWR sky130_fd_sc_hd__decap_3
XFILLER_106_251 VGND VGND VPWR VPWR sky130_fd_sc_hd__fill_1
XFILLER_4_345 VPWR VGND VPWR VGND sky130_ef_sc_hd__decap_12
X_11243_ clknet_leaf_137_clk _01290_ VGND VGND VPWR VPWR cpuregs\[22\]\[4\] sky130_fd_sc_hd__dfxtp_1
XFILLER_134_582 VGND VGND VPWR VPWR sky130_fd_sc_hd__decap_6
XFILLER_107_785 VGND VGND VPWR VPWR sky130_fd_sc_hd__decap_3
XFILLER_79_113 VGND VGND VPWR VPWR sky130_fd_sc_hd__fill_2
XFILLER_4_389 VPWR VGND VPWR VGND sky130_ef_sc_hd__decap_12
X_11174_ clknet_leaf_16_clk _01221_ VGND VGND VPWR VPWR cpuregs\[23\]\[31\] sky130_fd_sc_hd__dfxtp_1
X_10125_ clknet_leaf_42_clk _00255_ VGND VGND VPWR VPWR cpuregs\[28\]\[27\] sky130_fd_sc_hd__dfxtp_1
XFILLER_95_617 VPWR VGND VPWR VGND sky130_ef_sc_hd__decap_12
XFILLER_76_820 VGND VGND VPWR VPWR sky130_fd_sc_hd__decap_8
XTAP_TAPCELL_ROW_54_1190 VGND VPWR sky130_fd_sc_hd__tapvpwrvgnd_1
X_10056_ clknet_leaf_48_clk _00186_ VGND VGND VPWR VPWR cpuregs\[13\]\[22\] sky130_fd_sc_hd__dfxtp_1
XFILLER_121_287 VGND VGND VPWR VPWR sky130_fd_sc_hd__fill_1
XFILLER_87_190 VGND VGND VPWR VPWR sky130_fd_sc_hd__decap_4
XFILLER_57_61 VGND VGND VPWR VPWR sky130_fd_sc_hd__fill_1
XFILLER_48_533 VGND VGND VPWR VPWR sky130_fd_sc_hd__decap_6
XFILLER_0_584 VGND VGND VPWR VPWR sky130_fd_sc_hd__decap_4
XFILLER_75_385 VGND VGND VPWR VPWR sky130_fd_sc_hd__fill_2
XFILLER_63_547 VGND VGND VPWR VPWR sky130_fd_sc_hd__fill_2
XFILLER_63_569 VGND VGND VPWR VPWR sky130_fd_sc_hd__decap_3
XFILLER_51_709 VGND VGND VPWR VPWR sky130_fd_sc_hd__decap_4
XFILLER_90_399 VGND VGND VPWR VPWR sky130_fd_sc_hd__fill_1
X_10958_ clknet_leaf_97_clk _01020_ VGND VGND VPWR VPWR decoded_imm\[10\] sky130_fd_sc_hd__dfxtp_2
XFILLER_31_411 VGND VGND VPWR VPWR sky130_fd_sc_hd__fill_1
XFILLER_43_260 VGND VGND VPWR VPWR sky130_fd_sc_hd__decap_6
XFILLER_31_444 VGND VGND VPWR VPWR sky130_fd_sc_hd__decap_4
X_10889_ clknet_leaf_102_clk _00951_ VGND VGND VPWR VPWR is_alu_reg_reg sky130_fd_sc_hd__dfxtp_1
XFILLER_117_505 VPWR VGND VPWR VGND sky130_ef_sc_hd__decap_12
XFILLER_11_190 VPWR VGND VPWR VGND sky130_ef_sc_hd__decap_12
X_05100_ count_instr\[3\] instr_rdinstr net257 _01711_ VGND VGND VPWR VPWR _01712_
+ sky130_fd_sc_hd__a211o_1
X_06080_ cpuregs\[28\]\[3\] cpuregs\[29\]\[3\] cpuregs\[30\]\[3\] cpuregs\[31\]\[3\]
+ net279 _00008_ VGND VGND VPWR VPWR _02552_ sky130_fd_sc_hd__mux4_1
XFILLER_7_161 VGND VGND VPWR VPWR sky130_fd_sc_hd__decap_6
XFILLER_113_700 VGND VGND VPWR VPWR sky130_fd_sc_hd__decap_4
XTAP_TAPCELL_ROW_74_1522 VGND VPWR sky130_fd_sc_hd__tapvpwrvgnd_1
XTAP_TAPCELL_ROW_74_1511 VGND VPWR sky130_fd_sc_hd__tapvpwrvgnd_1
X_05031_ _01606_ _01652_ VGND VGND VPWR VPWR _00019_ sky130_fd_sc_hd__nor2_1
XPHY_EDGE_ROW_9_Right_9 VGND VGND VPWR VPWR sky130_fd_sc_hd__decap_3
XPHY_EDGE_ROW_107_Right_107 VGND VGND VPWR VPWR sky130_fd_sc_hd__decap_3
X_06982_ _02714_ _03377_ _03379_ _03380_ _03395_ VGND VGND VPWR VPWR _03396_ sky130_fd_sc_hd__o41a_1
XFILLER_98_477 VGND VGND VPWR VPWR sky130_fd_sc_hd__decap_6
X_09770_ _02624_ cpuregs\[7\]\[10\] _04874_ VGND VGND VPWR VPWR _01424_ sky130_fd_sc_hd__mux2_1
X_08721_ cpuregs\[12\]\[13\] cpuregs\[13\]\[13\] cpuregs\[14\]\[13\] cpuregs\[15\]\[13\]
+ net275 net271 VGND VGND VPWR VPWR _04410_ sky130_fd_sc_hd__mux4_1
X_05933_ mem_wordsize\[1\] net122 net205 _01672_ VGND VGND VPWR VPWR net99 sky130_fd_sc_hd__a22o_1
XFILLER_27_717 VGND VGND VPWR VPWR sky130_fd_sc_hd__decap_6
X_08652_ _01558_ _04335_ net269 VGND VGND VPWR VPWR _04345_ sky130_fd_sc_hd__o21a_1
X_07603_ cpuregs\[20\]\[20\] _02665_ _03573_ VGND VGND VPWR VPWR _00536_ sky130_fd_sc_hd__mux2_1
X_05864_ _02058_ _02238_ _02422_ _02059_ VGND VGND VPWR VPWR _02423_ sky130_fd_sc_hd__o2bb2a_1
XTAP_TAPCELL_ROW_105_2010 VGND VPWR sky130_fd_sc_hd__tapvpwrvgnd_1
XFILLER_67_897 VGND VGND VPWR VPWR sky130_fd_sc_hd__fill_2
XFILLER_54_536 VPWR VGND VPWR VGND sky130_ef_sc_hd__decap_12
XFILLER_54_514 VGND VGND VPWR VPWR sky130_fd_sc_hd__fill_1
XTAP_TAPCELL_ROW_1_348 VGND VPWR sky130_fd_sc_hd__tapvpwrvgnd_1
X_05795_ _02110_ _02240_ _02360_ VGND VGND VPWR VPWR _02361_ sky130_fd_sc_hd__a21o_1
X_08583_ decoded_imm\[5\] _01654_ _01586_ VGND VGND VPWR VPWR _04280_ sky130_fd_sc_hd__a21o_1
X_07534_ _02657_ cpuregs\[16\]\[18\] _03570_ VGND VGND VPWR VPWR _00470_ sky130_fd_sc_hd__mux2_1
XTAP_TAPCELL_ROW_85_1684 VGND VPWR sky130_fd_sc_hd__tapvpwrvgnd_1
XTAP_TAPCELL_ROW_85_1695 VGND VPWR sky130_fd_sc_hd__tapvpwrvgnd_1
X_07465_ cpuregs\[15\]\[16\] _02649_ net246 VGND VGND VPWR VPWR _00404_ sky130_fd_sc_hd__mux2_1
XFILLER_10_606 VPWR VGND VPWR VGND sky130_ef_sc_hd__decap_12
X_06416_ cpuregs\[2\]\[4\] cpuregs\[3\]\[4\] net263 VGND VGND VPWR VPWR _02850_ sky130_fd_sc_hd__mux2_1
X_09204_ decoded_rd\[4\] _01105_ _02513_ VGND VGND VPWR VPWR _00902_ sky130_fd_sc_hd__mux2_1
X_07396_ cpuregs\[14\]\[14\] _02641_ net247 VGND VGND VPWR VPWR _00338_ sky130_fd_sc_hd__mux2_1
Xrebuffer203 latched_stalu VGND VGND VPWR VPWR net589 sky130_fd_sc_hd__clkbuf_2
Xrebuffer214 latched_store VGND VGND VPWR VPWR net600 sky130_fd_sc_hd__dlymetal6s2s_1
XFILLER_136_825 VPWR VGND VPWR VGND sky130_ef_sc_hd__decap_12
Xrebuffer225 net610 VGND VGND VPWR VPWR net611 sky130_fd_sc_hd__dlymetal6s4s_1
X_09135_ instr_sw _04747_ _04763_ is_sb_sh_sw VGND VGND VPWR VPWR _00867_ sky130_fd_sc_hd__a22o_1
X_06347_ _01578_ _02782_ VGND VGND VPWR VPWR _02783_ sky130_fd_sc_hd__or2_1
XTAP_TAPCELL_ROW_20_645 VGND VPWR sky130_fd_sc_hd__tapvpwrvgnd_1
XTAP_TAPCELL_ROW_20_656 VGND VPWR sky130_fd_sc_hd__tapvpwrvgnd_1
XFILLER_136_869 VPWR VGND VPWR VGND sky130_ef_sc_hd__decap_12
X_06278_ cpu_state\[2\] cpu_state\[4\] VGND VGND VPWR VPWR _02716_ sky130_fd_sc_hd__nor2_1
X_09066_ is_beq_bne_blt_bge_bltu_bgeu instr_jalr VGND VGND VPWR VPWR _04734_ sky130_fd_sc_hd__or2_1
XTAP_TAPCELL_ROW_116_2194 VGND VPWR sky130_fd_sc_hd__tapvpwrvgnd_1
XTAP_TAPCELL_ROW_116_2183 VGND VPWR sky130_fd_sc_hd__tapvpwrvgnd_1
X_05229_ _01812_ _01830_ VGND VGND VPWR VPWR _01831_ sky130_fd_sc_hd__and2_1
X_08017_ _01547_ reg_next_pc\[12\] _01645_ _03699_ VGND VGND VPWR VPWR _03838_ sky130_fd_sc_hd__a22o_1
XFILLER_2_805 VGND VGND VPWR VPWR sky130_fd_sc_hd__decap_6
XFILLER_151_839 VGND VGND VPWR VPWR sky130_fd_sc_hd__fill_1
XFILLER_78_27 VGND VGND VPWR VPWR sky130_fd_sc_hd__fill_1
XFILLER_2_849 VPWR VGND VPWR VGND sky130_ef_sc_hd__decap_12
XFILLER_131_585 VGND VGND VPWR VPWR sky130_fd_sc_hd__decap_6
X_09968_ clknet_leaf_58_clk _00098_ VGND VGND VPWR VPWR net192 sky130_fd_sc_hd__dfxtp_4
XFILLER_89_477 VGND VGND VPWR VPWR sky130_fd_sc_hd__fill_1
XFILLER_77_617 VPWR VGND VPWR VGND sky130_ef_sc_hd__decap_12
XFILLER_49_319 VGND VGND VPWR VPWR sky130_fd_sc_hd__decap_8
X_08919_ cpuregs\[8\]\[24\] cpuregs\[9\]\[24\] cpuregs\[10\]\[24\] cpuregs\[11\]\[24\]
+ net280 net274 VGND VGND VPWR VPWR _04597_ sky130_fd_sc_hd__mux4_1
XFILLER_58_820 VGND VGND VPWR VPWR sky130_fd_sc_hd__decap_4
X_09899_ cpuregs\[0\]\[29\] VGND VGND VPWR VPWR _01507_ sky130_fd_sc_hd__clkbuf_1
XFILLER_69_190 VPWR VGND VPWR VGND sky130_ef_sc_hd__decap_12
XFILLER_18_717 VGND VGND VPWR VPWR sky130_fd_sc_hd__fill_1
XFILLER_18_739 VGND VGND VPWR VPWR sky130_fd_sc_hd__fill_1
XFILLER_45_536 VPWR VGND VPWR VGND sky130_ef_sc_hd__decap_12
XFILLER_150_65 VPWR VGND VPWR VGND sky130_ef_sc_hd__decap_12
XFILLER_84_193 VGND VGND VPWR VPWR sky130_fd_sc_hd__decap_3
XFILLER_27_86 VPWR VGND VPWR VGND sky130_ef_sc_hd__decap_12
XFILLER_72_377 VGND VGND VPWR VPWR sky130_fd_sc_hd__decap_4
X_10812_ clknet_leaf_97_clk _00877_ VGND VGND VPWR VPWR instr_sra sky130_fd_sc_hd__dfxtp_1
XFILLER_25_260 VGND VGND VPWR VPWR sky130_fd_sc_hd__decap_4
XTAP_TAPCELL_ROW_28_778 VGND VPWR sky130_fd_sc_hd__tapvpwrvgnd_1
X_10743_ clknet_leaf_101_clk _00840_ VGND VGND VPWR VPWR latched_branch sky130_fd_sc_hd__dfxtp_4
XTAP_TAPCELL_ROW_136_2504 VGND VPWR sky130_fd_sc_hd__tapvpwrvgnd_1
XFILLER_13_444 VGND VGND VPWR VPWR sky130_fd_sc_hd__decap_4
XFILLER_41_775 VGND VGND VPWR VPWR sky130_fd_sc_hd__decap_8
XTAP_TAPCELL_ROW_136_2515 VGND VPWR sky130_fd_sc_hd__tapvpwrvgnd_1
X_10674_ clknet_leaf_122_clk _00772_ VGND VGND VPWR VPWR net55 sky130_fd_sc_hd__dfxtp_1
XFILLER_5_610 VGND VGND VPWR VPWR sky130_fd_sc_hd__fill_2
XFILLER_5_665 VGND VGND VPWR VPWR sky130_fd_sc_hd__decap_6
XFILLER_153_165 VGND VGND VPWR VPWR sky130_fd_sc_hd__decap_3
XFILLER_141_305 VPWR VGND VPWR VGND sky130_ef_sc_hd__decap_12
XTAP_TAPCELL_ROW_56_1230 VGND VPWR sky130_fd_sc_hd__tapvpwrvgnd_1
XFILLER_4_153 VPWR VGND VPWR VGND sky130_ef_sc_hd__decap_12
X_11226_ clknet_leaf_71_clk _01273_ VGND VGND VPWR VPWR cpuregs\[3\]\[19\] sky130_fd_sc_hd__dfxtp_1
XFILLER_4_197 VPWR VGND VPWR VGND sky130_ef_sc_hd__decap_12
XFILLER_150_861 VGND VGND VPWR VPWR sky130_fd_sc_hd__decap_6
X_11157_ clknet_leaf_28_clk _01204_ VGND VGND VPWR VPWR cpuregs\[23\]\[14\] sky130_fd_sc_hd__dfxtp_1
XFILLER_68_639 VGND VGND VPWR VPWR sky130_fd_sc_hd__decap_4
XFILLER_110_736 VGND VGND VPWR VPWR sky130_fd_sc_hd__decap_4
X_10108_ clknet_leaf_14_clk _00238_ VGND VGND VPWR VPWR cpuregs\[28\]\[10\] sky130_fd_sc_hd__dfxtp_1
XTAP_TAPCELL_ROW_147_2688 VGND VPWR sky130_fd_sc_hd__tapvpwrvgnd_1
XTAP_TAPCELL_ROW_147_2677 VGND VPWR sky130_fd_sc_hd__tapvpwrvgnd_1
X_11088_ clknet_leaf_73_clk _01145_ VGND VGND VPWR VPWR cpuregs\[24\]\[19\] sky130_fd_sc_hd__dfxtp_1
XFILLER_95_469 VGND VGND VPWR VPWR sky130_fd_sc_hd__decap_6
XFILLER_49_853 VGND VGND VPWR VPWR sky130_fd_sc_hd__decap_3
XFILLER_49_897 VGND VGND VPWR VPWR sky130_fd_sc_hd__decap_4
XFILLER_48_363 VGND VGND VPWR VPWR sky130_fd_sc_hd__fill_1
X_10039_ clknet_leaf_139_clk _00169_ VGND VGND VPWR VPWR cpuregs\[13\]\[5\] sky130_fd_sc_hd__dfxtp_1
XFILLER_90_141 VGND VGND VPWR VPWR sky130_fd_sc_hd__decap_6
XFILLER_64_867 VGND VGND VPWR VPWR sky130_fd_sc_hd__fill_1
XFILLER_90_163 VGND VGND VPWR VPWR sky130_fd_sc_hd__decap_3
X_05580_ net199 net125 VGND VGND VPWR VPWR _02163_ sky130_fd_sc_hd__nor2_1
XFILLER_17_783 VGND VGND VPWR VPWR sky130_fd_sc_hd__fill_1
XFILLER_32_753 VGND VGND VPWR VPWR sky130_fd_sc_hd__decap_3
XFILLER_149_449 VPWR VGND VPWR VGND sky130_ef_sc_hd__decap_12
X_07250_ cpuregs\[2\]\[1\] _02588_ _03559_ VGND VGND VPWR VPWR _00197_ sky130_fd_sc_hd__mux2_1
XFILLER_31_285 VGND VGND VPWR VPWR sky130_fd_sc_hd__fill_1
X_06201_ _02650_ _02653_ _02584_ VGND VGND VPWR VPWR _02654_ sky130_fd_sc_hd__mux2_8
X_07181_ _03554_ _03555_ VGND VGND VPWR VPWR _03556_ sky130_fd_sc_hd__nor2_8
X_06132_ _02594_ _02597_ _02584_ VGND VGND VPWR VPWR _02598_ sky130_fd_sc_hd__mux2_8
XFILLER_118_869 VPWR VGND VPWR VGND sky130_ef_sc_hd__decap_12
XFILLER_144_165 VPWR VGND VPWR VGND sky130_ef_sc_hd__decap_12
XFILLER_133_839 VGND VGND VPWR VPWR sky130_fd_sc_hd__fill_1
X_06063_ _02531_ _02535_ _02524_ _02527_ VGND VGND VPWR VPWR _02536_ sky130_fd_sc_hd__o211a_1
X_05014_ reg_sh\[1\] reg_sh\[0\] VGND VGND VPWR VPWR _01637_ sky130_fd_sc_hd__or2_1
X_09822_ _02704_ cpuregs\[8\]\[29\] _04875_ VGND VGND VPWR VPWR _01475_ sky130_fd_sc_hd__mux2_1
XFILLER_99_797 VGND VGND VPWR VPWR sky130_fd_sc_hd__decap_8
XFILLER_48_19 VGND VGND VPWR VPWR sky130_fd_sc_hd__decap_8
XTAP_TAPCELL_ROW_6_429 VGND VPWR sky130_fd_sc_hd__tapvpwrvgnd_1
X_09753_ _02691_ cpuregs\[6\]\[26\] _04873_ VGND VGND VPWR VPWR _01408_ sky130_fd_sc_hd__mux2_1
X_06965_ net183 _02721_ _02744_ _03378_ VGND VGND VPWR VPWR _03379_ sky130_fd_sc_hd__o211a_1
X_08704_ _01558_ _04393_ VGND VGND VPWR VPWR _04394_ sky130_fd_sc_hd__or2_1
XFILLER_39_341 VGND VGND VPWR VPWR sky130_fd_sc_hd__fill_1
X_06896_ _03307_ _03308_ _03311_ _03312_ _01579_ _01581_ VGND VGND VPWR VPWR _03313_
+ sky130_fd_sc_hd__mux4_1
X_09684_ cpuregs\[4\]\[23\] _02678_ net238 VGND VGND VPWR VPWR _01341_ sky130_fd_sc_hd__mux2_1
X_05916_ instr_sub _02068_ VGND VGND VPWR VPWR _02468_ sky130_fd_sc_hd__nor2_1
XTAP_TAPCELL_ROW_87_1724 VGND VPWR sky130_fd_sc_hd__tapvpwrvgnd_1
XFILLER_39_363 VGND VGND VPWR VPWR sky130_fd_sc_hd__decap_8
X_05847_ _02087_ _02399_ VGND VGND VPWR VPWR _02407_ sky130_fd_sc_hd__nor2_1
XFILLER_70_804 VGND VGND VPWR VPWR sky130_fd_sc_hd__fill_1
XFILLER_64_29 VPWR VGND VPWR VGND sky130_ef_sc_hd__decap_12
X_08635_ _04319_ _04327_ _04328_ _01560_ _00010_ VGND VGND VPWR VPWR _04329_ sky130_fd_sc_hd__a221o_1
XFILLER_82_686 VPWR VGND VPWR VGND sky130_ef_sc_hd__decap_12
X_08566_ cpuregs\[28\]\[5\] cpuregs\[29\]\[5\] cpuregs\[30\]\[5\] cpuregs\[31\]\[5\]
+ net279 _00008_ VGND VGND VPWR VPWR _04263_ sky130_fd_sc_hd__mux4_1
X_05778_ _02147_ _02238_ _02240_ _02149_ _02345_ VGND VGND VPWR VPWR _02346_ sky130_fd_sc_hd__a221o_1
X_07517_ _02588_ cpuregs\[16\]\[1\] _03570_ VGND VGND VPWR VPWR _00453_ sky130_fd_sc_hd__mux2_1
XTAP_TAPCELL_ROW_25_726 VGND VPWR sky130_fd_sc_hd__tapvpwrvgnd_1
XTAP_TAPCELL_ROW_25_737 VGND VPWR sky130_fd_sc_hd__tapvpwrvgnd_1
XFILLER_42_539 VGND VGND VPWR VPWR sky130_fd_sc_hd__fill_1
X_08497_ net81 net50 _04208_ VGND VGND VPWR VPWR _00795_ sky130_fd_sc_hd__mux2_1
XFILLER_50_550 VGND VGND VPWR VPWR sky130_fd_sc_hd__decap_6
XTAP_TAPCELL_ROW_118_2223 VGND VPWR sky130_fd_sc_hd__tapvpwrvgnd_1
XTAP_TAPCELL_ROW_118_2212 VGND VPWR sky130_fd_sc_hd__tapvpwrvgnd_1
XFILLER_23_797 VPWR VGND VPWR VGND sky130_ef_sc_hd__decap_12
X_07448_ _02581_ _03551_ VGND VGND VPWR VPWR _03567_ sky130_fd_sc_hd__nor2_2
X_07379_ _02709_ cpuregs\[9\]\[30\] _03563_ VGND VGND VPWR VPWR _00322_ sky130_fd_sc_hd__mux2_1
XFILLER_6_407 VPWR VGND VPWR VGND sky130_ef_sc_hd__decap_12
XFILLER_13_55 VGND VGND VPWR VPWR sky130_fd_sc_hd__fill_1
XFILLER_129_55 VGND VGND VPWR VPWR sky130_fd_sc_hd__fill_1
XFILLER_109_858 VGND VGND VPWR VPWR sky130_fd_sc_hd__decap_8
X_09118_ _01556_ mem_rdata_q\[13\] _01557_ VGND VGND VPWR VPWR _04761_ sky130_fd_sc_hd__and3_1
XFILLER_151_603 VGND VGND VPWR VPWR sky130_fd_sc_hd__decap_3
XTAP_TAPCELL_ROW_131_2434 VGND VPWR sky130_fd_sc_hd__tapvpwrvgnd_1
XTAP_TAPCELL_ROW_131_2423 VGND VPWR sky130_fd_sc_hd__tapvpwrvgnd_1
XTAP_TAPCELL_ROW_98_1897 VGND VPWR sky130_fd_sc_hd__tapvpwrvgnd_1
X_10390_ clknet_leaf_138_clk _00520_ VGND VGND VPWR VPWR cpuregs\[20\]\[4\] sky130_fd_sc_hd__dfxtp_1
XFILLER_123_305 VGND VGND VPWR VPWR sky130_fd_sc_hd__decap_4
X_09049_ cpuregs\[0\]\[31\] cpuregs\[1\]\[31\] cpuregs\[2\]\[31\] cpuregs\[3\]\[31\]
+ net277 net272 VGND VGND VPWR VPWR _04720_ sky130_fd_sc_hd__mux4_1
XFILLER_2_657 VPWR VGND VPWR VGND sky130_ef_sc_hd__decap_12
XFILLER_132_861 VGND VGND VPWR VPWR sky130_fd_sc_hd__decap_6
XFILLER_89_252 VGND VGND VPWR VPWR sky130_fd_sc_hd__decap_3
XFILLER_1_167 VGND VGND VPWR VPWR sky130_fd_sc_hd__fill_1
X_11011_ clknet_leaf_149_clk _01073_ VGND VGND VPWR VPWR cpuregs\[19\]\[11\] sky130_fd_sc_hd__dfxtp_1
XFILLER_38_41 VGND VGND VPWR VPWR sky130_fd_sc_hd__decap_8
XTAP_TAPCELL_ROW_129_2396 VGND VPWR sky130_fd_sc_hd__tapvpwrvgnd_1
XFILLER_92_417 VGND VGND VPWR VPWR sky130_fd_sc_hd__decap_3
XFILLER_38_85 VGND VGND VPWR VPWR sky130_fd_sc_hd__decap_3
XFILLER_100_791 VPWR VGND VPWR VGND sky130_ef_sc_hd__decap_12
XTAP_TAPCELL_ROW_142_2596 VGND VPWR sky130_fd_sc_hd__tapvpwrvgnd_1
XFILLER_54_40 VGND VGND VPWR VPWR sky130_fd_sc_hd__decap_6
XFILLER_60_336 VGND VGND VPWR VPWR sky130_fd_sc_hd__decap_4
XFILLER_14_753 VGND VGND VPWR VPWR sky130_fd_sc_hd__decap_3
X_10726_ clknet_leaf_57_clk _00823_ VGND VGND VPWR VPWR net211 sky130_fd_sc_hd__dfxtp_4
X_10657_ clknet_leaf_94_clk _04884_ VGND VGND VPWR VPWR reg_out\[15\] sky130_fd_sc_hd__dfxtp_1
Xclkload26 clknet_leaf_11_clk VGND VGND VPWR VPWR clkload26/Y sky130_fd_sc_hd__clkinv_2
Xclkload15 clknet_leaf_4_clk VGND VGND VPWR VPWR clkload15/Y sky130_fd_sc_hd__inv_6
XFILLER_127_666 VGND VGND VPWR VPWR sky130_fd_sc_hd__decap_6
Xclkload59 clknet_leaf_37_clk VGND VGND VPWR VPWR clkload59/Y sky130_fd_sc_hd__inv_12
XFILLER_115_806 VGND VGND VPWR VPWR sky130_fd_sc_hd__decap_3
Xclkload48 clknet_leaf_24_clk VGND VGND VPWR VPWR clkload48/Y sky130_fd_sc_hd__clkinv_2
X_10588_ clknet_leaf_104_clk _00718_ VGND VGND VPWR VPWR count_cycle\[11\] sky130_fd_sc_hd__dfxtp_1
XFILLER_62_7 VGND VGND VPWR VPWR sky130_fd_sc_hd__fill_1
Xclkload37 clknet_leaf_148_clk VGND VGND VPWR VPWR clkload37/Y sky130_fd_sc_hd__inv_6
XTAP_TAPCELL_ROW_149_2717 VGND VPWR sky130_fd_sc_hd__tapvpwrvgnd_1
XFILLER_141_113 VGND VGND VPWR VPWR sky130_fd_sc_hd__decap_4
XFILLER_114_349 VPWR VGND VPWR VGND sky130_ef_sc_hd__decap_12
X_11209_ clknet_leaf_121_clk _01256_ VGND VGND VPWR VPWR cpuregs\[3\]\[2\] sky130_fd_sc_hd__dfxtp_1
XFILLER_123_894 VGND VGND VPWR VPWR sky130_fd_sc_hd__fill_2
XFILLER_110_533 VPWR VGND VPWR VGND sky130_ef_sc_hd__decap_12
X_06750_ cpuregs\[16\]\[16\] cpuregs\[17\]\[16\] cpuregs\[18\]\[16\] cpuregs\[19\]\[16\]
+ net265 net260 VGND VGND VPWR VPWR _03172_ sky130_fd_sc_hd__mux4_1
XFILLER_95_277 VGND VGND VPWR VPWR sky130_fd_sc_hd__decap_3
XFILLER_95_91 VGND VGND VPWR VPWR sky130_fd_sc_hd__decap_8
X_06681_ reg_pc\[13\] _02751_ _03105_ _02715_ VGND VGND VPWR VPWR _03106_ sky130_fd_sc_hd__a211o_1
XTAP_TAPCELL_ROW_69_1443 VGND VPWR sky130_fd_sc_hd__tapvpwrvgnd_1
XTAP_TAPCELL_ROW_69_1432 VGND VPWR sky130_fd_sc_hd__tapvpwrvgnd_1
X_05701_ _02164_ _02276_ _02277_ VGND VGND VPWR VPWR _02278_ sky130_fd_sc_hd__a21oi_1
X_08420_ count_cycle\[59\] _04159_ net34 VGND VGND VPWR VPWR _04162_ sky130_fd_sc_hd__o21ai_1
X_05632_ _01564_ net213 _02213_ _02214_ VGND VGND VPWR VPWR _02215_ sky130_fd_sc_hd__o211a_1
XFILLER_37_889 VGND VGND VPWR VPWR sky130_fd_sc_hd__decap_6
XFILLER_63_185 VGND VGND VPWR VPWR sky130_fd_sc_hd__fill_1
XFILLER_51_314 VGND VGND VPWR VPWR sky130_fd_sc_hd__decap_8
XTAP_TAPCELL_ROW_82_1643 VGND VPWR sky130_fd_sc_hd__tapvpwrvgnd_1
X_05563_ _02144_ _02145_ VGND VGND VPWR VPWR _02146_ sky130_fd_sc_hd__and2b_1
X_08351_ _04118_ net34 _04117_ VGND VGND VPWR VPWR _00740_ sky130_fd_sc_hd__and3b_1
X_07302_ cpuregs\[28\]\[20\] _02665_ _03560_ VGND VGND VPWR VPWR _00248_ sky130_fd_sc_hd__mux2_1
X_05494_ net191 net223 VGND VGND VPWR VPWR _02077_ sky130_fd_sc_hd__or2_1
X_08282_ count_cycle\[9\] _04072_ net34 VGND VGND VPWR VPWR _04074_ sky130_fd_sc_hd__o21ai_1
XFILLER_20_701 VGND VGND VPWR VPWR sky130_fd_sc_hd__decap_6
XFILLER_149_279 VGND VGND VPWR VPWR sky130_fd_sc_hd__fill_1
XFILLER_137_408 VGND VGND VPWR VPWR sky130_fd_sc_hd__fill_1
X_07233_ cpuregs\[13\]\[17\] _02654_ net251 VGND VGND VPWR VPWR _00181_ sky130_fd_sc_hd__mux2_1
Xclkload9 clknet_4_11_0_clk VGND VGND VPWR VPWR clkload9/X sky130_fd_sc_hd__clkbuf_8
X_07164_ cpuregs\[12\]\[18\] _02657_ net253 VGND VGND VPWR VPWR _00118_ sky130_fd_sc_hd__mux2_1
XFILLER_118_699 VGND VGND VPWR VPWR sky130_fd_sc_hd__fill_1
XTAP_TAPCELL_ROW_113_2142 VGND VPWR sky130_fd_sc_hd__tapvpwrvgnd_1
X_07095_ _03476_ _03479_ VGND VGND VPWR VPWR _03504_ sky130_fd_sc_hd__nand2_1
X_06115_ reg_out\[0\] alu_out_q\[0\] net587 VGND VGND VPWR VPWR _02585_ sky130_fd_sc_hd__mux2_1
XFILLER_145_496 VGND VGND VPWR VPWR sky130_fd_sc_hd__decap_8
XFILLER_121_809 VPWR VGND VPWR VGND sky130_ef_sc_hd__decap_12
X_06046_ _00009_ _02518_ VGND VGND VPWR VPWR _02519_ sky130_fd_sc_hd__or2_1
XFILLER_132_179 VPWR VGND VPWR VGND sky130_ef_sc_hd__decap_12
XFILLER_132_157 VGND VGND VPWR VPWR sky130_fd_sc_hd__fill_2
XFILLER_99_561 VGND VGND VPWR VPWR sky130_fd_sc_hd__decap_6
XFILLER_141_691 VPWR VGND VPWR VGND sky130_ef_sc_hd__decap_12
XFILLER_115_35 VPWR VGND VPWR VGND sky130_ef_sc_hd__decap_12
X_07997_ _03817_ _03818_ VGND VGND VPWR VPWR _03819_ sky130_fd_sc_hd__nor2_1
X_09805_ _02633_ cpuregs\[8\]\[12\] _04875_ VGND VGND VPWR VPWR _01458_ sky130_fd_sc_hd__mux2_1
XFILLER_47_609 VGND VGND VPWR VPWR sky130_fd_sc_hd__decap_6
X_06948_ _03354_ _03355_ _03358_ _03359_ _01579_ _01581_ VGND VGND VPWR VPWR _03363_
+ sky130_fd_sc_hd__mux4_1
X_09736_ _02621_ cpuregs\[6\]\[9\] _04873_ VGND VGND VPWR VPWR _01391_ sky130_fd_sc_hd__mux2_1
XFILLER_54_130 VGND VGND VPWR VPWR sky130_fd_sc_hd__decap_8
XFILLER_28_867 VGND VGND VPWR VPWR sky130_fd_sc_hd__fill_1
X_09667_ cpuregs\[4\]\[6\] _02607_ net238 VGND VGND VPWR VPWR _01324_ sky130_fd_sc_hd__mux2_1
X_06879_ decoded_imm\[21\] net184 VGND VGND VPWR VPWR _03296_ sky130_fd_sc_hd__and2_1
XFILLER_82_472 VGND VGND VPWR VPWR sky130_fd_sc_hd__decap_4
XFILLER_54_141 VGND VGND VPWR VPWR sky130_fd_sc_hd__decap_3
XFILLER_15_517 VGND VGND VPWR VPWR sky130_fd_sc_hd__fill_1
X_08618_ _00009_ _04308_ _04307_ _01560_ VGND VGND VPWR VPWR _04313_ sky130_fd_sc_hd__o211a_1
XFILLER_43_826 VGND VGND VPWR VPWR sky130_fd_sc_hd__fill_2
XFILLER_91_27 VPWR VGND VPWR VGND sky130_ef_sc_hd__decap_12
X_09598_ _02598_ cpuregs\[3\]\[4\] _04868_ VGND VGND VPWR VPWR _01258_ sky130_fd_sc_hd__mux2_1
X_08549_ cpuregs\[24\]\[1\] cpuregs\[25\]\[1\] cpuregs\[26\]\[1\] cpuregs\[27\]\[1\]
+ _00007_ _00008_ VGND VGND VPWR VPWR _04250_ sky130_fd_sc_hd__mux4_1
XFILLER_42_369 VGND VGND VPWR VPWR sky130_fd_sc_hd__fill_1
XFILLER_138_3 VPWR VGND VPWR VGND sky130_ef_sc_hd__decap_12
X_10511_ clknet_leaf_81_clk _00641_ VGND VGND VPWR VPWR count_instr\[60\] sky130_fd_sc_hd__dfxtp_1
XFILLER_11_767 VPWR VGND VPWR VGND sky130_ef_sc_hd__decap_12
XFILLER_11_745 VGND VGND VPWR VPWR sky130_fd_sc_hd__fill_1
X_11491_ clknet_leaf_48_clk _01535_ VGND VGND VPWR VPWR cpuregs\[10\]\[25\] sky130_fd_sc_hd__dfxtp_1
XFILLER_7_738 VGND VGND VPWR VPWR sky130_fd_sc_hd__decap_4
X_10442_ clknet_leaf_70_clk _00572_ VGND VGND VPWR VPWR cpuregs\[17\]\[24\] sky130_fd_sc_hd__dfxtp_1
XFILLER_136_430 VPWR VGND VPWR VGND sky130_ef_sc_hd__decap_12
X_10373_ clknet_leaf_64_clk _00503_ VGND VGND VPWR VPWR cpuregs\[25\]\[19\] sky130_fd_sc_hd__dfxtp_1
XFILLER_2_421 VPWR VGND VPWR VGND sky130_ef_sc_hd__decap_12
XFILLER_111_308 VPWR VGND VPWR VGND sky130_ef_sc_hd__decap_12
XFILLER_2_454 VGND VGND VPWR VPWR sky130_fd_sc_hd__decap_4
XFILLER_132_691 VGND VGND VPWR VPWR sky130_fd_sc_hd__fill_2
XFILLER_105_894 VGND VGND VPWR VPWR sky130_fd_sc_hd__fill_2
XFILLER_38_609 VGND VGND VPWR VPWR sky130_fd_sc_hd__fill_1
XTAP_TAPCELL_ROW_144_2636 VGND VPWR sky130_fd_sc_hd__tapvpwrvgnd_1
XFILLER_1_69 VPWR VGND VPWR VGND sky130_ef_sc_hd__decap_12
XFILLER_19_889 VGND VGND VPWR VPWR sky130_fd_sc_hd__decap_6
XFILLER_34_837 VPWR VGND VPWR VGND sky130_ef_sc_hd__decap_12
XTAP_TAPCELL_ROW_64_1351 VGND VPWR sky130_fd_sc_hd__tapvpwrvgnd_1
XFILLER_61_667 VGND VGND VPWR VPWR sky130_fd_sc_hd__decap_4
XFILLER_60_133 VGND VGND VPWR VPWR sky130_fd_sc_hd__decap_6
XTAP_TAPCELL_ROW_64_1362 VGND VPWR sky130_fd_sc_hd__tapvpwrvgnd_1
XFILLER_61_689 VGND VGND VPWR VPWR sky130_fd_sc_hd__fill_2
XTAP_TAPCELL_ROW_16_589 VGND VPWR sky130_fd_sc_hd__tapvpwrvgnd_1
XFILLER_42_881 VPWR VGND VPWR VGND sky130_ef_sc_hd__decap_12
XFILLER_119_408 VGND VGND VPWR VPWR sky130_fd_sc_hd__fill_1
XFILLER_14_594 VGND VGND VPWR VPWR sky130_fd_sc_hd__decap_3
X_10709_ clknet_leaf_127_clk _00806_ VGND VGND VPWR VPWR net97 sky130_fd_sc_hd__dfxtp_4
Xclkload104 clknet_leaf_104_clk VGND VGND VPWR VPWR clkload104/Y sky130_fd_sc_hd__bufinv_16
Xclkload137 clknet_leaf_78_clk VGND VGND VPWR VPWR clkload137/Y sky130_fd_sc_hd__clkinv_8
Xclkload126 clknet_leaf_81_clk VGND VGND VPWR VPWR clkload126/X sky130_fd_sc_hd__clkbuf_4
Xclkload115 clknet_leaf_95_clk VGND VGND VPWR VPWR clkload115/Y sky130_fd_sc_hd__clkinv_2
XFILLER_115_625 VGND VGND VPWR VPWR sky130_fd_sc_hd__decap_6
XFILLER_6_793 VPWR VGND VPWR VGND sky130_ef_sc_hd__decap_12
XFILLER_5_281 VPWR VGND VPWR VGND sky130_ef_sc_hd__decap_12
XFILLER_130_606 VGND VGND VPWR VPWR sky130_fd_sc_hd__fill_1
X_07920_ _03576_ _03748_ VGND VGND VPWR VPWR _03749_ sky130_fd_sc_hd__nor2_1
X_07851_ _02639_ reg_next_pc\[14\] _02482_ VGND VGND VPWR VPWR _03701_ sky130_fd_sc_hd__mux2_2
X_06802_ cpuregs\[16\]\[18\] cpuregs\[17\]\[18\] cpuregs\[18\]\[18\] cpuregs\[19\]\[18\]
+ net267 net260 VGND VGND VPWR VPWR _03222_ sky130_fd_sc_hd__mux4_1
XFILLER_111_897 VPWR VGND VPWR VGND sky130_ef_sc_hd__decap_12
XFILLER_111_886 VGND VGND VPWR VPWR sky130_fd_sc_hd__decap_8
XFILLER_96_597 VPWR VGND VPWR VGND sky130_ef_sc_hd__decap_12
X_07782_ net586 count_instr\[48\] _01549_ VGND VGND VPWR VPWR _03661_ sky130_fd_sc_hd__a21oi_2
Xinput2 mem_rdata[10] VGND VGND VPWR VPWR net2 sky130_fd_sc_hd__dlymetal6s2s_1
X_09521_ cpuregs\[31\]\[26\] _02691_ net240 VGND VGND VPWR VPWR _01184_ sky130_fd_sc_hd__mux2_1
X_06733_ net177 _03155_ net236 VGND VGND VPWR VPWR _00084_ sky130_fd_sc_hd__mux2_1
XFILLER_83_247 VGND VGND VPWR VPWR sky130_fd_sc_hd__fill_1
XFILLER_83_225 VGND VGND VPWR VPWR sky130_fd_sc_hd__fill_2
X_04994_ cpu_state\[6\] cpu_state\[5\] VGND VGND VPWR VPWR _01622_ sky130_fd_sc_hd__or2_4
XFILLER_36_141 VGND VGND VPWR VPWR sky130_fd_sc_hd__decap_8
XFILLER_37_653 VPWR VGND VPWR VGND sky130_ef_sc_hd__decap_12
X_09452_ _02678_ cpuregs\[19\]\[23\] _04863_ VGND VGND VPWR VPWR _01085_ sky130_fd_sc_hd__mux2_1
XFILLER_92_781 VGND VGND VPWR VPWR sky130_fd_sc_hd__decap_4
X_06664_ net202 _02721_ _02744_ _03088_ VGND VGND VPWR VPWR _03089_ sky130_fd_sc_hd__o211a_1
X_08403_ _04149_ count_cycle\[53\] _01549_ VGND VGND VPWR VPWR _04151_ sky130_fd_sc_hd__a21oi_1
X_05615_ _02153_ _02197_ _02196_ VGND VGND VPWR VPWR _02198_ sky130_fd_sc_hd__a21o_1
XFILLER_51_144 VGND VGND VPWR VPWR sky130_fd_sc_hd__decap_3
X_06595_ cpuregs\[4\]\[10\] cpuregs\[5\]\[10\] cpuregs\[6\]\[10\] cpuregs\[7\]\[10\]
+ net263 net259 VGND VGND VPWR VPWR _03023_ sky130_fd_sc_hd__mux4_1
X_09383_ mem_rdata_q\[11\] _04822_ VGND VGND VPWR VPWR _04854_ sky130_fd_sc_hd__and2_1
X_08334_ count_cycle\[26\] count_cycle\[27\] net415 VGND VGND VPWR VPWR _04108_ sky130_fd_sc_hd__and3_1
XFILLER_61_19 VPWR VGND VPWR VGND sky130_ef_sc_hd__decap_12
X_05546_ net171 net97 VGND VGND VPWR VPWR _02129_ sky130_fd_sc_hd__nand2_1
XTAP_TAPCELL_ROW_35_887 VGND VPWR sky130_fd_sc_hd__tapvpwrvgnd_1
XTAP_TAPCELL_ROW_35_898 VGND VPWR sky130_fd_sc_hd__tapvpwrvgnd_1
X_05477_ _02058_ _02059_ VGND VGND VPWR VPWR _02060_ sky130_fd_sc_hd__nor2_1
X_08265_ count_cycle\[2\] count_cycle\[1\] count_cycle\[0\] count_cycle\[3\] VGND
+ VGND VPWR VPWR _04063_ sky130_fd_sc_hd__and4_1
X_08196_ _03713_ _03992_ _01551_ VGND VGND VPWR VPWR _04003_ sky130_fd_sc_hd__o21a_1
X_07216_ cpuregs\[13\]\[0\] _02586_ net251 VGND VGND VPWR VPWR _00164_ sky130_fd_sc_hd__mux2_1
XFILLER_106_625 VGND VGND VPWR VPWR sky130_fd_sc_hd__decap_3
XTAP_TAPCELL_ROW_95_1856 VGND VPWR sky130_fd_sc_hd__tapvpwrvgnd_1
XTAP_TAPCELL_ROW_95_1845 VGND VPWR sky130_fd_sc_hd__tapvpwrvgnd_1
X_07147_ cpuregs\[12\]\[1\] _02588_ _03552_ VGND VGND VPWR VPWR _00101_ sky130_fd_sc_hd__mux2_1
XFILLER_105_135 VPWR VGND VPWR VGND sky130_ef_sc_hd__decap_12
XFILLER_105_113 VGND VGND VPWR VPWR sky130_fd_sc_hd__fill_2
X_07078_ cpuregs\[28\]\[28\] cpuregs\[29\]\[28\] cpuregs\[30\]\[28\] cpuregs\[31\]\[28\]
+ net266 net261 VGND VGND VPWR VPWR _03488_ sky130_fd_sc_hd__mux4_1
XFILLER_133_455 VGND VGND VPWR VPWR sky130_fd_sc_hd__fill_1
XFILLER_105_179 VGND VGND VPWR VPWR sky130_fd_sc_hd__decap_6
XFILLER_86_27 VGND VGND VPWR VPWR sky130_fd_sc_hd__fill_1
X_06029_ mem_rdata_q\[24\] net17 _01609_ VGND VGND VPWR VPWR _01118_ sky130_fd_sc_hd__mux2_1
XFILLER_87_553 VGND VGND VPWR VPWR sky130_fd_sc_hd__decap_6
XFILLER_47_428 VGND VGND VPWR VPWR sky130_fd_sc_hd__decap_6
XTAP_TAPCELL_ROW_126_2355 VGND VPWR sky130_fd_sc_hd__tapvpwrvgnd_1
XTAP_TAPCELL_ROW_126_2344 VGND VPWR sky130_fd_sc_hd__tapvpwrvgnd_1
XFILLER_28_620 VGND VGND VPWR VPWR sky130_fd_sc_hd__decap_4
XFILLER_142_77 VGND VGND VPWR VPWR sky130_fd_sc_hd__decap_6
X_09719_ _02688_ cpuregs\[5\]\[25\] _04872_ VGND VGND VPWR VPWR _01375_ sky130_fd_sc_hd__mux2_1
X_10991_ clknet_leaf_53_clk _01053_ VGND VGND VPWR VPWR cpuregs\[18\]\[23\] sky130_fd_sc_hd__dfxtp_1
XFILLER_90_707 VGND VGND VPWR VPWR sky130_fd_sc_hd__fill_1
XFILLER_74_269 VGND VGND VPWR VPWR sky130_fd_sc_hd__decap_8
XFILLER_55_483 VGND VGND VPWR VPWR sky130_fd_sc_hd__decap_8
XFILLER_16_837 VPWR VGND VPWR VGND sky130_ef_sc_hd__decap_12
XFILLER_43_645 VGND VGND VPWR VPWR sky130_fd_sc_hd__decap_8
XFILLER_70_464 VPWR VGND VPWR VGND sky130_ef_sc_hd__decap_12
XFILLER_24_881 VPWR VGND VPWR VGND sky130_ef_sc_hd__decap_12
X_11612_ net126 VGND VGND VPWR VPWR net232 sky130_fd_sc_hd__clkbuf_1
XTAP_TAPCELL_ROW_46_1070 VGND VPWR sky130_fd_sc_hd__tapvpwrvgnd_1
XFILLER_129_717 VGND VGND VPWR VPWR sky130_fd_sc_hd__fill_1
XTAP_TAPCELL_ROW_104_1996 VGND VPWR sky130_fd_sc_hd__tapvpwrvgnd_1
XTAP_TAPCELL_ROW_13_537 VGND VPWR sky130_fd_sc_hd__tapvpwrvgnd_1
XFILLER_23_391 VGND VGND VPWR VPWR sky130_fd_sc_hd__fill_1
XFILLER_7_502 VGND VGND VPWR VPWR sky130_fd_sc_hd__fill_2
X_11474_ clknet_leaf_13_clk _01518_ VGND VGND VPWR VPWR cpuregs\[10\]\[8\] sky130_fd_sc_hd__dfxtp_1
X_10425_ clknet_leaf_144_clk _00555_ VGND VGND VPWR VPWR cpuregs\[17\]\[7\] sky130_fd_sc_hd__dfxtp_1
XFILLER_152_753 VGND VGND VPWR VPWR sky130_fd_sc_hd__decap_3
XFILLER_124_477 VGND VGND VPWR VPWR sky130_fd_sc_hd__decap_6
XPHY_EDGE_ROW_115_Left_269 VGND VGND VPWR VPWR sky130_fd_sc_hd__decap_3
XFILLER_3_741 VPWR VGND VPWR VGND sky130_ef_sc_hd__decap_12
X_10356_ clknet_leaf_120_clk _00486_ VGND VGND VPWR VPWR cpuregs\[25\]\[2\] sky130_fd_sc_hd__dfxtp_1
X_10287_ clknet_leaf_33_clk _00417_ VGND VGND VPWR VPWR cpuregs\[15\]\[29\] sky130_fd_sc_hd__dfxtp_1
XFILLER_3_785 VPWR VGND VPWR VGND sky130_ef_sc_hd__decap_12
XFILLER_2_251 VGND VGND VPWR VPWR sky130_fd_sc_hd__fill_1
XFILLER_66_748 VGND VGND VPWR VPWR sky130_fd_sc_hd__fill_2
XFILLER_65_225 VGND VGND VPWR VPWR sky130_fd_sc_hd__decap_6
XFILLER_80_206 VGND VGND VPWR VPWR sky130_fd_sc_hd__decap_8
XFILLER_18_141 VGND VGND VPWR VPWR sky130_fd_sc_hd__decap_4
XFILLER_46_450 VPWR VGND VPWR VGND sky130_ef_sc_hd__decap_12
XFILLER_18_174 VGND VGND VPWR VPWR sky130_fd_sc_hd__decap_6
XFILLER_33_111 VGND VGND VPWR VPWR sky130_fd_sc_hd__fill_1
XPHY_EDGE_ROW_124_Left_278 VGND VGND VPWR VPWR sky130_fd_sc_hd__decap_3
XFILLER_33_133 VGND VGND VPWR VPWR sky130_fd_sc_hd__fill_2
XFILLER_34_678 VGND VGND VPWR VPWR sky130_fd_sc_hd__decap_4
X_05400_ _01674_ _01987_ _01988_ net189 cpu_state\[4\] VGND VGND VPWR VPWR _01989_
+ sky130_fd_sc_hd__a32o_1
X_06380_ cpuregs\[16\]\[3\] cpuregs\[17\]\[3\] cpuregs\[18\]\[3\] cpuregs\[19\]\[3\]
+ net268 net262 VGND VGND VPWR VPWR _02815_ sky130_fd_sc_hd__mux4_1
XTAP_TAPCELL_ROW_32_846 VGND VPWR sky130_fd_sc_hd__tapvpwrvgnd_1
XFILLER_147_514 VGND VGND VPWR VPWR sky130_fd_sc_hd__decap_6
X_05331_ _01908_ _01914_ _01923_ VGND VGND VPWR VPWR _01925_ sky130_fd_sc_hd__a21o_1
X_08050_ decoded_imm_j\[15\] _03702_ VGND VGND VPWR VPWR _03868_ sky130_fd_sc_hd__nand2_1
X_05262_ count_instr\[15\] instr_rdinstr count_cycle\[47\] instr_rdcycleh VGND VGND
+ VPWR VPWR _01862_ sky130_fd_sc_hd__a22o_1
X_07001_ cpuregs\[4\]\[25\] cpuregs\[5\]\[25\] cpuregs\[6\]\[25\] cpuregs\[7\]\[25\]
+ net267 net261 VGND VGND VPWR VPWR _03414_ sky130_fd_sc_hd__mux4_1
XFILLER_134_219 VGND VGND VPWR VPWR sky130_fd_sc_hd__fill_1
XFILLER_127_260 VGND VGND VPWR VPWR sky130_fd_sc_hd__decap_8
XPHY_EDGE_ROW_133_Left_287 VGND VGND VPWR VPWR sky130_fd_sc_hd__decap_3
XFILLER_115_422 VGND VGND VPWR VPWR sky130_fd_sc_hd__decap_3
XTAP_TAPCELL_ROW_77_1564 VGND VPWR sky130_fd_sc_hd__tapvpwrvgnd_1
X_05193_ _01554_ _01561_ _01675_ _01797_ _01794_ VGND VGND VPWR VPWR _01798_ sky130_fd_sc_hd__o221a_1
Xpicorv32_299 VGND VGND VPWR VPWR picorv32_299/HI eoi[18] sky130_fd_sc_hd__conb_1
X_08952_ net220 _01585_ _04627_ _04628_ VGND VGND VPWR VPWR _00831_ sky130_fd_sc_hd__o22a_1
Xpicorv32_288 VGND VGND VPWR VPWR picorv32_288/HI eoi[7] sky130_fd_sc_hd__conb_1
X_08883_ cpuregs\[24\]\[22\] cpuregs\[25\]\[22\] cpuregs\[26\]\[22\] cpuregs\[27\]\[22\]
+ net276 net272 VGND VGND VPWR VPWR _04563_ sky130_fd_sc_hd__mux4_1
XTAP_TAPCELL_ROW_90_1775 VGND VPWR sky130_fd_sc_hd__tapvpwrvgnd_1
XTAP_TAPCELL_ROW_90_1764 VGND VPWR sky130_fd_sc_hd__tapvpwrvgnd_1
X_07903_ decoded_imm_j\[3\] _03689_ VGND VGND VPWR VPWR _03733_ sky130_fd_sc_hd__or2_1
XFILLER_96_372 VPWR VGND VPWR VGND sky130_ef_sc_hd__decap_12
XFILLER_56_19 VGND VGND VPWR VPWR sky130_fd_sc_hd__decap_8
X_07834_ reg_pc\[5\] _01624_ _01628_ _03692_ VGND VGND VPWR VPWR _00649_ sky130_fd_sc_hd__a22o_1
XTAP_TAPCELL_ROW_108_2052 VGND VPWR sky130_fd_sc_hd__tapvpwrvgnd_1
XPHY_EDGE_ROW_142_Left_296 VGND VGND VPWR VPWR sky130_fd_sc_hd__decap_3
XTAP_TAPCELL_ROW_108_2063 VGND VPWR sky130_fd_sc_hd__tapvpwrvgnd_1
XFILLER_84_589 VGND VGND VPWR VPWR sky130_fd_sc_hd__decap_4
X_07765_ _03649_ _03650_ VGND VGND VPWR VPWR _00622_ sky130_fd_sc_hd__nor2_1
XFILLER_25_601 VPWR VGND VPWR VGND sky130_ef_sc_hd__decap_12
XFILLER_37_461 VPWR VGND VPWR VGND sky130_ef_sc_hd__decap_12
X_04977_ net34 _01606_ VGND VGND VPWR VPWR _01607_ sky130_fd_sc_hd__and2_1
X_07696_ _03605_ _03606_ VGND VGND VPWR VPWR _00597_ sky130_fd_sc_hd__nor2_1
X_06716_ net176 _02721_ _03063_ _01641_ VGND VGND VPWR VPWR _03139_ sky130_fd_sc_hd__o211a_1
XFILLER_65_781 VGND VGND VPWR VPWR sky130_fd_sc_hd__decap_3
X_09504_ cpuregs\[31\]\[9\] _02621_ net240 VGND VGND VPWR VPWR _01167_ sky130_fd_sc_hd__mux2_1
XTAP_TAPCELL_ROW_121_2263 VGND VPWR sky130_fd_sc_hd__tapvpwrvgnd_1
XFILLER_72_29 VPWR VGND VPWR VGND sky130_ef_sc_hd__decap_12
X_06647_ _01579_ _03072_ VGND VGND VPWR VPWR _03073_ sky130_fd_sc_hd__or2_1
XFILLER_25_667 VGND VGND VPWR VPWR sky130_fd_sc_hd__decap_4
X_09435_ _02607_ cpuregs\[19\]\[6\] _04863_ VGND VGND VPWR VPWR _01068_ sky130_fd_sc_hd__mux2_1
XTAP_TAPCELL_ROW_121_2274 VGND VPWR sky130_fd_sc_hd__tapvpwrvgnd_1
XFILLER_24_177 VGND VGND VPWR VPWR sky130_fd_sc_hd__decap_3
X_09366_ instr_jal decoded_imm_j\[12\] _01589_ mem_rdata_q\[12\] VGND VGND VPWR VPWR
+ _04845_ sky130_fd_sc_hd__a22o_1
X_06578_ _03005_ VGND VGND VPWR VPWR _03006_ sky130_fd_sc_hd__inv_2
X_09297_ net154 net116 _04206_ VGND VGND VPWR VPWR _00983_ sky130_fd_sc_hd__mux2_1
X_05529_ net178 net210 VGND VGND VPWR VPWR _02112_ sky130_fd_sc_hd__nor2_1
X_08317_ count_cycle\[21\] _04094_ net34 VGND VGND VPWR VPWR _04097_ sky130_fd_sc_hd__o21ai_1
XANTENNA_40 net201 VGND VGND VPWR VPWR sky130_fd_sc_hd__diode_2
X_08248_ _01547_ reg_next_pc\[30\] _01645_ _03718_ VGND VGND VPWR VPWR _04051_ sky130_fd_sc_hd__a22o_1
XFILLER_21_895 VGND VGND VPWR VPWR sky130_fd_sc_hd__fill_1
XFILLER_119_783 VGND VGND VPWR VPWR sky130_fd_sc_hd__fill_1
XFILLER_21_55 VGND VGND VPWR VPWR sky130_fd_sc_hd__fill_1
XFILLER_146_580 VGND VGND VPWR VPWR sky130_fd_sc_hd__decap_8
XFILLER_137_55 VGND VGND VPWR VPWR sky130_fd_sc_hd__fill_1
X_08179_ decoded_imm_j\[20\] _03712_ VGND VGND VPWR VPWR _03987_ sky130_fd_sc_hd__nor2_1
X_10210_ clknet_leaf_20_clk _00340_ VGND VGND VPWR VPWR cpuregs\[14\]\[16\] sky130_fd_sc_hd__dfxtp_1
X_11190_ clknet_leaf_14_clk _01237_ VGND VGND VPWR VPWR cpuregs\[29\]\[15\] sky130_fd_sc_hd__dfxtp_1
XFILLER_106_488 VGND VGND VPWR VPWR sky130_fd_sc_hd__fill_1
X_10141_ clknet_leaf_147_clk _00271_ VGND VGND VPWR VPWR cpuregs\[21\]\[11\] sky130_fd_sc_hd__dfxtp_1
Xoutput191 net191 VGND VGND VPWR VPWR pcpi_rs1[28] sky130_fd_sc_hd__buf_2
XFILLER_121_447 VGND VGND VPWR VPWR sky130_fd_sc_hd__fill_1
Xoutput180 net180 VGND VGND VPWR VPWR pcpi_rs1[18] sky130_fd_sc_hd__buf_2
XFILLER_88_862 VGND VGND VPWR VPWR sky130_fd_sc_hd__decap_6
XFILLER_0_755 VGND VGND VPWR VPWR sky130_fd_sc_hd__fill_1
X_10072_ clknet_leaf_4_clk _00202_ VGND VGND VPWR VPWR cpuregs\[2\]\[6\] sky130_fd_sc_hd__dfxtp_1
XFILLER_94_309 VGND VGND VPWR VPWR sky130_fd_sc_hd__fill_2
XFILLER_48_737 VGND VGND VPWR VPWR sky130_fd_sc_hd__decap_3
XFILLER_63_729 VGND VGND VPWR VPWR sky130_fd_sc_hd__decap_6
XFILLER_46_41 VPWR VGND VPWR VGND sky130_ef_sc_hd__decap_12
XFILLER_90_537 VGND VGND VPWR VPWR sky130_fd_sc_hd__fill_1
XFILLER_90_526 VGND VGND VPWR VPWR sky130_fd_sc_hd__decap_6
XFILLER_16_612 VGND VGND VPWR VPWR sky130_fd_sc_hd__fill_1
XTAP_TAPCELL_ROW_18_618 VGND VPWR sky130_fd_sc_hd__tapvpwrvgnd_1
XFILLER_28_483 VGND VGND VPWR VPWR sky130_fd_sc_hd__fill_1
X_10974_ clknet_leaf_4_clk _01036_ VGND VGND VPWR VPWR cpuregs\[18\]\[6\] sky130_fd_sc_hd__dfxtp_1
XFILLER_16_645 VPWR VGND VPWR VGND sky130_ef_sc_hd__decap_12
XFILLER_43_431 VGND VGND VPWR VPWR sky130_fd_sc_hd__fill_1
XFILLER_43_442 VGND VGND VPWR VPWR sky130_fd_sc_hd__decap_6
XFILLER_16_678 VGND VGND VPWR VPWR sky130_fd_sc_hd__decap_6
XFILLER_31_615 VGND VGND VPWR VPWR sky130_fd_sc_hd__fill_1
XFILLER_43_486 VGND VGND VPWR VPWR sky130_fd_sc_hd__fill_2
XTAP_TAPCELL_ROW_44_1029 VGND VPWR sky130_fd_sc_hd__tapvpwrvgnd_1
XTAP_TAPCELL_ROW_61_1310 VGND VPWR sky130_fd_sc_hd__tapvpwrvgnd_1
XFILLER_15_199 VPWR VGND VPWR VGND sky130_ef_sc_hd__decap_12
XTAP_TAPCELL_ROW_139_2557 VGND VPWR sky130_fd_sc_hd__tapvpwrvgnd_1
XFILLER_129_503 VGND VGND VPWR VPWR sky130_fd_sc_hd__fill_1
Xwire241 net242 VGND VGND VPWR VPWR net241 sky130_fd_sc_hd__clkbuf_8
XTAP_TAPCELL_ROW_152_2757 VGND VPWR sky130_fd_sc_hd__tapvpwrvgnd_1
XFILLER_7_57 VPWR VGND VPWR VGND sky130_ef_sc_hd__decap_12
XTAP_TAPCELL_ROW_152_2768 VGND VPWR sky130_fd_sc_hd__tapvpwrvgnd_1
X_11457_ clknet_leaf_43_clk _01501_ VGND VGND VPWR VPWR cpuregs\[0\]\[23\] sky130_fd_sc_hd__dfxtp_1
XFILLER_109_260 VGND VGND VPWR VPWR sky130_fd_sc_hd__decap_4
X_10408_ clknet_leaf_48_clk _00538_ VGND VGND VPWR VPWR cpuregs\[20\]\[22\] sky130_fd_sc_hd__dfxtp_1
XFILLER_140_701 VPWR VGND VPWR VGND sky130_ef_sc_hd__decap_12
X_11388_ clknet_leaf_42_clk _01432_ VGND VGND VPWR VPWR cpuregs\[7\]\[18\] sky130_fd_sc_hd__dfxtp_1
XTAP_TAPCELL_ROW_59_1283 VGND VPWR sky130_fd_sc_hd__tapvpwrvgnd_1
XTAP_TAPCELL_ROW_59_1272 VGND VPWR sky130_fd_sc_hd__tapvpwrvgnd_1
XFILLER_112_425 VGND VGND VPWR VPWR sky130_fd_sc_hd__fill_1
X_10339_ clknet_leaf_54_clk _00469_ VGND VGND VPWR VPWR cpuregs\[16\]\[17\] sky130_fd_sc_hd__dfxtp_1
XFILLER_87_70 VGND VGND VPWR VPWR sky130_fd_sc_hd__fill_1
XFILLER_94_810 VGND VGND VPWR VPWR sky130_fd_sc_hd__fill_2
XTAP_TAPCELL_ROW_72_1483 VGND VPWR sky130_fd_sc_hd__tapvpwrvgnd_1
X_05880_ _02055_ _02436_ _02238_ _02053_ VGND VGND VPWR VPWR _02437_ sky130_fd_sc_hd__a2bb2o_1
XFILLER_16_3 VPWR VGND VPWR VGND sky130_ef_sc_hd__decap_12
XFILLER_93_353 VGND VGND VPWR VPWR sky130_fd_sc_hd__fill_1
XFILLER_66_589 VGND VGND VPWR VPWR sky130_fd_sc_hd__decap_4
XTAP_TAPCELL_ROW_37_916 VGND VPWR sky130_fd_sc_hd__tapvpwrvgnd_1
X_07550_ cpuregs\[25\]\[1\] _02588_ _03571_ VGND VGND VPWR VPWR _00485_ sky130_fd_sc_hd__mux2_1
XTAP_TAPCELL_ROW_37_927 VGND VPWR sky130_fd_sc_hd__tapvpwrvgnd_1
XFILLER_81_559 VGND VGND VPWR VPWR sky130_fd_sc_hd__fill_1
X_06501_ _01641_ _02867_ _02931_ _02929_ _01622_ VGND VGND VPWR VPWR _02932_ sky130_fd_sc_hd__a32o_1
X_09220_ _03549_ _03557_ VGND VGND VPWR VPWR _04799_ sky130_fd_sc_hd__nor2_8
X_07481_ _03553_ _03565_ VGND VGND VPWR VPWR _03568_ sky130_fd_sc_hd__and2_4
XFILLER_34_453 VGND VGND VPWR VPWR sky130_fd_sc_hd__decap_8
XFILLER_21_125 VPWR VGND VPWR VGND sky130_ef_sc_hd__decap_12
XFILLER_34_497 VGND VGND VPWR VPWR sky130_fd_sc_hd__decap_4
X_06432_ _01622_ _02864_ _02865_ VGND VGND VPWR VPWR _02866_ sky130_fd_sc_hd__and3_1
X_09151_ instr_xor _04748_ _04754_ _04772_ VGND VGND VPWR VPWR _00875_ sky130_fd_sc_hd__a22o_1
XFILLER_21_169 VGND VGND VPWR VPWR sky130_fd_sc_hd__fill_2
X_06363_ _01640_ _02798_ VGND VGND VPWR VPWR _02799_ sky130_fd_sc_hd__or2_1
XFILLER_148_867 VGND VGND VPWR VPWR sky130_fd_sc_hd__fill_1
X_05314_ _01907_ _01908_ VGND VGND VPWR VPWR _01909_ sky130_fd_sc_hd__nand2_1
X_08102_ net34 _03916_ VGND VGND VPWR VPWR _00693_ sky130_fd_sc_hd__and2_1
X_09082_ _04741_ VGND VGND VPWR VPWR _01099_ sky130_fd_sc_hd__inv_2
X_08033_ instr_jal _03850_ _03852_ _03841_ VGND VGND VPWR VPWR _03853_ sky130_fd_sc_hd__a31o_1
X_06294_ net258 _02729_ _02731_ _00015_ VGND VGND VPWR VPWR _02732_ sky130_fd_sc_hd__o211a_1
XTAP_TAPCELL_ROW_92_1804 VGND VPWR sky130_fd_sc_hd__tapvpwrvgnd_1
X_05245_ net6 _01666_ _01667_ net24 _01772_ VGND VGND VPWR VPWR _01846_ sky130_fd_sc_hd__o221a_1
X_05176_ _01767_ _01770_ _01781_ VGND VGND VPWR VPWR _01782_ sky130_fd_sc_hd__a21o_1
XFILLER_116_797 VGND VGND VPWR VPWR sky130_fd_sc_hd__decap_3
XFILLER_89_615 VGND VGND VPWR VPWR sky130_fd_sc_hd__fill_1
XFILLER_130_244 VGND VGND VPWR VPWR sky130_fd_sc_hd__decap_8
X_09984_ clknet_leaf_27_clk _00114_ VGND VGND VPWR VPWR cpuregs\[12\]\[14\] sky130_fd_sc_hd__dfxtp_1
X_08935_ cpuregs\[28\]\[25\] cpuregs\[29\]\[25\] cpuregs\[30\]\[25\] cpuregs\[31\]\[25\]
+ net280 net274 VGND VGND VPWR VPWR _04612_ sky130_fd_sc_hd__mux4_1
XFILLER_97_670 VGND VGND VPWR VPWR sky130_fd_sc_hd__fill_2
XFILLER_76_309 VPWR VGND VPWR VGND sky130_ef_sc_hd__decap_12
XPHY_EDGE_ROW_150_Left_304 VGND VGND VPWR VPWR sky130_fd_sc_hd__decap_3
X_08866_ cpuregs\[4\]\[21\] cpuregs\[5\]\[21\] cpuregs\[6\]\[21\] cpuregs\[7\]\[21\]
+ _00007_ net274 VGND VGND VPWR VPWR _04547_ sky130_fd_sc_hd__mux4_1
XFILLER_130_299 VGND VGND VPWR VPWR sky130_fd_sc_hd__decap_8
XTAP_TAPCELL_ROW_123_2303 VGND VPWR sky130_fd_sc_hd__tapvpwrvgnd_1
XFILLER_123_57 VPWR VGND VPWR VGND sky130_ef_sc_hd__decap_12
X_07817_ _03679_ count_instr\[60\] count_instr\[61\] VGND VGND VPWR VPWR _03683_ sky130_fd_sc_hd__and3_1
X_08797_ cpuregs\[0\]\[17\] cpuregs\[1\]\[17\] cpuregs\[2\]\[17\] cpuregs\[3\]\[17\]
+ net277 net272 VGND VGND VPWR VPWR _04482_ sky130_fd_sc_hd__mux4_1
XFILLER_17_409 VGND VGND VPWR VPWR sky130_fd_sc_hd__decap_4
XFILLER_29_269 VGND VGND VPWR VPWR sky130_fd_sc_hd__decap_8
XFILLER_72_515 VGND VGND VPWR VPWR sky130_fd_sc_hd__decap_8
X_07748_ count_instr\[35\] _03638_ net34 VGND VGND VPWR VPWR _03640_ sky130_fd_sc_hd__o21ai_1
X_07679_ count_instr\[10\] _03594_ net34 VGND VGND VPWR VPWR _03596_ sky130_fd_sc_hd__o21ai_1
XFILLER_52_250 VGND VGND VPWR VPWR sky130_fd_sc_hd__fill_2
XFILLER_16_77 VGND VGND VPWR VPWR sky130_fd_sc_hd__decap_6
XFILLER_25_486 VGND VGND VPWR VPWR sky130_fd_sc_hd__fill_2
X_09418_ _02675_ cpuregs\[18\]\[22\] _04862_ VGND VGND VPWR VPWR _01052_ sky130_fd_sc_hd__mux2_1
X_10690_ clknet_leaf_83_clk _00788_ VGND VGND VPWR VPWR net43 sky130_fd_sc_hd__dfxtp_1
XFILLER_13_659 VPWR VGND VPWR VGND sky130_ef_sc_hd__decap_12
XFILLER_25_497 VGND VGND VPWR VPWR sky130_fd_sc_hd__decap_6
XTAP_TAPCELL_ROW_101_1955 VGND VPWR sky130_fd_sc_hd__tapvpwrvgnd_1
XTAP_TAPCELL_ROW_101_1944 VGND VPWR sky130_fd_sc_hd__tapvpwrvgnd_1
X_09349_ decoded_imm\[21\] _04746_ _04825_ _04836_ VGND VGND VPWR VPWR _01009_ sky130_fd_sc_hd__o22a_1
XTAP_TAPCELL_ROW_23_698 VGND VPWR sky130_fd_sc_hd__tapvpwrvgnd_1
XFILLER_148_65 VPWR VGND VPWR VGND sky130_ef_sc_hd__decap_12
XFILLER_139_889 VGND VGND VPWR VPWR sky130_fd_sc_hd__decap_6
XFILLER_126_517 VGND VGND VPWR VPWR sky130_fd_sc_hd__decap_8
X_11311_ clknet_leaf_136_clk _01358_ VGND VGND VPWR VPWR cpuregs\[5\]\[8\] sky130_fd_sc_hd__dfxtp_1
XTAP_TAPCELL_ROW_134_2476 VGND VPWR sky130_fd_sc_hd__tapvpwrvgnd_1
X_11242_ clknet_leaf_123_clk _01289_ VGND VGND VPWR VPWR cpuregs\[22\]\[3\] sky130_fd_sc_hd__dfxtp_1
XFILLER_4_357 VGND VGND VPWR VPWR sky130_fd_sc_hd__decap_6
XFILLER_122_701 VGND VGND VPWR VPWR sky130_fd_sc_hd__decap_4
X_11173_ clknet_leaf_33_clk _01220_ VGND VGND VPWR VPWR cpuregs\[23\]\[30\] sky130_fd_sc_hd__dfxtp_1
X_10124_ clknet_leaf_43_clk _00254_ VGND VGND VPWR VPWR cpuregs\[28\]\[26\] sky130_fd_sc_hd__dfxtp_1
XFILLER_0_530 VGND VGND VPWR VPWR sky130_fd_sc_hd__fill_2
XFILLER_95_629 VGND VGND VPWR VPWR sky130_fd_sc_hd__decap_6
XFILLER_79_169 VGND VGND VPWR VPWR sky130_fd_sc_hd__decap_6
XFILLER_48_501 VGND VGND VPWR VPWR sky130_fd_sc_hd__fill_2
X_10055_ clknet_leaf_80_clk _00185_ VGND VGND VPWR VPWR cpuregs\[13\]\[21\] sky130_fd_sc_hd__dfxtp_1
XFILLER_102_491 VGND VGND VPWR VPWR sky130_fd_sc_hd__fill_2
XFILLER_88_692 VGND VGND VPWR VPWR sky130_fd_sc_hd__decap_8
XTAP_TAPCELL_ROW_54_1191 VGND VPWR sky130_fd_sc_hd__tapvpwrvgnd_1
XFILLER_76_876 VGND VGND VPWR VPWR sky130_fd_sc_hd__decap_8
XFILLER_48_589 VPWR VGND VPWR VGND sky130_ef_sc_hd__decap_12
XFILLER_91_868 VPWR VGND VPWR VGND sky130_ef_sc_hd__decap_12
XFILLER_28_291 VPWR VGND VPWR VGND sky130_ef_sc_hd__decap_12
X_10957_ clknet_leaf_100_clk _01019_ VGND VGND VPWR VPWR decoded_imm\[11\] sky130_fd_sc_hd__dfxtp_2
X_10888_ clknet_leaf_102_clk _00950_ VGND VGND VPWR VPWR is_alu_reg_imm sky130_fd_sc_hd__dfxtp_2
XFILLER_31_478 VGND VGND VPWR VPWR sky130_fd_sc_hd__fill_2
XTAP_TAPCELL_ROW_42_996 VGND VPWR sky130_fd_sc_hd__tapvpwrvgnd_1
XFILLER_117_517 VGND VGND VPWR VPWR sky130_fd_sc_hd__decap_4
XFILLER_117_539 VGND VGND VPWR VPWR sky130_fd_sc_hd__fill_1
XFILLER_144_358 VGND VGND VPWR VPWR sky130_fd_sc_hd__decap_6
XFILLER_132_509 VPWR VGND VPWR VGND sky130_ef_sc_hd__decap_12
XTAP_TAPCELL_ROW_74_1523 VGND VPWR sky130_fd_sc_hd__tapvpwrvgnd_1
XTAP_TAPCELL_ROW_74_1512 VGND VPWR sky130_fd_sc_hd__tapvpwrvgnd_1
X_05030_ instr_jal _01555_ _01629_ VGND VGND VPWR VPWR _01652_ sky130_fd_sc_hd__or3_1
XFILLER_153_881 VGND VGND VPWR VPWR sky130_fd_sc_hd__decap_4
XFILLER_125_561 VGND VGND VPWR VPWR sky130_fd_sc_hd__decap_4
XFILLER_140_542 VPWR VGND VPWR VGND sky130_ef_sc_hd__decap_12
XFILLER_113_745 VGND VGND VPWR VPWR sky130_fd_sc_hd__decap_6
XFILLER_140_586 VGND VGND VPWR VPWR sky130_fd_sc_hd__fill_2
X_06981_ reg_pc\[24\] _02751_ _03394_ _02715_ VGND VGND VPWR VPWR _03395_ sky130_fd_sc_hd__a211o_1
XFILLER_98_489 VGND VGND VPWR VPWR sky130_fd_sc_hd__decap_4
XFILLER_58_309 VGND VGND VPWR VPWR sky130_fd_sc_hd__decap_4
X_08720_ net270 _04408_ VGND VGND VPWR VPWR _04409_ sky130_fd_sc_hd__or2_1
X_05932_ mem_wordsize\[1\] net122 net205 mem_wordsize\[2\] VGND VGND VPWR VPWR _02477_
+ sky130_fd_sc_hd__a22o_1
X_05863_ _02058_ _02239_ _02237_ VGND VGND VPWR VPWR _02422_ sky130_fd_sc_hd__o21ba_1
XFILLER_82_813 VGND VGND VPWR VPWR sky130_fd_sc_hd__decap_3
X_08651_ cpuregs\[8\]\[9\] cpuregs\[9\]\[9\] cpuregs\[10\]\[9\] cpuregs\[11\]\[9\]
+ net278 net273 VGND VGND VPWR VPWR _04344_ sky130_fd_sc_hd__mux4_1
X_07602_ cpuregs\[20\]\[19\] _02662_ _03573_ VGND VGND VPWR VPWR _00535_ sky130_fd_sc_hd__mux2_1
XTAP_TAPCELL_ROW_105_2011 VGND VPWR sky130_fd_sc_hd__tapvpwrvgnd_1
XTAP_TAPCELL_ROW_1_349 VGND VPWR sky130_fd_sc_hd__tapvpwrvgnd_1
XFILLER_26_206 VPWR VGND VPWR VGND sky130_ef_sc_hd__decap_12
XFILLER_27_729 VGND VGND VPWR VPWR sky130_fd_sc_hd__fill_1
X_05794_ _02108_ _02237_ _02238_ _02109_ VGND VGND VPWR VPWR _02360_ sky130_fd_sc_hd__a22o_1
XFILLER_81_345 VGND VGND VPWR VPWR sky130_fd_sc_hd__fill_2
X_08582_ _04277_ _04278_ _04266_ _04275_ VGND VGND VPWR VPWR _04279_ sky130_fd_sc_hd__o211a_1
X_07533_ _02654_ cpuregs\[16\]\[17\] _03570_ VGND VGND VPWR VPWR _00469_ sky130_fd_sc_hd__mux2_1
XTAP_TAPCELL_ROW_85_1685 VGND VPWR sky130_fd_sc_hd__tapvpwrvgnd_1
XFILLER_81_367 VPWR VGND VPWR VGND sky130_ef_sc_hd__decap_12
XTAP_TAPCELL_ROW_85_1696 VGND VPWR sky130_fd_sc_hd__tapvpwrvgnd_1
X_07464_ cpuregs\[15\]\[15\] _02646_ net246 VGND VGND VPWR VPWR _00403_ sky130_fd_sc_hd__mux2_1
XFILLER_34_283 VGND VGND VPWR VPWR sky130_fd_sc_hd__decap_4
XFILLER_10_618 VPWR VGND VPWR VGND sky130_ef_sc_hd__decap_12
X_06415_ _01579_ _02846_ _02848_ VGND VGND VPWR VPWR _02849_ sky130_fd_sc_hd__a21o_1
X_09203_ mem_rdata_q\[11\] net3 _01609_ VGND VGND VPWR VPWR _01105_ sky130_fd_sc_hd__mux2_1
X_07395_ cpuregs\[14\]\[13\] _02638_ net247 VGND VGND VPWR VPWR _00337_ sky130_fd_sc_hd__mux2_1
X_09134_ instr_andi _04748_ _04757_ _04765_ VGND VGND VPWR VPWR _00866_ sky130_fd_sc_hd__a22o_1
Xrebuffer204 net589 VGND VGND VPWR VPWR net590 sky130_fd_sc_hd__dlymetal6s2s_1
XFILLER_148_653 VGND VGND VPWR VPWR sky130_fd_sc_hd__decap_3
Xrebuffer226 net608 VGND VGND VPWR VPWR net612 sky130_fd_sc_hd__dlymetal6s2s_1
X_06346_ cpuregs\[22\]\[2\] cpuregs\[23\]\[2\] net268 VGND VGND VPWR VPWR _02782_
+ sky130_fd_sc_hd__mux2_1
XTAP_TAPCELL_ROW_20_646 VGND VPWR sky130_fd_sc_hd__tapvpwrvgnd_1
XTAP_TAPCELL_ROW_20_657 VGND VPWR sky130_fd_sc_hd__tapvpwrvgnd_1
Xrebuffer215 net600 VGND VGND VPWR VPWR net601 sky130_fd_sc_hd__dlygate4sd1_1
XFILLER_136_837 VPWR VGND VPWR VGND sky130_ef_sc_hd__decap_12
X_09065_ cpu_state\[3\] _01547_ _01644_ net587 net34 VGND VGND VPWR VPWR _00839_ sky130_fd_sc_hd__o221a_1
X_06277_ _01554_ _01621_ VGND VGND VPWR VPWR _02715_ sky130_fd_sc_hd__nand2_8
XTAP_TAPCELL_ROW_116_2195 VGND VPWR sky130_fd_sc_hd__tapvpwrvgnd_1
XTAP_TAPCELL_ROW_116_2184 VGND VPWR sky130_fd_sc_hd__tapvpwrvgnd_1
X_05228_ _01828_ _01829_ VGND VGND VPWR VPWR _01830_ sky130_fd_sc_hd__nor2_1
X_08016_ _03833_ _03836_ _03576_ VGND VGND VPWR VPWR _03837_ sky130_fd_sc_hd__a21oi_1
XFILLER_150_306 VGND VGND VPWR VPWR sky130_fd_sc_hd__fill_2
XFILLER_144_881 VPWR VGND VPWR VGND sky130_ef_sc_hd__decap_12
XFILLER_1_305 VPWR VGND VPWR VGND sky130_ef_sc_hd__decap_12
XFILLER_143_391 VGND VGND VPWR VPWR sky130_fd_sc_hd__fill_1
XFILLER_103_222 VGND VGND VPWR VPWR sky130_fd_sc_hd__fill_2
X_05159_ reg_pc\[8\] decoded_imm\[8\] VGND VGND VPWR VPWR _01766_ sky130_fd_sc_hd__or2_1
XFILLER_1_349 VGND VGND VPWR VPWR sky130_fd_sc_hd__fill_1
X_09967_ clknet_leaf_56_clk _00097_ VGND VGND VPWR VPWR net191 sky130_fd_sc_hd__dfxtp_4
XFILLER_77_629 VGND VGND VPWR VPWR sky130_fd_sc_hd__decap_6
X_08918_ cpuregs\[24\]\[24\] cpuregs\[25\]\[24\] cpuregs\[26\]\[24\] cpuregs\[27\]\[24\]
+ net280 net274 VGND VGND VPWR VPWR _04596_ sky130_fd_sc_hd__mux4_1
XFILLER_94_27 VGND VGND VPWR VPWR sky130_fd_sc_hd__fill_1
X_09898_ cpuregs\[0\]\[28\] VGND VGND VPWR VPWR _01506_ sky130_fd_sc_hd__clkbuf_1
XFILLER_94_49 VGND VGND VPWR VPWR sky130_fd_sc_hd__fill_1
XFILLER_73_802 VGND VGND VPWR VPWR sky130_fd_sc_hd__decap_8
XFILLER_58_854 VPWR VGND VPWR VGND sky130_ef_sc_hd__decap_12
X_08849_ cpuregs\[12\]\[20\] cpuregs\[13\]\[20\] cpuregs\[14\]\[20\] cpuregs\[15\]\[20\]
+ net280 net274 VGND VGND VPWR VPWR _04531_ sky130_fd_sc_hd__mux4_1
XFILLER_85_673 VGND VGND VPWR VPWR sky130_fd_sc_hd__fill_2
XFILLER_72_323 VGND VGND VPWR VPWR sky130_fd_sc_hd__decap_3
XFILLER_45_548 VGND VGND VPWR VPWR sky130_fd_sc_hd__fill_2
XFILLER_45_559 VGND VGND VPWR VPWR sky130_fd_sc_hd__fill_1
XFILLER_150_77 VGND VGND VPWR VPWR sky130_fd_sc_hd__decap_6
X_10811_ clknet_leaf_97_clk _00876_ VGND VGND VPWR VPWR instr_srl sky130_fd_sc_hd__dfxtp_1
XFILLER_27_98 VPWR VGND VPWR VGND sky130_ef_sc_hd__decap_12
XFILLER_26_751 VGND VGND VPWR VPWR sky130_fd_sc_hd__decap_4
XTAP_TAPCELL_ROW_28_779 VGND VPWR sky130_fd_sc_hd__tapvpwrvgnd_1
XFILLER_81_890 VGND VGND VPWR VPWR sky130_fd_sc_hd__decap_6
X_10742_ clknet_leaf_101_clk _00839_ VGND VGND VPWR VPWR latched_stalu sky130_fd_sc_hd__dfxtp_4
XFILLER_43_31 VGND VGND VPWR VPWR sky130_fd_sc_hd__fill_2
XFILLER_40_253 VPWR VGND VPWR VGND sky130_ef_sc_hd__decap_12
XTAP_TAPCELL_ROW_136_2505 VGND VPWR sky130_fd_sc_hd__tapvpwrvgnd_1
X_10673_ clknet_leaf_95_clk _04902_ VGND VGND VPWR VPWR reg_out\[31\] sky130_fd_sc_hd__dfxtp_1
XFILLER_9_449 VGND VGND VPWR VPWR sky130_fd_sc_hd__decap_6
XFILLER_41_798 VGND VGND VPWR VPWR sky130_fd_sc_hd__fill_2
XFILLER_138_141 VPWR VGND VPWR VGND sky130_ef_sc_hd__decap_12
XFILLER_138_130 VGND VGND VPWR VPWR sky130_fd_sc_hd__decap_8
XFILLER_126_325 VGND VGND VPWR VPWR sky130_fd_sc_hd__fill_2
XFILLER_126_347 VGND VGND VPWR VPWR sky130_fd_sc_hd__fill_1
XFILLER_4_121 VPWR VGND VPWR VGND sky130_ef_sc_hd__decap_12
XFILLER_141_317 VGND VGND VPWR VPWR sky130_fd_sc_hd__decap_3
X_11225_ clknet_leaf_23_clk _01272_ VGND VGND VPWR VPWR cpuregs\[3\]\[18\] sky130_fd_sc_hd__dfxtp_1
XTAP_TAPCELL_ROW_56_1231 VGND VPWR sky130_fd_sc_hd__tapvpwrvgnd_1
XTAP_TAPCELL_ROW_56_1220 VGND VPWR sky130_fd_sc_hd__tapvpwrvgnd_1
XFILLER_4_165 VPWR VGND VPWR VGND sky130_ef_sc_hd__decap_12
XFILLER_122_531 VGND VGND VPWR VPWR sky130_fd_sc_hd__fill_1
XFILLER_122_520 VGND VGND VPWR VPWR sky130_fd_sc_hd__decap_4
X_11156_ clknet_leaf_8_clk _01203_ VGND VGND VPWR VPWR cpuregs\[23\]\[13\] sky130_fd_sc_hd__dfxtp_1
XTAP_TAPCELL_ROW_8_460 VGND VPWR sky130_fd_sc_hd__tapvpwrvgnd_1
X_11087_ clknet_leaf_52_clk _01144_ VGND VGND VPWR VPWR cpuregs\[24\]\[18\] sky130_fd_sc_hd__dfxtp_1
XFILLER_0_371 VGND VGND VPWR VPWR sky130_fd_sc_hd__decap_3
X_10107_ clknet_leaf_146_clk _00237_ VGND VGND VPWR VPWR cpuregs\[28\]\[9\] sky130_fd_sc_hd__dfxtp_1
XTAP_TAPCELL_ROW_147_2689 VGND VPWR sky130_fd_sc_hd__tapvpwrvgnd_1
XTAP_TAPCELL_ROW_147_2678 VGND VPWR sky130_fd_sc_hd__tapvpwrvgnd_1
XFILLER_95_459 VGND VGND VPWR VPWR sky130_fd_sc_hd__decap_3
XFILLER_0_393 VGND VGND VPWR VPWR sky130_fd_sc_hd__fill_2
X_10038_ clknet_leaf_134_clk _00168_ VGND VGND VPWR VPWR cpuregs\[13\]\[4\] sky130_fd_sc_hd__dfxtp_1
XFILLER_63_301 VPWR VGND VPWR VGND sky130_ef_sc_hd__decap_12
XFILLER_63_367 VGND VGND VPWR VPWR sky130_fd_sc_hd__fill_1
XFILLER_90_197 VGND VGND VPWR VPWR sky130_fd_sc_hd__decap_4
XFILLER_31_220 VGND VGND VPWR VPWR sky130_fd_sc_hd__decap_4
X_06200_ _02651_ _02652_ VGND VGND VPWR VPWR _02653_ sky130_fd_sc_hd__nor2_1
XPHY_EDGE_ROW_140_Right_140 VGND VGND VPWR VPWR sky130_fd_sc_hd__decap_3
X_07180_ latched_rd\[2\] latched_rd\[3\] latched_rd\[4\] VGND VGND VPWR VPWR _03555_
+ sky130_fd_sc_hd__nand3_4
X_06131_ _02595_ _02596_ VGND VGND VPWR VPWR _02597_ sky130_fd_sc_hd__nor2_1
XFILLER_117_347 VGND VGND VPWR VPWR sky130_fd_sc_hd__decap_8
X_06062_ _00010_ _02534_ _01560_ VGND VGND VPWR VPWR _02535_ sky130_fd_sc_hd__a21o_1
XFILLER_144_177 VPWR VGND VPWR VGND sky130_ef_sc_hd__decap_12
XFILLER_126_881 VPWR VGND VPWR VGND sky130_ef_sc_hd__decap_12
XFILLER_99_721 VGND VGND VPWR VPWR sky130_fd_sc_hd__fill_1
X_05013_ _01612_ _01635_ VGND VGND VPWR VPWR _01636_ sky130_fd_sc_hd__nand2b_1
XFILLER_140_350 VPWR VGND VPWR VGND sky130_ef_sc_hd__decap_12
X_09821_ _02699_ cpuregs\[8\]\[28\] _04875_ VGND VGND VPWR VPWR _01474_ sky130_fd_sc_hd__mux2_1
XFILLER_86_415 VGND VGND VPWR VPWR sky130_fd_sc_hd__decap_4
X_09752_ _02688_ cpuregs\[6\]\[25\] _04873_ VGND VGND VPWR VPWR _01407_ sky130_fd_sc_hd__mux2_1
XFILLER_141_895 VGND VGND VPWR VPWR sky130_fd_sc_hd__fill_1
XFILLER_101_737 VPWR VGND VPWR VGND sky130_ef_sc_hd__decap_12
XFILLER_86_437 VGND VGND VPWR VPWR sky130_fd_sc_hd__decap_3
XFILLER_58_128 VPWR VGND VPWR VGND sky130_ef_sc_hd__decap_12
X_06964_ _01567_ _02721_ VGND VGND VPWR VPWR _03378_ sky130_fd_sc_hd__nand2_1
X_08703_ cpuregs\[12\]\[12\] cpuregs\[13\]\[12\] cpuregs\[14\]\[12\] cpuregs\[15\]\[12\]
+ net277 net271 VGND VGND VPWR VPWR _04393_ sky130_fd_sc_hd__mux4_1
X_09683_ cpuregs\[4\]\[22\] _02675_ net238 VGND VGND VPWR VPWR _01340_ sky130_fd_sc_hd__mux2_1
X_06895_ cpuregs\[0\]\[21\] cpuregs\[1\]\[21\] cpuregs\[2\]\[21\] cpuregs\[3\]\[21\]
+ _00012_ _00013_ VGND VGND VPWR VPWR _03312_ sky130_fd_sc_hd__mux4_1
X_05915_ _02069_ _02459_ VGND VGND VPWR VPWR _02467_ sky130_fd_sc_hd__nand2b_1
XTAP_TAPCELL_ROW_87_1725 VGND VPWR sky130_fd_sc_hd__tapvpwrvgnd_1
XFILLER_67_673 VGND VGND VPWR VPWR sky130_fd_sc_hd__fill_1
X_05846_ instr_sub _02405_ VGND VGND VPWR VPWR _02406_ sky130_fd_sc_hd__nand2_1
XFILLER_55_846 VPWR VGND VPWR VGND sky130_ef_sc_hd__decap_12
XFILLER_27_559 VGND VGND VPWR VPWR sky130_fd_sc_hd__fill_1
X_08634_ _04322_ _04323_ _01558_ VGND VGND VPWR VPWR _04328_ sky130_fd_sc_hd__mux2_1
X_05777_ _02148_ _02237_ VGND VGND VPWR VPWR _02345_ sky130_fd_sc_hd__and2b_1
X_08565_ cpuregs\[24\]\[5\] cpuregs\[25\]\[5\] cpuregs\[26\]\[5\] cpuregs\[27\]\[5\]
+ net279 _00008_ VGND VGND VPWR VPWR _04262_ sky130_fd_sc_hd__mux4_1
XFILLER_82_698 VGND VGND VPWR VPWR sky130_fd_sc_hd__fill_2
XTAP_TAPCELL_ROW_25_727 VGND VPWR sky130_fd_sc_hd__tapvpwrvgnd_1
XTAP_TAPCELL_ROW_25_738 VGND VPWR sky130_fd_sc_hd__tapvpwrvgnd_1
X_07516_ _02586_ cpuregs\[16\]\[0\] _03570_ VGND VGND VPWR VPWR _00452_ sky130_fd_sc_hd__mux2_1
X_08496_ net80 net49 _04208_ VGND VGND VPWR VPWR _00794_ sky130_fd_sc_hd__mux2_1
XFILLER_80_29 VPWR VGND VPWR VGND sky130_ef_sc_hd__decap_12
XFILLER_50_540 VGND VGND VPWR VPWR sky130_fd_sc_hd__fill_1
XTAP_TAPCELL_ROW_118_2213 VGND VPWR sky130_fd_sc_hd__tapvpwrvgnd_1
X_07447_ cpuregs\[27\]\[31\] _02712_ _03566_ VGND VGND VPWR VPWR _00387_ sky130_fd_sc_hd__mux2_1
XTAP_TAPCELL_ROW_118_2224 VGND VPWR sky130_fd_sc_hd__tapvpwrvgnd_1
X_07378_ _02704_ cpuregs\[9\]\[29\] _03563_ VGND VGND VPWR VPWR _00321_ sky130_fd_sc_hd__mux2_1
X_09117_ instr_lh _04747_ _04753_ is_lb_lh_lw_lbu_lhu VGND VGND VPWR VPWR _00855_
+ sky130_fd_sc_hd__a22o_1
XFILLER_6_419 VGND VGND VPWR VPWR sky130_fd_sc_hd__fill_1
XFILLER_13_89 VGND VGND VPWR VPWR sky130_fd_sc_hd__decap_3
X_06329_ _01640_ _02764_ _02765_ _01641_ VGND VGND VPWR VPWR _02766_ sky130_fd_sc_hd__o22a_1
XFILLER_136_645 VPWR VGND VPWR VGND sky130_ef_sc_hd__decap_12
XFILLER_135_122 VGND VGND VPWR VPWR sky130_fd_sc_hd__decap_6
XTAP_TAPCELL_ROW_131_2424 VGND VPWR sky130_fd_sc_hd__tapvpwrvgnd_1
XTAP_TAPCELL_ROW_98_1898 VGND VPWR sky130_fd_sc_hd__tapvpwrvgnd_1
X_09048_ cpuregs\[4\]\[31\] cpuregs\[5\]\[31\] cpuregs\[6\]\[31\] cpuregs\[7\]\[31\]
+ net277 net272 VGND VGND VPWR VPWR _04719_ sky130_fd_sc_hd__mux4_1
XFILLER_151_615 VGND VGND VPWR VPWR sky130_fd_sc_hd__fill_1
XTAP_TAPCELL_ROW_131_2435 VGND VPWR sky130_fd_sc_hd__tapvpwrvgnd_1
XFILLER_2_625 VPWR VGND VPWR VGND sky130_ef_sc_hd__decap_12
XFILLER_1_113 VPWR VGND VPWR VGND sky130_ef_sc_hd__decap_12
XFILLER_145_55 VGND VGND VPWR VPWR sky130_fd_sc_hd__fill_1
X_11010_ clknet_leaf_2_clk _01072_ VGND VGND VPWR VPWR cpuregs\[19\]\[10\] sky130_fd_sc_hd__dfxtp_1
XFILLER_2_669 VPWR VGND VPWR VGND sky130_ef_sc_hd__decap_12
XTAP_TAPCELL_ROW_51_1150 VGND VPWR sky130_fd_sc_hd__tapvpwrvgnd_1
XTAP_TAPCELL_ROW_129_2397 VGND VPWR sky130_fd_sc_hd__tapvpwrvgnd_1
XFILLER_46_813 VGND VGND VPWR VPWR sky130_fd_sc_hd__fill_1
XFILLER_45_334 VGND VGND VPWR VPWR sky130_fd_sc_hd__fill_2
XTAP_TAPCELL_ROW_142_2597 VGND VPWR sky130_fd_sc_hd__tapvpwrvgnd_1
XFILLER_72_197 VPWR VGND VPWR VGND sky130_ef_sc_hd__decap_12
XFILLER_14_721 VPWR VGND VPWR VGND sky130_ef_sc_hd__decap_12
XFILLER_54_85 VGND VGND VPWR VPWR sky130_fd_sc_hd__fill_1
X_10725_ clknet_leaf_57_clk _00822_ VGND VGND VPWR VPWR net210 sky130_fd_sc_hd__dfxtp_2
X_10656_ clknet_leaf_95_clk _04883_ VGND VGND VPWR VPWR reg_out\[14\] sky130_fd_sc_hd__dfxtp_1
XFILLER_9_246 VGND VGND VPWR VPWR sky130_fd_sc_hd__decap_4
XFILLER_139_461 VPWR VGND VPWR VGND sky130_ef_sc_hd__decap_12
Xclkload16 clknet_leaf_149_clk VGND VGND VPWR VPWR clkload16/Y sky130_fd_sc_hd__inv_8
Xclkload49 clknet_leaf_25_clk VGND VGND VPWR VPWR clkload49/Y sky130_fd_sc_hd__inv_6
X_10587_ clknet_leaf_104_clk _00717_ VGND VGND VPWR VPWR count_cycle\[10\] sky130_fd_sc_hd__dfxtp_1
Xclkload38 clknet_leaf_14_clk VGND VGND VPWR VPWR clkload38/Y sky130_fd_sc_hd__clkinvlp_4
Xclkload27 clknet_leaf_12_clk VGND VGND VPWR VPWR clkload27/Y sky130_fd_sc_hd__bufinv_16
XFILLER_115_829 VGND VGND VPWR VPWR sky130_fd_sc_hd__decap_8
XTAP_TAPCELL_ROW_149_2718 VGND VPWR sky130_fd_sc_hd__tapvpwrvgnd_1
X_11208_ clknet_leaf_115_clk _01255_ VGND VGND VPWR VPWR cpuregs\[3\]\[1\] sky130_fd_sc_hd__dfxtp_1
X_11139_ clknet_leaf_41_clk _01186_ VGND VGND VPWR VPWR cpuregs\[31\]\[28\] sky130_fd_sc_hd__dfxtp_1
XFILLER_110_556 VPWR VGND VPWR VGND sky130_ef_sc_hd__decap_12
XFILLER_110_589 VGND VGND VPWR VPWR sky130_fd_sc_hd__fill_1
XFILLER_55_109 VGND VGND VPWR VPWR sky130_fd_sc_hd__decap_3
XFILLER_49_673 VGND VGND VPWR VPWR sky130_fd_sc_hd__decap_6
X_06680_ _00015_ _03101_ _03104_ _02735_ VGND VGND VPWR VPWR _03105_ sky130_fd_sc_hd__o211a_1
XTAP_TAPCELL_ROW_69_1433 VGND VPWR sky130_fd_sc_hd__tapvpwrvgnd_1
X_05700_ _02164_ _02276_ _02241_ VGND VGND VPWR VPWR _02277_ sky130_fd_sc_hd__o21ai_1
X_05631_ net212 _02102_ net180 VGND VGND VPWR VPWR _02214_ sky130_fd_sc_hd__or3b_1
XFILLER_64_687 VGND VGND VPWR VPWR sky130_fd_sc_hd__decap_4
XFILLER_51_337 VPWR VGND VPWR VGND sky130_ef_sc_hd__decap_12
X_08350_ count_cycle\[32\] count_cycle\[33\] _04114_ VGND VGND VPWR VPWR _04118_ sky130_fd_sc_hd__and3_1
X_07301_ cpuregs\[28\]\[19\] _02662_ _03560_ VGND VGND VPWR VPWR _00247_ sky130_fd_sc_hd__mux2_1
XTAP_TAPCELL_ROW_82_1644 VGND VPWR sky130_fd_sc_hd__tapvpwrvgnd_1
X_05562_ net176 net208 VGND VGND VPWR VPWR _02145_ sky130_fd_sc_hd__or2_1
X_05493_ net191 net223 VGND VGND VPWR VPWR _02076_ sky130_fd_sc_hd__nand2_1
X_08281_ count_cycle\[7\] _04068_ count_cycle\[9\] count_cycle\[8\] VGND VGND VPWR
+ VPWR _04073_ sky130_fd_sc_hd__and4_1
X_07232_ cpuregs\[13\]\[16\] _02649_ net251 VGND VGND VPWR VPWR _00180_ sky130_fd_sc_hd__mux2_1
XFILLER_118_623 VPWR VGND VPWR VGND sky130_ef_sc_hd__decap_12
X_07163_ cpuregs\[12\]\[17\] _02654_ net253 VGND VGND VPWR VPWR _00117_ sky130_fd_sc_hd__mux2_1
XFILLER_118_667 VGND VGND VPWR VPWR sky130_fd_sc_hd__decap_6
X_06114_ net605 net601 VGND VGND VPWR VPWR _02584_ sky130_fd_sc_hd__nand2b_4
XFILLER_145_475 VGND VGND VPWR VPWR sky130_fd_sc_hd__decap_4
XTAP_TAPCELL_ROW_113_2143 VGND VPWR sky130_fd_sc_hd__tapvpwrvgnd_1
XTAP_TAPCELL_ROW_113_2132 VGND VPWR sky130_fd_sc_hd__tapvpwrvgnd_1
X_07094_ _03501_ _03502_ VGND VGND VPWR VPWR _03503_ sky130_fd_sc_hd__nor2_1
XFILLER_133_659 VPWR VGND VPWR VGND sky130_ef_sc_hd__decap_12
X_06045_ cpuregs\[0\]\[2\] cpuregs\[1\]\[2\] cpuregs\[2\]\[2\] cpuregs\[3\]\[2\] net279
+ _00008_ VGND VGND VPWR VPWR _02518_ sky130_fd_sc_hd__mux4_1
XFILLER_141_681 VGND VGND VPWR VPWR sky130_fd_sc_hd__fill_1
X_09804_ _02630_ cpuregs\[8\]\[11\] _04875_ VGND VGND VPWR VPWR _01457_ sky130_fd_sc_hd__mux2_1
X_07996_ decoded_imm_j\[11\] _03698_ VGND VGND VPWR VPWR _03818_ sky130_fd_sc_hd__nor2_1
X_06947_ cpuregs\[8\]\[23\] cpuregs\[9\]\[23\] cpuregs\[10\]\[23\] cpuregs\[11\]\[23\]
+ net267 net260 VGND VGND VPWR VPWR _03362_ sky130_fd_sc_hd__mux4_1
XFILLER_28_813 VPWR VGND VPWR VGND sky130_ef_sc_hd__decap_12
X_09735_ _02616_ cpuregs\[6\]\[8\] _04873_ VGND VGND VPWR VPWR _01390_ sky130_fd_sc_hd__mux2_1
X_09666_ cpuregs\[4\]\[5\] _02603_ net238 VGND VGND VPWR VPWR _01323_ sky130_fd_sc_hd__mux2_1
XFILLER_131_57 VPWR VGND VPWR VGND sky130_ef_sc_hd__decap_12
X_06878_ decoded_imm\[21\] net184 VGND VGND VPWR VPWR _03295_ sky130_fd_sc_hd__nor2_1
XFILLER_82_451 VGND VGND VPWR VPWR sky130_fd_sc_hd__decap_8
X_08617_ _04302_ _04303_ _01558_ VGND VGND VPWR VPWR _04312_ sky130_fd_sc_hd__mux2_1
XPHY_EDGE_ROW_19_Left_173 VGND VGND VPWR VPWR sky130_fd_sc_hd__decap_3
X_05829_ instr_sub _02090_ _02390_ _02389_ VGND VGND VPWR VPWR _02391_ sky130_fd_sc_hd__o31a_1
XFILLER_91_39 VPWR VGND VPWR VGND sky130_ef_sc_hd__decap_12
XFILLER_70_613 VGND VGND VPWR VPWR sky130_fd_sc_hd__fill_1
X_09597_ _02593_ cpuregs\[3\]\[3\] _04868_ VGND VGND VPWR VPWR _01257_ sky130_fd_sc_hd__mux2_1
X_08548_ cpuregs\[28\]\[1\] cpuregs\[29\]\[1\] cpuregs\[30\]\[1\] cpuregs\[31\]\[1\]
+ net279 _00008_ VGND VGND VPWR VPWR _04249_ sky130_fd_sc_hd__mux4_1
Xclkbuf_leaf_143_clk clknet_4_2_0_clk VGND VGND VPWR VPWR clknet_leaf_143_clk sky130_fd_sc_hd__clkbuf_8
X_08479_ net93 net62 _04208_ VGND VGND VPWR VPWR _00777_ sky130_fd_sc_hd__mux2_1
X_11490_ clknet_leaf_67_clk _01534_ VGND VGND VPWR VPWR cpuregs\[10\]\[24\] sky130_fd_sc_hd__dfxtp_1
X_10510_ clknet_leaf_81_clk _00640_ VGND VGND VPWR VPWR count_instr\[59\] sky130_fd_sc_hd__dfxtp_1
X_10441_ clknet_leaf_53_clk _00571_ VGND VGND VPWR VPWR cpuregs\[17\]\[23\] sky130_fd_sc_hd__dfxtp_1
XFILLER_11_779 VGND VGND VPWR VPWR sky130_fd_sc_hd__decap_4
XFILLER_136_442 VGND VGND VPWR VPWR sky130_fd_sc_hd__decap_3
XFILLER_108_111 VPWR VGND VPWR VGND sky130_ef_sc_hd__decap_12
XPHY_EDGE_ROW_28_Left_182 VGND VGND VPWR VPWR sky130_fd_sc_hd__decap_3
XFILLER_136_475 VGND VGND VPWR VPWR sky130_fd_sc_hd__fill_1
X_10372_ clknet_leaf_53_clk _00502_ VGND VGND VPWR VPWR cpuregs\[25\]\[18\] sky130_fd_sc_hd__dfxtp_1
XFILLER_2_433 VGND VGND VPWR VPWR sky130_fd_sc_hd__decap_4
XFILLER_2_477 VGND VGND VPWR VPWR sky130_fd_sc_hd__decap_3
XFILLER_49_74 VGND VGND VPWR VPWR sky130_fd_sc_hd__decap_6
XTAP_TAPCELL_ROW_144_2637 VGND VPWR sky130_fd_sc_hd__tapvpwrvgnd_1
XFILLER_1_15 VPWR VGND VPWR VGND sky130_ef_sc_hd__decap_12
XFILLER_92_248 VGND VGND VPWR VPWR sky130_fd_sc_hd__decap_4
XFILLER_65_51 VGND VGND VPWR VPWR sky130_fd_sc_hd__decap_4
XPHY_EDGE_ROW_37_Left_191 VGND VGND VPWR VPWR sky130_fd_sc_hd__decap_3
XFILLER_61_602 VPWR VGND VPWR VGND sky130_ef_sc_hd__decap_12
XFILLER_65_95 VGND VGND VPWR VPWR sky130_fd_sc_hd__fill_1
XFILLER_34_849 VPWR VGND VPWR VGND sky130_ef_sc_hd__decap_12
XTAP_TAPCELL_ROW_64_1352 VGND VPWR sky130_fd_sc_hd__tapvpwrvgnd_1
XTAP_TAPCELL_ROW_64_1363 VGND VPWR sky130_fd_sc_hd__tapvpwrvgnd_1
XFILLER_42_893 VPWR VGND VPWR VGND sky130_ef_sc_hd__decap_12
Xclkbuf_leaf_134_clk clknet_4_3_0_clk VGND VGND VPWR VPWR clknet_leaf_134_clk sky130_fd_sc_hd__clkbuf_8
X_10708_ clknet_leaf_101_clk _00000_ VGND VGND VPWR VPWR decoder_trigger sky130_fd_sc_hd__dfxtp_4
XFILLER_147_729 VGND VGND VPWR VPWR sky130_fd_sc_hd__fill_1
Xclkload116 clknet_leaf_65_clk VGND VGND VPWR VPWR clkload116/Y sky130_fd_sc_hd__inv_6
X_10639_ clknet_leaf_78_clk _00769_ VGND VGND VPWR VPWR count_cycle\[62\] sky130_fd_sc_hd__dfxtp_1
Xclkload127 clknet_leaf_83_clk VGND VGND VPWR VPWR clkload127/Y sky130_fd_sc_hd__inv_6
Xclkload105 clknet_leaf_105_clk VGND VGND VPWR VPWR clkload105/Y sky130_fd_sc_hd__clkinv_4
Xclkload138 clknet_leaf_79_clk VGND VGND VPWR VPWR clkload138/Y sky130_fd_sc_hd__inv_12
XFILLER_5_293 VPWR VGND VPWR VGND sky130_ef_sc_hd__decap_12
XPHY_EDGE_ROW_18_Right_18 VGND VGND VPWR VPWR sky130_fd_sc_hd__decap_3
XFILLER_122_180 VGND VGND VPWR VPWR sky130_fd_sc_hd__decap_8
XFILLER_96_565 VGND VGND VPWR VPWR sky130_fd_sc_hd__fill_2
XFILLER_96_543 VPWR VGND VPWR VGND sky130_ef_sc_hd__decap_12
X_07850_ reg_pc\[13\] _01624_ _01628_ _03700_ VGND VGND VPWR VPWR _00657_ sky130_fd_sc_hd__a22o_1
X_06801_ cpuregs\[20\]\[18\] cpuregs\[21\]\[18\] cpuregs\[22\]\[18\] cpuregs\[23\]\[18\]
+ net265 net260 VGND VGND VPWR VPWR _03221_ sky130_fd_sc_hd__mux4_1
XFILLER_84_738 VPWR VGND VPWR VGND sky130_ef_sc_hd__decap_12
X_07781_ _03659_ _03660_ VGND VGND VPWR VPWR _00628_ sky130_fd_sc_hd__nor2_1
X_04993_ cpu_state\[6\] cpu_state\[5\] VGND VGND VPWR VPWR _01621_ sky130_fd_sc_hd__nor2_8
X_09520_ cpuregs\[31\]\[25\] _02688_ _04865_ VGND VGND VPWR VPWR _01183_ sky130_fd_sc_hd__mux2_1
X_06732_ _02714_ _03136_ _03138_ _03139_ _03154_ VGND VGND VPWR VPWR _03155_ sky130_fd_sc_hd__o41a_1
Xinput3 mem_rdata[11] VGND VGND VPWR VPWR net3 sky130_fd_sc_hd__clkbuf_2
XFILLER_36_131 VGND VGND VPWR VPWR sky130_fd_sc_hd__decap_8
XFILLER_37_665 VGND VGND VPWR VPWR sky130_fd_sc_hd__decap_6
X_09451_ _02675_ cpuregs\[19\]\[22\] _04863_ VGND VGND VPWR VPWR _01084_ sky130_fd_sc_hd__mux2_1
X_06663_ net179 net254 VGND VGND VPWR VPWR _03088_ sky130_fd_sc_hd__or2_1
X_08402_ _04150_ _04149_ VGND VGND VPWR VPWR _00759_ sky130_fd_sc_hd__nor2_1
X_05614_ net206 net174 VGND VGND VPWR VPWR _02197_ sky130_fd_sc_hd__and2b_1
X_09382_ decoded_imm\[5\] _04746_ _04853_ VGND VGND VPWR VPWR _01025_ sky130_fd_sc_hd__o21a_1
X_06594_ cpuregs\[12\]\[10\] cpuregs\[13\]\[10\] cpuregs\[14\]\[10\] cpuregs\[15\]\[10\]
+ net263 net259 VGND VGND VPWR VPWR _03022_ sky130_fd_sc_hd__mux4_1
XPHY_EDGE_ROW_27_Right_27 VGND VGND VPWR VPWR sky130_fd_sc_hd__decap_3
XFILLER_36_197 VPWR VGND VPWR VGND sky130_ef_sc_hd__decap_12
X_08333_ count_cycle\[26\] net416 count_cycle\[27\] VGND VGND VPWR VPWR _04107_ sky130_fd_sc_hd__a21o_1
X_05545_ net171 net97 VGND VGND VPWR VPWR _02128_ sky130_fd_sc_hd__or2_1
Xclkbuf_leaf_125_clk clknet_4_8_0_clk VGND VGND VPWR VPWR clknet_leaf_125_clk sky130_fd_sc_hd__clkbuf_8
XTAP_TAPCELL_ROW_35_888 VGND VPWR sky130_fd_sc_hd__tapvpwrvgnd_1
XTAP_TAPCELL_ROW_35_899 VGND VPWR sky130_fd_sc_hd__tapvpwrvgnd_1
X_08264_ _04062_ net34 _04061_ VGND VGND VPWR VPWR _00709_ sky130_fd_sc_hd__and3b_1
X_05476_ net187 net219 VGND VGND VPWR VPWR _02059_ sky130_fd_sc_hd__nor2_1
X_08195_ _03713_ _03992_ VGND VGND VPWR VPWR _04002_ sky130_fd_sc_hd__nand2_1
XFILLER_20_598 VPWR VGND VPWR VGND sky130_ef_sc_hd__decap_12
X_07215_ _03551_ _03557_ VGND VGND VPWR VPWR _03558_ sky130_fd_sc_hd__nor2_4
XFILLER_152_209 VPWR VGND VPWR VGND sky130_ef_sc_hd__decap_12
XTAP_TAPCELL_ROW_95_1846 VGND VPWR sky130_fd_sc_hd__tapvpwrvgnd_1
X_07146_ cpuregs\[12\]\[0\] _02586_ net253 VGND VGND VPWR VPWR _00100_ sky130_fd_sc_hd__mux2_1
X_07077_ cpuregs\[16\]\[28\] cpuregs\[17\]\[28\] cpuregs\[18\]\[28\] cpuregs\[19\]\[28\]
+ net266 net261 VGND VGND VPWR VPWR _03487_ sky130_fd_sc_hd__mux4_1
XFILLER_133_423 VGND VGND VPWR VPWR sky130_fd_sc_hd__fill_2
XTAP_TAPCELL_ROW_95_1857 VGND VPWR sky130_fd_sc_hd__tapvpwrvgnd_1
XFILLER_105_169 VGND VGND VPWR VPWR sky130_fd_sc_hd__fill_1
XFILLER_105_158 VGND VGND VPWR VPWR sky130_fd_sc_hd__decap_8
XFILLER_105_147 VGND VGND VPWR VPWR sky130_fd_sc_hd__fill_2
X_06028_ decoded_imm_j\[3\] _01117_ _02513_ VGND VGND VPWR VPWR _00030_ sky130_fd_sc_hd__mux2_1
XPHY_EDGE_ROW_36_Right_36 VGND VGND VPWR VPWR sky130_fd_sc_hd__decap_3
XFILLER_102_810 VGND VGND VPWR VPWR sky130_fd_sc_hd__fill_2
XFILLER_59_223 VGND VGND VPWR VPWR sky130_fd_sc_hd__fill_1
XFILLER_102_876 VPWR VGND VPWR VGND sky130_ef_sc_hd__decap_12
XFILLER_59_278 VGND VGND VPWR VPWR sky130_fd_sc_hd__fill_2
XFILLER_19_55 VGND VGND VPWR VPWR sky130_fd_sc_hd__fill_1
X_09718_ _02683_ cpuregs\[5\]\[24\] _04872_ VGND VGND VPWR VPWR _01374_ sky130_fd_sc_hd__mux2_1
XTAP_TAPCELL_ROW_126_2345 VGND VPWR sky130_fd_sc_hd__tapvpwrvgnd_1
X_07979_ _03796_ _03797_ _03801_ _03802_ VGND VGND VPWR VPWR _03803_ sky130_fd_sc_hd__o22a_1
X_10990_ clknet_leaf_46_clk _01052_ VGND VGND VPWR VPWR cpuregs\[18\]\[22\] sky130_fd_sc_hd__dfxtp_1
X_09649_ _02675_ cpuregs\[22\]\[22\] _04869_ VGND VGND VPWR VPWR _01308_ sky130_fd_sc_hd__mux2_1
XFILLER_15_315 VGND VGND VPWR VPWR sky130_fd_sc_hd__decap_4
XFILLER_16_849 VPWR VGND VPWR VGND sky130_ef_sc_hd__decap_12
XFILLER_28_698 VGND VGND VPWR VPWR sky130_fd_sc_hd__fill_2
XPHY_EDGE_ROW_45_Right_45 VGND VGND VPWR VPWR sky130_fd_sc_hd__decap_3
XFILLER_150_3 VPWR VGND VPWR VGND sky130_ef_sc_hd__decap_12
XFILLER_15_337 VGND VGND VPWR VPWR sky130_fd_sc_hd__decap_3
X_11611_ net125 VGND VGND VPWR VPWR net231 sky130_fd_sc_hd__clkbuf_1
XTAP_TAPCELL_ROW_46_1060 VGND VPWR sky130_fd_sc_hd__tapvpwrvgnd_1
XTAP_TAPCELL_ROW_46_1071 VGND VPWR sky130_fd_sc_hd__tapvpwrvgnd_1
XTAP_TAPCELL_ROW_104_1997 VGND VPWR sky130_fd_sc_hd__tapvpwrvgnd_1
XFILLER_11_521 VGND VGND VPWR VPWR sky130_fd_sc_hd__decap_8
XTAP_TAPCELL_ROW_13_538 VGND VPWR sky130_fd_sc_hd__tapvpwrvgnd_1
Xclkbuf_leaf_116_clk clknet_4_10_0_clk VGND VGND VPWR VPWR clknet_leaf_116_clk sky130_fd_sc_hd__clkbuf_8
XFILLER_24_893 VPWR VGND VPWR VGND sky130_ef_sc_hd__decap_12
XFILLER_129_729 VPWR VGND VPWR VGND sky130_ef_sc_hd__decap_12
XFILLER_51_31 VPWR VGND VPWR VGND sky130_ef_sc_hd__decap_12
XFILLER_109_442 VGND VGND VPWR VPWR sky130_fd_sc_hd__decap_6
XFILLER_11_587 VPWR VGND VPWR VGND sky130_ef_sc_hd__decap_12
X_11473_ clknet_leaf_145_clk _01517_ VGND VGND VPWR VPWR cpuregs\[10\]\[7\] sky130_fd_sc_hd__dfxtp_1
XFILLER_136_250 VGND VGND VPWR VPWR sky130_fd_sc_hd__fill_2
X_10424_ clknet_leaf_3_clk _00554_ VGND VGND VPWR VPWR cpuregs\[17\]\[6\] sky130_fd_sc_hd__dfxtp_1
XPHY_EDGE_ROW_54_Right_54 VGND VGND VPWR VPWR sky130_fd_sc_hd__decap_3
XFILLER_140_905 VGND VGND VPWR VPWR sky130_fd_sc_hd__decap_4
XFILLER_98_819 VPWR VGND VPWR VGND sky130_ef_sc_hd__decap_12
XFILLER_3_753 VPWR VGND VPWR VGND sky130_ef_sc_hd__decap_12
X_10355_ clknet_leaf_117_clk _00485_ VGND VGND VPWR VPWR cpuregs\[25\]\[1\] sky130_fd_sc_hd__dfxtp_1
X_10286_ clknet_leaf_39_clk _00416_ VGND VGND VPWR VPWR cpuregs\[15\]\[28\] sky130_fd_sc_hd__dfxtp_1
XFILLER_3_797 VPWR VGND VPWR VGND sky130_ef_sc_hd__decap_12
XFILLER_78_554 VGND VGND VPWR VPWR sky130_fd_sc_hd__fill_1
XFILLER_120_651 VGND VGND VPWR VPWR sky130_fd_sc_hd__decap_4
XFILLER_78_587 VGND VGND VPWR VPWR sky130_fd_sc_hd__fill_1
XFILLER_38_407 VPWR VGND VPWR VGND sky130_ef_sc_hd__decap_12
XFILLER_38_429 VGND VGND VPWR VPWR sky130_fd_sc_hd__fill_1
XPHY_EDGE_ROW_63_Right_63 VGND VGND VPWR VPWR sky130_fd_sc_hd__decap_3
XFILLER_19_665 VGND VGND VPWR VPWR sky130_fd_sc_hd__decap_6
XFILLER_19_698 VPWR VGND VPWR VGND sky130_ef_sc_hd__decap_12
XFILLER_73_281 VGND VGND VPWR VPWR sky130_fd_sc_hd__fill_2
XFILLER_61_443 VGND VGND VPWR VPWR sky130_fd_sc_hd__fill_1
XFILLER_18_197 VGND VGND VPWR VPWR sky130_fd_sc_hd__decap_4
XFILLER_22_808 VGND VGND VPWR VPWR sky130_fd_sc_hd__decap_4
X_05330_ _01908_ _01923_ VGND VGND VPWR VPWR _01924_ sky130_fd_sc_hd__or2_1
Xclkbuf_leaf_107_clk clknet_4_11_0_clk VGND VGND VPWR VPWR clknet_leaf_107_clk sky130_fd_sc_hd__clkbuf_8
XTAP_TAPCELL_ROW_32_836 VGND VPWR sky130_fd_sc_hd__tapvpwrvgnd_1
XTAP_TAPCELL_ROW_32_847 VGND VPWR sky130_fd_sc_hd__tapvpwrvgnd_1
X_05261_ _01856_ _01859_ _01860_ cpu_state\[6\] VGND VGND VPWR VPWR _01861_ sky130_fd_sc_hd__o211a_1
X_07000_ cpuregs\[12\]\[25\] cpuregs\[13\]\[25\] cpuregs\[14\]\[25\] cpuregs\[15\]\[25\]
+ net267 net261 VGND VGND VPWR VPWR _03413_ sky130_fd_sc_hd__mux4_1
XPHY_EDGE_ROW_72_Right_72 VGND VGND VPWR VPWR sky130_fd_sc_hd__decap_3
X_05192_ count_cycle\[10\] _01588_ _01796_ VGND VGND VPWR VPWR _01797_ sky130_fd_sc_hd__o21ai_1
XTAP_TAPCELL_ROW_77_1565 VGND VPWR sky130_fd_sc_hd__tapvpwrvgnd_1
XFILLER_142_253 VGND VGND VPWR VPWR sky130_fd_sc_hd__decap_8
XFILLER_142_242 VGND VGND VPWR VPWR sky130_fd_sc_hd__decap_8
XFILLER_88_307 VGND VGND VPWR VPWR sky130_fd_sc_hd__fill_1
XFILLER_143_798 VPWR VGND VPWR VGND sky130_ef_sc_hd__decap_12
Xpicorv32_289 VGND VGND VPWR VPWR picorv32_289/HI eoi[8] sky130_fd_sc_hd__conb_1
X_08951_ decoded_imm\[25\] _01654_ _01586_ VGND VGND VPWR VPWR _04628_ sky130_fd_sc_hd__a21o_1
X_08882_ cpuregs\[28\]\[22\] cpuregs\[29\]\[22\] cpuregs\[30\]\[22\] cpuregs\[31\]\[22\]
+ net276 net272 VGND VGND VPWR VPWR _04562_ sky130_fd_sc_hd__mux4_1
XFILLER_130_459 VPWR VGND VPWR VGND sky130_ef_sc_hd__decap_12
XFILLER_130_437 VGND VGND VPWR VPWR sky130_fd_sc_hd__fill_1
XFILLER_111_640 VGND VGND VPWR VPWR sky130_fd_sc_hd__fill_1
XFILLER_97_841 VPWR VGND VPWR VGND sky130_ef_sc_hd__decap_12
XTAP_TAPCELL_ROW_90_1776 VGND VPWR sky130_fd_sc_hd__tapvpwrvgnd_1
XTAP_TAPCELL_ROW_90_1765 VGND VPWR sky130_fd_sc_hd__tapvpwrvgnd_1
X_07902_ decoded_imm_j\[3\] _03689_ VGND VGND VPWR VPWR _03732_ sky130_fd_sc_hd__nand2_1
XFILLER_111_673 VPWR VGND VPWR VGND sky130_ef_sc_hd__decap_12
XFILLER_57_727 VGND VGND VPWR VPWR sky130_fd_sc_hd__fill_1
XFILLER_57_705 VGND VGND VPWR VPWR sky130_fd_sc_hd__fill_1
X_07833_ _02599_ reg_next_pc\[5\] _02482_ VGND VGND VPWR VPWR _03692_ sky130_fd_sc_hd__mux2_2
XFILLER_96_384 VPWR VGND VPWR VGND sky130_ef_sc_hd__decap_12
XPHY_EDGE_ROW_81_Right_81 VGND VGND VPWR VPWR sky130_fd_sc_hd__decap_3
XTAP_TAPCELL_ROW_108_2064 VGND VPWR sky130_fd_sc_hd__tapvpwrvgnd_1
XTAP_TAPCELL_ROW_108_2053 VGND VPWR sky130_fd_sc_hd__tapvpwrvgnd_1
X_07764_ count_instr\[41\] _03648_ net34 VGND VGND VPWR VPWR _03650_ sky130_fd_sc_hd__o21ai_1
XFILLER_56_259 VGND VGND VPWR VPWR sky130_fd_sc_hd__fill_2
XFILLER_56_248 VGND VGND VPWR VPWR sky130_fd_sc_hd__decap_4
XFILLER_37_440 VGND VGND VPWR VPWR sky130_fd_sc_hd__fill_1
X_04976_ mem_do_rinst reg_pc\[1\] _01604_ _01605_ VGND VGND VPWR VPWR _01606_ sky130_fd_sc_hd__a22o_1
X_07695_ count_instr\[16\] _03604_ net34 VGND VGND VPWR VPWR _03606_ sky130_fd_sc_hd__o21ai_1
X_06715_ net173 _02721_ _02744_ _03137_ VGND VGND VPWR VPWR _03138_ sky130_fd_sc_hd__o211a_1
XFILLER_65_793 VPWR VGND VPWR VGND sky130_ef_sc_hd__decap_12
XFILLER_25_613 VGND VGND VPWR VPWR sky130_fd_sc_hd__decap_3
XFILLER_37_473 VGND VGND VPWR VPWR sky130_fd_sc_hd__decap_8
X_09503_ cpuregs\[31\]\[8\] _02616_ net240 VGND VGND VPWR VPWR _01166_ sky130_fd_sc_hd__mux2_1
X_06646_ cpuregs\[28\]\[12\] cpuregs\[29\]\[12\] cpuregs\[30\]\[12\] cpuregs\[31\]\[12\]
+ net263 net259 VGND VGND VPWR VPWR _03072_ sky130_fd_sc_hd__mux4_1
XFILLER_52_421 VPWR VGND VPWR VGND sky130_ef_sc_hd__decap_12
X_09434_ _02603_ cpuregs\[19\]\[5\] _04863_ VGND VGND VPWR VPWR _01067_ sky130_fd_sc_hd__mux2_1
XFILLER_37_495 VGND VGND VPWR VPWR sky130_fd_sc_hd__fill_1
XTAP_TAPCELL_ROW_121_2275 VGND VPWR sky130_fd_sc_hd__tapvpwrvgnd_1
XTAP_TAPCELL_ROW_121_2264 VGND VPWR sky130_fd_sc_hd__tapvpwrvgnd_1
XFILLER_40_627 VPWR VGND VPWR VGND sky130_ef_sc_hd__decap_12
X_09365_ decoded_imm\[13\] _04746_ _04824_ _04844_ VGND VGND VPWR VPWR _01017_ sky130_fd_sc_hd__o22a_1
X_06577_ decoded_imm\[10\] net172 VGND VGND VPWR VPWR _03005_ sky130_fd_sc_hd__nand2_1
XFILLER_21_841 VPWR VGND VPWR VGND sky130_ef_sc_hd__decap_12
XANTENNA_30 net220 VGND VGND VPWR VPWR sky130_fd_sc_hd__diode_2
X_05528_ net178 net210 VGND VGND VPWR VPWR _02111_ sky130_fd_sc_hd__and2_1
X_08316_ count_cycle\[20\] count_cycle\[21\] _04092_ VGND VGND VPWR VPWR _04096_ sky130_fd_sc_hd__and3_1
X_09296_ net153 net115 _04206_ VGND VGND VPWR VPWR _00982_ sky130_fd_sc_hd__mux2_1
XANTENNA_41 net201 VGND VGND VPWR VPWR sky130_fd_sc_hd__diode_2
X_05459_ count_instr\[63\] instr_rdinstrh _01587_ _02042_ VGND VGND VPWR VPWR _02043_
+ sky130_fd_sc_hd__a211o_1
X_08247_ _03576_ _04049_ VGND VGND VPWR VPWR _04050_ sky130_fd_sc_hd__nor2_1
XPHY_EDGE_ROW_90_Right_90 VGND VGND VPWR VPWR sky130_fd_sc_hd__decap_3
XFILLER_134_732 VGND VGND VPWR VPWR sky130_fd_sc_hd__decap_6
XFILLER_134_710 VPWR VGND VPWR VGND sky130_ef_sc_hd__decap_12
X_08178_ decoded_imm_j\[20\] _03712_ VGND VGND VPWR VPWR _03986_ sky130_fd_sc_hd__and2_1
XFILLER_106_401 VGND VGND VPWR VPWR sky130_fd_sc_hd__fill_2
XFILLER_122_905 VGND VGND VPWR VPWR sky130_fd_sc_hd__decap_4
X_07129_ cpuregs\[24\]\[30\] cpuregs\[25\]\[30\] cpuregs\[26\]\[30\] cpuregs\[27\]\[30\]
+ net265 net260 VGND VGND VPWR VPWR _03537_ sky130_fd_sc_hd__mux4_1
XFILLER_133_275 VGND VGND VPWR VPWR sky130_fd_sc_hd__decap_4
X_10140_ clknet_leaf_12_clk _00270_ VGND VGND VPWR VPWR cpuregs\[21\]\[10\] sky130_fd_sc_hd__dfxtp_1
XFILLER_0_701 VGND VGND VPWR VPWR sky130_fd_sc_hd__fill_2
Xoutput170 net170 VGND VGND VPWR VPWR mem_wstrb[3] sky130_fd_sc_hd__buf_2
Xoutput181 net181 VGND VGND VPWR VPWR pcpi_rs1[19] sky130_fd_sc_hd__buf_2
Xoutput192 net192 VGND VGND VPWR VPWR pcpi_rs1[29] sky130_fd_sc_hd__buf_2
XFILLER_88_841 VPWR VGND VPWR VGND sky130_ef_sc_hd__decap_12
X_10071_ clknet_leaf_143_clk _00201_ VGND VGND VPWR VPWR cpuregs\[2\]\[5\] sky130_fd_sc_hd__dfxtp_1
XFILLER_0_734 VGND VGND VPWR VPWR sky130_fd_sc_hd__decap_4
XFILLER_47_204 VGND VGND VPWR VPWR sky130_fd_sc_hd__decap_4
XFILLER_75_535 VPWR VGND VPWR VGND sky130_ef_sc_hd__decap_12
XFILLER_75_524 VGND VGND VPWR VPWR sky130_fd_sc_hd__fill_2
XFILLER_56_793 VGND VGND VPWR VPWR sky130_fd_sc_hd__fill_1
XTAP_TAPCELL_ROW_48_1100 VGND VPWR sky130_fd_sc_hd__tapvpwrvgnd_1
X_10973_ clknet_leaf_142_clk _01035_ VGND VGND VPWR VPWR cpuregs\[18\]\[5\] sky130_fd_sc_hd__dfxtp_1
XTAP_TAPCELL_ROW_18_619 VGND VPWR sky130_fd_sc_hd__tapvpwrvgnd_1
XFILLER_46_53 VPWR VGND VPWR VGND sky130_ef_sc_hd__decap_12
XFILLER_55_281 VPWR VGND VPWR VGND sky130_ef_sc_hd__decap_12
XFILLER_16_657 VGND VGND VPWR VPWR sky130_fd_sc_hd__decap_4
XTAP_TAPCELL_ROW_61_1300 VGND VPWR sky130_fd_sc_hd__tapvpwrvgnd_1
XFILLER_62_41 VPWR VGND VPWR VGND sky130_ef_sc_hd__decap_12
XTAP_TAPCELL_ROW_61_1311 VGND VPWR sky130_fd_sc_hd__tapvpwrvgnd_1
XTAP_TAPCELL_ROW_139_2558 VGND VPWR sky130_fd_sc_hd__tapvpwrvgnd_1
XFILLER_129_559 VGND VGND VPWR VPWR sky130_fd_sc_hd__fill_1
XTAP_TAPCELL_ROW_152_2758 VGND VPWR sky130_fd_sc_hd__tapvpwrvgnd_1
XFILLER_8_867 VGND VGND VPWR VPWR sky130_fd_sc_hd__fill_1
XFILLER_7_69 VPWR VGND VPWR VGND sky130_ef_sc_hd__decap_12
Xwire242 net243 VGND VGND VPWR VPWR net242 sky130_fd_sc_hd__clkbuf_8
Xwire253 _03552_ VGND VGND VPWR VPWR net253 sky130_fd_sc_hd__buf_12
XTAP_TAPCELL_ROW_152_2769 VGND VPWR sky130_fd_sc_hd__tapvpwrvgnd_1
X_11456_ clknet_leaf_46_clk _01500_ VGND VGND VPWR VPWR cpuregs\[0\]\[22\] sky130_fd_sc_hd__dfxtp_1
X_10407_ clknet_leaf_75_clk _00537_ VGND VGND VPWR VPWR cpuregs\[20\]\[21\] sky130_fd_sc_hd__dfxtp_1
XFILLER_125_743 VGND VGND VPWR VPWR sky130_fd_sc_hd__fill_1
X_11387_ clknet_leaf_24_clk _01431_ VGND VGND VPWR VPWR cpuregs\[7\]\[17\] sky130_fd_sc_hd__dfxtp_1
XTAP_TAPCELL_ROW_59_1273 VGND VPWR sky130_fd_sc_hd__tapvpwrvgnd_1
XFILLER_140_713 VPWR VGND VPWR VGND sky130_ef_sc_hd__decap_12
XFILLER_124_275 VPWR VGND VPWR VGND sky130_ef_sc_hd__decap_12
XFILLER_124_253 VPWR VGND VPWR VGND sky130_ef_sc_hd__decap_12
XFILLER_112_415 VGND VGND VPWR VPWR sky130_fd_sc_hd__decap_4
X_10338_ clknet_leaf_54_clk _00468_ VGND VGND VPWR VPWR cpuregs\[16\]\[16\] sky130_fd_sc_hd__dfxtp_1
XFILLER_97_104 VGND VGND VPWR VPWR sky130_fd_sc_hd__decap_8
XFILLER_3_561 VPWR VGND VPWR VGND sky130_ef_sc_hd__decap_12
XFILLER_140_757 VGND VGND VPWR VPWR sky130_fd_sc_hd__decap_6
XFILLER_79_841 VPWR VGND VPWR VGND sky130_ef_sc_hd__decap_12
XFILLER_140_779 VPWR VGND VPWR VGND sky130_ef_sc_hd__decap_12
XFILLER_78_362 VGND VGND VPWR VPWR sky130_fd_sc_hd__fill_2
XTAP_TAPCELL_ROW_72_1484 VGND VPWR sky130_fd_sc_hd__tapvpwrvgnd_1
X_10269_ clknet_leaf_147_clk _00399_ VGND VGND VPWR VPWR cpuregs\[15\]\[11\] sky130_fd_sc_hd__dfxtp_1
XFILLER_120_492 VPWR VGND VPWR VGND sky130_ef_sc_hd__decap_12
XFILLER_66_579 VGND VGND VPWR VPWR sky130_fd_sc_hd__decap_8
XFILLER_19_440 VGND VGND VPWR VPWR sky130_fd_sc_hd__decap_8
XFILLER_47_760 VGND VGND VPWR VPWR sky130_fd_sc_hd__fill_1
XFILLER_53_229 VGND VGND VPWR VPWR sky130_fd_sc_hd__fill_1
XTAP_TAPCELL_ROW_37_917 VGND VPWR sky130_fd_sc_hd__tapvpwrvgnd_1
XTAP_TAPCELL_ROW_37_928 VGND VPWR sky130_fd_sc_hd__tapvpwrvgnd_1
XFILLER_47_793 VGND VGND VPWR VPWR sky130_fd_sc_hd__decap_6
X_07480_ cpuregs\[15\]\[31\] _02712_ net246 VGND VGND VPWR VPWR _00419_ sky130_fd_sc_hd__mux2_1
XFILLER_34_421 VGND VGND VPWR VPWR sky130_fd_sc_hd__fill_1
X_06500_ net199 _02721_ VGND VGND VPWR VPWR _02931_ sky130_fd_sc_hd__or2_1
XFILLER_34_465 VGND VGND VPWR VPWR sky130_fd_sc_hd__decap_8
X_06431_ _02806_ _02808_ _02863_ VGND VGND VPWR VPWR _02865_ sky130_fd_sc_hd__o21ai_1
XFILLER_148_813 VPWR VGND VPWR VGND sky130_ef_sc_hd__decap_12
X_09150_ instr_sltu _04748_ _04766_ _04772_ VGND VGND VPWR VPWR _00874_ sky130_fd_sc_hd__a22o_1
XFILLER_21_137 VPWR VGND VPWR VGND sky130_ef_sc_hd__decap_12
X_06362_ net606 net196 _02721_ VGND VGND VPWR VPWR _02798_ sky130_fd_sc_hd__mux2_1
X_05313_ reg_pc\[20\] decoded_imm\[20\] VGND VGND VPWR VPWR _01908_ sky130_fd_sc_hd__nand2_1
X_08101_ _03575_ _03914_ _03915_ VGND VGND VPWR VPWR _03916_ sky130_fd_sc_hd__a21o_1
X_09081_ mem_rdata_q\[5\] _01610_ _04740_ VGND VGND VPWR VPWR _04741_ sky130_fd_sc_hd__a21oi_2
X_06293_ _01579_ _02730_ VGND VGND VPWR VPWR _02731_ sky130_fd_sc_hd__or2_1
XFILLER_107_209 VGND VGND VPWR VPWR sky130_fd_sc_hd__decap_8
X_05244_ _01844_ cpu_state\[3\] _01843_ VGND VGND VPWR VPWR _01845_ sky130_fd_sc_hd__and3b_1
X_08032_ _03844_ _03849_ VGND VGND VPWR VPWR _03852_ sky130_fd_sc_hd__nand2_1
XTAP_TAPCELL_ROW_92_1805 VGND VPWR sky130_fd_sc_hd__tapvpwrvgnd_1
X_05175_ _01779_ _01780_ VGND VGND VPWR VPWR _01781_ sky130_fd_sc_hd__nand2_1
X_09983_ clknet_leaf_10_clk _00113_ VGND VGND VPWR VPWR cpuregs\[12\]\[13\] sky130_fd_sc_hd__dfxtp_1
X_08934_ cpuregs\[24\]\[25\] cpuregs\[25\]\[25\] cpuregs\[26\]\[25\] cpuregs\[27\]\[25\]
+ net280 net274 VGND VGND VPWR VPWR _04611_ sky130_fd_sc_hd__mux4_1
XFILLER_97_660 VGND VGND VPWR VPWR sky130_fd_sc_hd__decap_6
X_08865_ cpuregs\[24\]\[21\] cpuregs\[25\]\[21\] cpuregs\[26\]\[21\] cpuregs\[27\]\[21\]
+ _00007_ net274 VGND VGND VPWR VPWR _04546_ sky130_fd_sc_hd__mux4_1
XTAP_TAPCELL_ROW_123_2304 VGND VPWR sky130_fd_sc_hd__tapvpwrvgnd_1
X_07816_ count_instr\[60\] _03679_ count_instr\[61\] VGND VGND VPWR VPWR _03682_ sky130_fd_sc_hd__a21o_1
X_08796_ cpuregs\[4\]\[17\] cpuregs\[5\]\[17\] cpuregs\[6\]\[17\] cpuregs\[7\]\[17\]
+ net277 net272 VGND VGND VPWR VPWR _04481_ sky130_fd_sc_hd__mux4_1
XFILLER_29_248 VGND VGND VPWR VPWR sky130_fd_sc_hd__decap_4
XFILLER_123_69 VPWR VGND VPWR VGND sky130_ef_sc_hd__decap_12
X_07747_ _03634_ count_instr\[34\] count_instr\[33\] count_instr\[35\] VGND VGND VPWR
+ VPWR _03639_ sky130_fd_sc_hd__and4_1
X_04959_ instr_auipc instr_lui VGND VGND VPWR VPWR _01589_ sky130_fd_sc_hd__or2_4
X_07678_ _03590_ count_instr\[9\] count_instr\[8\] count_instr\[10\] VGND VGND VPWR
+ VPWR _03595_ sky130_fd_sc_hd__and4_1
XPHY_EDGE_ROW_0_Right_0 VGND VGND VPWR VPWR sky130_fd_sc_hd__decap_3
X_09417_ _02670_ cpuregs\[18\]\[21\] _04862_ VGND VGND VPWR VPWR _01051_ sky130_fd_sc_hd__mux2_1
X_06629_ net236 _03040_ _03055_ _03032_ VGND VGND VPWR VPWR _00080_ sky130_fd_sc_hd__a31o_1
XTAP_TAPCELL_ROW_101_1945 VGND VPWR sky130_fd_sc_hd__tapvpwrvgnd_1
X_09348_ mem_rdata_q\[21\] _01589_ VGND VGND VPWR VPWR _04836_ sky130_fd_sc_hd__and2_1
XTAP_TAPCELL_ROW_23_699 VGND VPWR sky130_fd_sc_hd__tapvpwrvgnd_1
X_09279_ net166 net128 _04206_ VGND VGND VPWR VPWR _00965_ sky130_fd_sc_hd__mux2_1
X_11310_ clknet_leaf_148_clk _01357_ VGND VGND VPWR VPWR cpuregs\[5\]\[7\] sky130_fd_sc_hd__dfxtp_1
XFILLER_153_337 VGND VGND VPWR VPWR sky130_fd_sc_hd__fill_2
XFILLER_148_77 VGND VGND VPWR VPWR sky130_fd_sc_hd__decap_6
XTAP_TAPCELL_ROW_134_2477 VGND VPWR sky130_fd_sc_hd__tapvpwrvgnd_1
XFILLER_119_581 VGND VGND VPWR VPWR sky130_fd_sc_hd__decap_3
X_11241_ clknet_leaf_122_clk _01288_ VGND VGND VPWR VPWR cpuregs\[22\]\[2\] sky130_fd_sc_hd__dfxtp_1
X_11172_ clknet_leaf_32_clk _01219_ VGND VGND VPWR VPWR cpuregs\[23\]\[29\] sky130_fd_sc_hd__dfxtp_1
X_10123_ clknet_leaf_66_clk _00253_ VGND VGND VPWR VPWR cpuregs\[28\]\[25\] sky130_fd_sc_hd__dfxtp_1
XFILLER_106_286 VGND VGND VPWR VPWR sky130_fd_sc_hd__decap_6
XFILLER_0_553 VGND VGND VPWR VPWR sky130_fd_sc_hd__decap_6
X_10054_ clknet_leaf_72_clk _00184_ VGND VGND VPWR VPWR cpuregs\[13\]\[20\] sky130_fd_sc_hd__dfxtp_1
XTAP_TAPCELL_ROW_54_1192 VGND VPWR sky130_fd_sc_hd__tapvpwrvgnd_1
XFILLER_91_847 VGND VGND VPWR VPWR sky130_fd_sc_hd__fill_1
XFILLER_75_376 VGND VGND VPWR VPWR sky130_fd_sc_hd__decap_4
XTAP_TAPCELL_ROW_3_380 VGND VPWR sky130_fd_sc_hd__tapvpwrvgnd_1
XPHY_EDGE_ROW_121_Right_121 VGND VGND VPWR VPWR sky130_fd_sc_hd__decap_3
XFILLER_113_91 VGND VGND VPWR VPWR sky130_fd_sc_hd__decap_8
XFILLER_28_281 VGND VGND VPWR VPWR sky130_fd_sc_hd__fill_1
X_10956_ clknet_leaf_93_clk _01018_ VGND VGND VPWR VPWR decoded_imm\[12\] sky130_fd_sc_hd__dfxtp_2
XFILLER_73_73 VGND VGND VPWR VPWR sky130_fd_sc_hd__fill_2
X_10887_ clknet_leaf_135_clk _00949_ VGND VGND VPWR VPWR cpuregs\[1\]\[31\] sky130_fd_sc_hd__dfxtp_1
XFILLER_148_109 VPWR VGND VPWR VGND sky130_ef_sc_hd__decap_12
XFILLER_129_334 VGND VGND VPWR VPWR sky130_fd_sc_hd__fill_2
XTAP_TAPCELL_ROW_42_997 VGND VPWR sky130_fd_sc_hd__tapvpwrvgnd_1
XFILLER_129_378 VPWR VGND VPWR VGND sky130_ef_sc_hd__decap_12
XTAP_TAPCELL_ROW_74_1513 VGND VPWR sky130_fd_sc_hd__tapvpwrvgnd_1
X_11439_ clknet_leaf_142_clk _01483_ VGND VGND VPWR VPWR cpuregs\[0\]\[5\] sky130_fd_sc_hd__dfxtp_1
XFILLER_153_860 VGND VGND VPWR VPWR sky130_fd_sc_hd__decap_4
XFILLER_98_413 VGND VGND VPWR VPWR sky130_fd_sc_hd__decap_6
XFILLER_98_424 VGND VGND VPWR VPWR sky130_fd_sc_hd__decap_8
XFILLER_4_881 VPWR VGND VPWR VGND sky130_ef_sc_hd__decap_12
XFILLER_140_554 VPWR VGND VPWR VGND sky130_ef_sc_hd__decap_12
X_06980_ _00015_ _03390_ _03393_ _02735_ VGND VGND VPWR VPWR _03394_ sky130_fd_sc_hd__o211a_1
XFILLER_86_608 VPWR VGND VPWR VGND sky130_ef_sc_hd__decap_12
XFILLER_3_391 VGND VGND VPWR VPWR sky130_fd_sc_hd__fill_1
XFILLER_39_502 VGND VGND VPWR VPWR sky130_fd_sc_hd__fill_2
XFILLER_94_630 VGND VGND VPWR VPWR sky130_fd_sc_hd__fill_1
X_05931_ mem_wordsize\[1\] net119 net204 _01672_ VGND VGND VPWR VPWR net98 sky130_fd_sc_hd__a22o_1
X_05862_ _02060_ _02420_ VGND VGND VPWR VPWR _02421_ sky130_fd_sc_hd__xnor2_1
X_08650_ _01558_ _04342_ VGND VGND VPWR VPWR _04343_ sky130_fd_sc_hd__or2_1
X_07601_ cpuregs\[20\]\[18\] _02657_ net245 VGND VGND VPWR VPWR _00534_ sky130_fd_sc_hd__mux2_1
XTAP_TAPCELL_ROW_105_2012 VGND VPWR sky130_fd_sc_hd__tapvpwrvgnd_1
XFILLER_26_218 VPWR VGND VPWR VGND sky130_ef_sc_hd__decap_12
X_05793_ _02110_ _02355_ _02357_ net255 VGND VGND VPWR VPWR _02359_ sky130_fd_sc_hd__o31a_1
XFILLER_81_335 VGND VGND VPWR VPWR sky130_fd_sc_hd__fill_1
XFILLER_19_270 VGND VGND VPWR VPWR sky130_fd_sc_hd__decap_8
X_08581_ _00011_ _04276_ _01559_ VGND VGND VPWR VPWR _04278_ sky130_fd_sc_hd__a21o_1
X_07532_ _02649_ cpuregs\[16\]\[16\] _03570_ VGND VGND VPWR VPWR _00468_ sky130_fd_sc_hd__mux2_1
XFILLER_81_379 VPWR VGND VPWR VGND sky130_ef_sc_hd__decap_12
XTAP_TAPCELL_ROW_85_1697 VGND VPWR sky130_fd_sc_hd__tapvpwrvgnd_1
XTAP_TAPCELL_ROW_85_1686 VGND VPWR sky130_fd_sc_hd__tapvpwrvgnd_1
X_07463_ cpuregs\[15\]\[14\] _02641_ net246 VGND VGND VPWR VPWR _00402_ sky130_fd_sc_hd__mux2_1
XFILLER_34_273 VGND VGND VPWR VPWR sky130_fd_sc_hd__fill_1
XFILLER_35_785 VPWR VGND VPWR VGND sky130_ef_sc_hd__decap_12
XFILLER_148_610 VGND VGND VPWR VPWR sky130_fd_sc_hd__decap_6
XFILLER_50_755 VGND VGND VPWR VPWR sky130_fd_sc_hd__fill_1
X_09202_ decoded_rd\[3\] _01104_ _02513_ VGND VGND VPWR VPWR _00901_ sky130_fd_sc_hd__mux2_1
X_06414_ net258 _02847_ _01580_ VGND VGND VPWR VPWR _02848_ sky130_fd_sc_hd__a21o_1
X_09133_ instr_ori _04748_ _04756_ _04765_ VGND VGND VPWR VPWR _00865_ sky130_fd_sc_hd__a22o_1
X_07394_ cpuregs\[14\]\[12\] _02633_ net247 VGND VGND VPWR VPWR _00336_ sky130_fd_sc_hd__mux2_1
Xrebuffer205 net590 VGND VGND VPWR VPWR net591 sky130_fd_sc_hd__dlymetal6s4s_1
X_06345_ cpuregs\[16\]\[2\] cpuregs\[17\]\[2\] cpuregs\[18\]\[2\] cpuregs\[19\]\[2\]
+ net264 net262 VGND VGND VPWR VPWR _02781_ sky130_fd_sc_hd__mux4_1
XTAP_TAPCELL_ROW_20_647 VGND VPWR sky130_fd_sc_hd__tapvpwrvgnd_1
XTAP_TAPCELL_ROW_20_658 VGND VPWR sky130_fd_sc_hd__tapvpwrvgnd_1
Xrebuffer227 net608 VGND VGND VPWR VPWR net613 sky130_fd_sc_hd__dlygate4sd1_1
Xrebuffer216 latched_branch VGND VGND VPWR VPWR net602 sky130_fd_sc_hd__dlygate4sd1_1
XFILLER_136_849 VPWR VGND VPWR VGND sky130_ef_sc_hd__decap_12
XFILLER_135_304 VPWR VGND VPWR VGND sky130_ef_sc_hd__decap_12
X_06276_ cpu_state\[4\] _01622_ VGND VGND VPWR VPWR _02714_ sky130_fd_sc_hd__nor2_8
X_09064_ net598 _04732_ _04733_ _04731_ net34 VGND VGND VPWR VPWR _00838_ sky130_fd_sc_hd__o221a_1
XFILLER_135_348 VGND VGND VPWR VPWR sky130_fd_sc_hd__decap_8
XFILLER_135_337 VGND VGND VPWR VPWR sky130_fd_sc_hd__fill_2
XTAP_TAPCELL_ROW_116_2185 VGND VPWR sky130_fd_sc_hd__tapvpwrvgnd_1
X_05227_ reg_pc\[13\] decoded_imm\[13\] VGND VGND VPWR VPWR _01829_ sky130_fd_sc_hd__nor2_1
X_08015_ instr_jal _03834_ _03835_ VGND VGND VPWR VPWR _03836_ sky130_fd_sc_hd__or3_1
XFILLER_78_29 VPWR VGND VPWR VGND sky130_ef_sc_hd__decap_12
X_05158_ _01754_ _01757_ VGND VGND VPWR VPWR _01765_ sky130_fd_sc_hd__and2b_1
XFILLER_144_893 VPWR VGND VPWR VGND sky130_ef_sc_hd__decap_12
XFILLER_104_735 VPWR VGND VPWR VGND sky130_ef_sc_hd__decap_12
XFILLER_1_317 VGND VGND VPWR VPWR sky130_fd_sc_hd__decap_3
X_09966_ clknet_leaf_56_clk _00096_ VGND VGND VPWR VPWR net190 sky130_fd_sc_hd__dfxtp_4
X_05089_ cpu_state\[3\] _01696_ _01698_ cpu_state\[4\] net193 VGND VGND VPWR VPWR
+ _01702_ sky130_fd_sc_hd__a32o_1
X_08917_ cpuregs\[28\]\[24\] cpuregs\[29\]\[24\] cpuregs\[30\]\[24\] cpuregs\[31\]\[24\]
+ net280 net274 VGND VGND VPWR VPWR _04595_ sky130_fd_sc_hd__mux4_1
X_09897_ cpuregs\[0\]\[27\] VGND VGND VPWR VPWR _01505_ sky130_fd_sc_hd__clkbuf_1
X_08848_ cpuregs\[0\]\[20\] cpuregs\[1\]\[20\] cpuregs\[2\]\[20\] cpuregs\[3\]\[20\]
+ _00007_ net274 VGND VGND VPWR VPWR _04530_ sky130_fd_sc_hd__mux4_1
Xclkbuf_leaf_96_clk clknet_4_9_0_clk VGND VGND VPWR VPWR clknet_leaf_96_clk sky130_fd_sc_hd__clkbuf_8
XFILLER_58_866 VGND VGND VPWR VPWR sky130_fd_sc_hd__fill_2
XFILLER_72_313 VGND VGND VPWR VPWR sky130_fd_sc_hd__fill_1
X_08779_ cpuregs\[4\]\[16\] cpuregs\[5\]\[16\] cpuregs\[6\]\[16\] cpuregs\[7\]\[16\]
+ net276 net272 VGND VGND VPWR VPWR _04465_ sky130_fd_sc_hd__mux4_1
XFILLER_27_55 VGND VGND VPWR VPWR sky130_fd_sc_hd__fill_1
X_10810_ clknet_leaf_97_clk _00875_ VGND VGND VPWR VPWR instr_xor sky130_fd_sc_hd__dfxtp_1
XFILLER_26_763 VGND VGND VPWR VPWR sky130_fd_sc_hd__fill_1
XFILLER_13_424 VGND VGND VPWR VPWR sky130_fd_sc_hd__decap_4
X_10741_ clknet_leaf_101_clk _00838_ VGND VGND VPWR VPWR latched_store sky130_fd_sc_hd__dfxtp_4
XTAP_TAPCELL_ROW_136_2506 VGND VPWR sky130_fd_sc_hd__tapvpwrvgnd_1
X_10672_ clknet_leaf_95_clk _04901_ VGND VGND VPWR VPWR reg_out\[30\] sky130_fd_sc_hd__dfxtp_1
XFILLER_13_479 VGND VGND VPWR VPWR sky130_fd_sc_hd__decap_8
XFILLER_40_265 VGND VGND VPWR VPWR sky130_fd_sc_hd__decap_6
XFILLER_138_153 VGND VGND VPWR VPWR sky130_fd_sc_hd__fill_1
Xclkbuf_leaf_20_clk clknet_4_6_0_clk VGND VGND VPWR VPWR clknet_leaf_20_clk sky130_fd_sc_hd__clkbuf_8
XFILLER_4_133 VGND VGND VPWR VPWR sky130_fd_sc_hd__decap_6
XFILLER_141_329 VGND VGND VPWR VPWR sky130_fd_sc_hd__decap_6
X_11224_ clknet_leaf_23_clk _01271_ VGND VGND VPWR VPWR cpuregs\[3\]\[17\] sky130_fd_sc_hd__dfxtp_1
XTAP_TAPCELL_ROW_56_1232 VGND VPWR sky130_fd_sc_hd__tapvpwrvgnd_1
XTAP_TAPCELL_ROW_56_1221 VGND VPWR sky130_fd_sc_hd__tapvpwrvgnd_1
XFILLER_4_15 VPWR VGND VPWR VGND sky130_ef_sc_hd__decap_12
XFILLER_134_370 VGND VGND VPWR VPWR sky130_fd_sc_hd__fill_2
XFILLER_4_177 VPWR VGND VPWR VGND sky130_ef_sc_hd__decap_12
X_11155_ clknet_leaf_6_clk _01202_ VGND VGND VPWR VPWR cpuregs\[23\]\[12\] sky130_fd_sc_hd__dfxtp_1
XTAP_TAPCELL_ROW_8_461 VGND VPWR sky130_fd_sc_hd__tapvpwrvgnd_1
XFILLER_122_598 VGND VGND VPWR VPWR sky130_fd_sc_hd__decap_4
XFILLER_122_587 VGND VGND VPWR VPWR sky130_fd_sc_hd__fill_1
X_11086_ clknet_leaf_21_clk _01143_ VGND VGND VPWR VPWR cpuregs\[24\]\[17\] sky130_fd_sc_hd__dfxtp_1
XFILLER_67_107 VGND VGND VPWR VPWR sky130_fd_sc_hd__decap_4
XFILLER_0_350 VGND VGND VPWR VPWR sky130_fd_sc_hd__decap_3
X_10106_ clknet_leaf_135_clk _00236_ VGND VGND VPWR VPWR cpuregs\[28\]\[8\] sky130_fd_sc_hd__dfxtp_1
XTAP_TAPCELL_ROW_147_2679 VGND VPWR sky130_fd_sc_hd__tapvpwrvgnd_1
Xclkbuf_leaf_87_clk clknet_4_14_0_clk VGND VGND VPWR VPWR clknet_leaf_87_clk sky130_fd_sc_hd__clkbuf_8
XFILLER_76_652 VGND VGND VPWR VPWR sky130_fd_sc_hd__fill_2
X_10037_ clknet_leaf_139_clk _00167_ VGND VGND VPWR VPWR cpuregs\[13\]\[3\] sky130_fd_sc_hd__dfxtp_1
XFILLER_48_365 VGND VGND VPWR VPWR sky130_fd_sc_hd__decap_6
XFILLER_90_132 VGND VGND VPWR VPWR sky130_fd_sc_hd__decap_8
XFILLER_63_335 VGND VGND VPWR VPWR sky130_fd_sc_hd__fill_1
X_10939_ clknet_leaf_95_clk _01001_ VGND VGND VPWR VPWR decoded_imm\[29\] sky130_fd_sc_hd__dfxtp_2
XFILLER_16_262 VGND VGND VPWR VPWR sky130_fd_sc_hd__decap_6
XFILLER_17_785 VPWR VGND VPWR VGND sky130_ef_sc_hd__decap_12
XFILLER_76_3 VGND VGND VPWR VPWR sky130_fd_sc_hd__decap_3
Xclkbuf_leaf_11_clk clknet_4_1_0_clk VGND VGND VPWR VPWR clknet_leaf_11_clk sky130_fd_sc_hd__clkbuf_8
XFILLER_12_490 VGND VGND VPWR VPWR sky130_fd_sc_hd__fill_1
XFILLER_129_164 VGND VGND VPWR VPWR sky130_fd_sc_hd__decap_4
X_06130_ reg_pc\[3\] reg_pc\[2\] reg_pc\[4\] VGND VGND VPWR VPWR _02596_ sky130_fd_sc_hd__a21oi_1
XFILLER_144_134 VGND VGND VPWR VPWR sky130_fd_sc_hd__decap_6
XFILLER_117_337 VGND VGND VPWR VPWR sky130_fd_sc_hd__fill_1
X_06061_ _02532_ _02533_ _01558_ VGND VGND VPWR VPWR _02534_ sky130_fd_sc_hd__mux2_1
X_05012_ cpu_state\[3\] is_beq_bne_blt_bge_bltu_bgeu VGND VGND VPWR VPWR _01635_ sky130_fd_sc_hd__and2_1
XFILLER_144_189 VGND VGND VPWR VPWR sky130_fd_sc_hd__decap_6
XFILLER_141_841 VPWR VGND VPWR VGND sky130_ef_sc_hd__decap_12
XFILLER_126_893 VPWR VGND VPWR VGND sky130_ef_sc_hd__decap_12
X_09820_ _02696_ cpuregs\[8\]\[27\] _04875_ VGND VGND VPWR VPWR _01473_ sky130_fd_sc_hd__mux2_1
XFILLER_113_554 VGND VGND VPWR VPWR sky130_fd_sc_hd__decap_6
X_09751_ _02683_ cpuregs\[6\]\[24\] _04873_ VGND VGND VPWR VPWR _01406_ sky130_fd_sc_hd__mux2_1
XFILLER_140_384 VPWR VGND VPWR VGND sky130_ef_sc_hd__decap_12
XFILLER_140_373 VGND VGND VPWR VPWR sky130_fd_sc_hd__fill_2
XFILLER_140_362 VGND VGND VPWR VPWR sky130_fd_sc_hd__fill_2
XFILLER_101_749 VGND VGND VPWR VPWR sky130_fd_sc_hd__decap_8
XFILLER_101_727 VGND VGND VPWR VPWR sky130_fd_sc_hd__fill_1
X_06963_ _01622_ _03375_ _03376_ VGND VGND VPWR VPWR _03377_ sky130_fd_sc_hd__and3_1
XFILLER_100_215 VGND VGND VPWR VPWR sky130_fd_sc_hd__decap_3
Xclkbuf_leaf_78_clk clknet_4_15_0_clk VGND VGND VPWR VPWR clknet_leaf_78_clk sky130_fd_sc_hd__clkbuf_8
XFILLER_104_27 VGND VGND VPWR VPWR sky130_fd_sc_hd__fill_1
X_05914_ _02070_ _02460_ _02226_ VGND VGND VPWR VPWR _02466_ sky130_fd_sc_hd__o21ai_1
X_08702_ cpuregs\[0\]\[12\] cpuregs\[1\]\[12\] cpuregs\[2\]\[12\] cpuregs\[3\]\[12\]
+ net278 net273 VGND VGND VPWR VPWR _04392_ sky130_fd_sc_hd__mux4_1
X_06894_ cpuregs\[4\]\[21\] cpuregs\[5\]\[21\] cpuregs\[6\]\[21\] cpuregs\[7\]\[21\]
+ _00012_ _00013_ VGND VGND VPWR VPWR _03311_ sky130_fd_sc_hd__mux4_1
X_09682_ cpuregs\[4\]\[21\] _02670_ _04871_ VGND VGND VPWR VPWR _01339_ sky130_fd_sc_hd__mux2_1
XTAP_TAPCELL_ROW_87_1726 VGND VPWR sky130_fd_sc_hd__tapvpwrvgnd_1
XFILLER_67_663 VGND VGND VPWR VPWR sky130_fd_sc_hd__decap_8
XFILLER_55_825 VGND VGND VPWR VPWR sky130_fd_sc_hd__fill_1
X_05845_ _02089_ _02396_ _02220_ VGND VGND VPWR VPWR _02405_ sky130_fd_sc_hd__a21o_1
X_08633_ _01558_ _04317_ net269 VGND VGND VPWR VPWR _04327_ sky130_fd_sc_hd__o21a_1
X_05776_ _02149_ _02342_ VGND VGND VPWR VPWR _02344_ sky130_fd_sc_hd__or2_1
XFILLER_81_132 VGND VGND VPWR VPWR sky130_fd_sc_hd__decap_3
X_08564_ net123 _01586_ _04260_ _04261_ VGND VGND VPWR VPWR _00810_ sky130_fd_sc_hd__a22o_1
XTAP_TAPCELL_ROW_25_728 VGND VPWR sky130_fd_sc_hd__tapvpwrvgnd_1
XTAP_TAPCELL_ROW_25_739 VGND VPWR sky130_fd_sc_hd__tapvpwrvgnd_1
X_07515_ _03550_ _03569_ VGND VGND VPWR VPWR _03570_ sky130_fd_sc_hd__or2_4
X_08495_ net79 net48 _04208_ VGND VGND VPWR VPWR _00793_ sky130_fd_sc_hd__mux2_1
XFILLER_80_19 VGND VGND VPWR VPWR sky130_fd_sc_hd__decap_8
X_07446_ cpuregs\[27\]\[30\] _02709_ _03566_ VGND VGND VPWR VPWR _00386_ sky130_fd_sc_hd__mux2_1
XFILLER_50_563 VGND VGND VPWR VPWR sky130_fd_sc_hd__decap_8
X_07377_ _02699_ cpuregs\[9\]\[28\] _03563_ VGND VGND VPWR VPWR _00320_ sky130_fd_sc_hd__mux2_1
XTAP_TAPCELL_ROW_118_2225 VGND VPWR sky130_fd_sc_hd__tapvpwrvgnd_1
XTAP_TAPCELL_ROW_118_2214 VGND VPWR sky130_fd_sc_hd__tapvpwrvgnd_1
XFILLER_13_57 VPWR VGND VPWR VGND sky130_ef_sc_hd__decap_12
XFILLER_129_57 VPWR VGND VPWR VGND sky130_ef_sc_hd__decap_12
XFILLER_109_849 VGND VGND VPWR VPWR sky130_fd_sc_hd__fill_2
X_09116_ instr_lb _04747_ _04760_ is_lb_lh_lw_lbu_lhu VGND VGND VPWR VPWR _00854_
+ sky130_fd_sc_hd__a22o_1
X_06328_ cpu_state\[4\] net198 _02721_ VGND VGND VPWR VPWR _02765_ sky130_fd_sc_hd__and3_1
XFILLER_136_657 VGND VGND VPWR VPWR sky130_fd_sc_hd__decap_6
XTAP_TAPCELL_ROW_131_2425 VGND VPWR sky130_fd_sc_hd__tapvpwrvgnd_1
XTAP_TAPCELL_ROW_98_1899 VGND VPWR sky130_fd_sc_hd__tapvpwrvgnd_1
XFILLER_89_39 VPWR VGND VPWR VGND sky130_ef_sc_hd__decap_12
X_09047_ net270 _04717_ VGND VGND VPWR VPWR _04718_ sky130_fd_sc_hd__or2_1
XFILLER_135_167 VGND VGND VPWR VPWR sky130_fd_sc_hd__fill_1
X_06259_ reg_out\[29\] alu_out_q\[29\] net587 VGND VGND VPWR VPWR _02700_ sky130_fd_sc_hd__mux2_1
XFILLER_2_615 VGND VGND VPWR VPWR sky130_fd_sc_hd__fill_1
XFILLER_123_329 VGND VGND VPWR VPWR sky130_fd_sc_hd__decap_6
XFILLER_104_510 VGND VGND VPWR VPWR sky130_fd_sc_hd__decap_3
XFILLER_89_221 VGND VGND VPWR VPWR sky130_fd_sc_hd__decap_3
XFILLER_2_637 VGND VGND VPWR VPWR sky130_fd_sc_hd__decap_6
XFILLER_1_125 VPWR VGND VPWR VGND sky130_ef_sc_hd__decap_12
XFILLER_104_587 VGND VGND VPWR VPWR sky130_fd_sc_hd__fill_1
X_09949_ clknet_leaf_133_clk _00079_ VGND VGND VPWR VPWR net172 sky130_fd_sc_hd__dfxtp_4
XFILLER_1_169 VPWR VGND VPWR VGND sky130_ef_sc_hd__decap_12
Xclkbuf_leaf_69_clk clknet_4_13_0_clk VGND VGND VPWR VPWR clknet_leaf_69_clk sky130_fd_sc_hd__clkbuf_8
XFILLER_93_909 VGND VGND VPWR VPWR sky130_fd_sc_hd__decap_3
XFILLER_77_449 VGND VGND VPWR VPWR sky130_fd_sc_hd__decap_4
XTAP_TAPCELL_ROW_51_1151 VGND VPWR sky130_fd_sc_hd__tapvpwrvgnd_1
XTAP_TAPCELL_ROW_51_1140 VGND VPWR sky130_fd_sc_hd__tapvpwrvgnd_1
XTAP_TAPCELL_ROW_129_2398 VGND VPWR sky130_fd_sc_hd__tapvpwrvgnd_1
XFILLER_73_633 VGND VGND VPWR VPWR sky130_fd_sc_hd__fill_1
XFILLER_18_527 VGND VGND VPWR VPWR sky130_fd_sc_hd__decap_4
XFILLER_46_869 VPWR VGND VPWR VGND sky130_ef_sc_hd__decap_12
XFILLER_72_154 VGND VGND VPWR VPWR sky130_fd_sc_hd__fill_1
XTAP_TAPCELL_ROW_142_2598 VGND VPWR sky130_fd_sc_hd__tapvpwrvgnd_1
XFILLER_72_176 VGND VGND VPWR VPWR sky130_fd_sc_hd__decap_3
XFILLER_60_305 VGND VGND VPWR VPWR sky130_fd_sc_hd__decap_3
XFILLER_14_733 VGND VGND VPWR VPWR sky130_fd_sc_hd__decap_4
XFILLER_60_349 VPWR VGND VPWR VGND sky130_ef_sc_hd__decap_12
XFILLER_41_552 VGND VGND VPWR VPWR sky130_fd_sc_hd__fill_1
X_10724_ clknet_leaf_19_clk _00821_ VGND VGND VPWR VPWR net209 sky130_fd_sc_hd__dfxtp_2
XFILLER_9_225 VPWR VGND VPWR VGND sky130_ef_sc_hd__decap_12
X_10655_ clknet_leaf_96_clk _04882_ VGND VGND VPWR VPWR reg_out\[13\] sky130_fd_sc_hd__dfxtp_1
XFILLER_70_41 VGND VGND VPWR VPWR sky130_fd_sc_hd__fill_2
XFILLER_13_298 VPWR VGND VPWR VGND sky130_ef_sc_hd__decap_12
XFILLER_139_473 VGND VGND VPWR VPWR sky130_fd_sc_hd__decap_8
XFILLER_70_85 VGND VGND VPWR VPWR sky130_fd_sc_hd__decap_6
Xclkload17 clknet_leaf_150_clk VGND VGND VPWR VPWR clkload17/Y sky130_fd_sc_hd__clkinv_8
Xclkload28 clknet_leaf_15_clk VGND VGND VPWR VPWR clkload28/X sky130_fd_sc_hd__clkbuf_4
Xclkload39 clknet_leaf_16_clk VGND VGND VPWR VPWR clkload39/Y sky130_fd_sc_hd__inv_8
X_10586_ clknet_leaf_104_clk _00716_ VGND VGND VPWR VPWR count_cycle\[9\] sky130_fd_sc_hd__dfxtp_1
XTAP_TAPCELL_ROW_149_2708 VGND VPWR sky130_fd_sc_hd__tapvpwrvgnd_1
XFILLER_123_841 VPWR VGND VPWR VGND sky130_ef_sc_hd__decap_12
XFILLER_79_72 VGND VGND VPWR VPWR sky130_fd_sc_hd__decap_8
XTAP_TAPCELL_ROW_149_2719 VGND VPWR sky130_fd_sc_hd__tapvpwrvgnd_1
X_11207_ clknet_leaf_125_clk _01254_ VGND VGND VPWR VPWR cpuregs\[3\]\[0\] sky130_fd_sc_hd__dfxtp_1
X_11138_ clknet_leaf_35_clk _01185_ VGND VGND VPWR VPWR cpuregs\[31\]\[27\] sky130_fd_sc_hd__dfxtp_1
XFILLER_68_416 VGND VGND VPWR VPWR sky130_fd_sc_hd__fill_1
XFILLER_110_579 VGND VGND VPWR VPWR sky130_fd_sc_hd__fill_2
XFILLER_48_162 VGND VGND VPWR VPWR sky130_fd_sc_hd__fill_1
X_11069_ clknet_leaf_118_clk _01126_ VGND VGND VPWR VPWR cpuregs\[24\]\[0\] sky130_fd_sc_hd__dfxtp_1
Xclkbuf_leaf_0_clk clknet_4_0_0_clk VGND VGND VPWR VPWR clknet_leaf_0_clk sky130_fd_sc_hd__clkbuf_8
XFILLER_91_430 VGND VGND VPWR VPWR sky130_fd_sc_hd__decap_3
XTAP_TAPCELL_ROW_69_1434 VGND VPWR sky130_fd_sc_hd__tapvpwrvgnd_1
XFILLER_48_195 VGND VGND VPWR VPWR sky130_fd_sc_hd__fill_1
X_05630_ _02102_ _02106_ _02212_ VGND VGND VPWR VPWR _02213_ sky130_fd_sc_hd__or3b_1
XFILLER_17_571 VGND VGND VPWR VPWR sky130_fd_sc_hd__fill_1
XFILLER_36_379 VGND VGND VPWR VPWR sky130_fd_sc_hd__decap_4
X_07300_ cpuregs\[28\]\[18\] _02657_ net249 VGND VGND VPWR VPWR _00246_ sky130_fd_sc_hd__mux2_1
XTAP_TAPCELL_ROW_82_1645 VGND VPWR sky130_fd_sc_hd__tapvpwrvgnd_1
X_05561_ net176 net208 VGND VGND VPWR VPWR _02144_ sky130_fd_sc_hd__and2_1
XFILLER_51_349 VPWR VGND VPWR VGND sky130_ef_sc_hd__decap_12
X_05492_ _02072_ _02074_ VGND VGND VPWR VPWR _02075_ sky130_fd_sc_hd__or2_1
X_08280_ _04072_ net34 _04071_ VGND VGND VPWR VPWR _00715_ sky130_fd_sc_hd__and3b_1
XFILLER_20_714 VGND VGND VPWR VPWR sky130_fd_sc_hd__fill_1
XFILLER_32_552 VGND VGND VPWR VPWR sky130_fd_sc_hd__decap_4
X_07231_ cpuregs\[13\]\[15\] _02646_ net251 VGND VGND VPWR VPWR _00179_ sky130_fd_sc_hd__mux2_1
X_07162_ cpuregs\[12\]\[16\] _02649_ net253 VGND VGND VPWR VPWR _00116_ sky130_fd_sc_hd__mux2_1
XFILLER_118_635 VGND VGND VPWR VPWR sky130_fd_sc_hd__decap_8
X_06113_ net605 latched_store VGND VGND VPWR VPWR _02583_ sky130_fd_sc_hd__and2b_4
XTAP_TAPCELL_ROW_113_2144 VGND VPWR sky130_fd_sc_hd__tapvpwrvgnd_1
XTAP_TAPCELL_ROW_113_2133 VGND VPWR sky130_fd_sc_hd__tapvpwrvgnd_1
XFILLER_105_307 VPWR VGND VPWR VGND sky130_ef_sc_hd__decap_12
X_07093_ decoded_imm\[29\] net192 VGND VGND VPWR VPWR _03502_ sky130_fd_sc_hd__and2_1
XFILLER_114_830 VGND VGND VPWR VPWR sky130_fd_sc_hd__fill_1
X_06044_ cpuregs\[4\]\[2\] cpuregs\[5\]\[2\] cpuregs\[6\]\[2\] cpuregs\[7\]\[2\] net279
+ _00008_ VGND VGND VPWR VPWR _02517_ sky130_fd_sc_hd__mux4_1
XFILLER_99_541 VGND VGND VPWR VPWR sky130_fd_sc_hd__decap_4
XFILLER_141_671 VGND VGND VPWR VPWR sky130_fd_sc_hd__fill_1
XFILLER_99_574 VPWR VGND VPWR VGND sky130_ef_sc_hd__decap_12
X_09803_ _02624_ cpuregs\[8\]\[10\] _04875_ VGND VGND VPWR VPWR _01456_ sky130_fd_sc_hd__mux2_1
X_07995_ decoded_imm_j\[11\] _03698_ VGND VGND VPWR VPWR _03817_ sky130_fd_sc_hd__and2_1
X_06946_ _01579_ _03360_ VGND VGND VPWR VPWR _03361_ sky130_fd_sc_hd__or2_1
X_09734_ _02612_ cpuregs\[6\]\[7\] _04873_ VGND VGND VPWR VPWR _01389_ sky130_fd_sc_hd__mux2_1
XFILLER_28_825 VPWR VGND VPWR VGND sky130_ef_sc_hd__decap_12
X_06877_ net237 _03279_ _03294_ _03263_ VGND VGND VPWR VPWR _00089_ sky130_fd_sc_hd__a31o_1
X_09665_ cpuregs\[4\]\[4\] _02598_ net238 VGND VGND VPWR VPWR _01322_ sky130_fd_sc_hd__mux2_1
XFILLER_39_162 VGND VGND VPWR VPWR sky130_fd_sc_hd__decap_6
X_05828_ _02091_ _02380_ VGND VGND VPWR VPWR _02390_ sky130_fd_sc_hd__nor2_1
X_08616_ _04300_ _04309_ _04310_ _01560_ _00010_ VGND VGND VPWR VPWR _04311_ sky130_fd_sc_hd__a221o_1
XFILLER_28_869 VPWR VGND VPWR VGND sky130_ef_sc_hd__decap_12
XFILLER_43_806 VPWR VGND VPWR VGND sky130_ef_sc_hd__decap_12
XFILLER_131_69 VGND VGND VPWR VPWR sky130_fd_sc_hd__decap_6
X_09596_ _02590_ cpuregs\[3\]\[2\] _04868_ VGND VGND VPWR VPWR _01256_ sky130_fd_sc_hd__mux2_1
XFILLER_43_839 VGND VGND VPWR VPWR sky130_fd_sc_hd__fill_1
X_05759_ _02152_ _02328_ _02241_ VGND VGND VPWR VPWR _02329_ sky130_fd_sc_hd__o21ai_1
X_08547_ _04246_ _04247_ _01558_ VGND VGND VPWR VPWR _04248_ sky130_fd_sc_hd__mux2_1
XFILLER_35_390 VGND VGND VPWR VPWR sky130_fd_sc_hd__fill_2
X_08478_ net92 net61 _04208_ VGND VGND VPWR VPWR _00776_ sky130_fd_sc_hd__mux2_1
X_07429_ cpuregs\[27\]\[13\] _02638_ _03566_ VGND VGND VPWR VPWR _00369_ sky130_fd_sc_hd__mux2_1
XFILLER_51_894 VGND VGND VPWR VPWR sky130_fd_sc_hd__fill_2
X_10440_ clknet_leaf_47_clk _00570_ VGND VGND VPWR VPWR cpuregs\[17\]\[22\] sky130_fd_sc_hd__dfxtp_1
XFILLER_149_782 VGND VGND VPWR VPWR sky130_fd_sc_hd__fill_2
XFILLER_108_123 VGND VGND VPWR VPWR sky130_fd_sc_hd__fill_1
XFILLER_124_605 VGND VGND VPWR VPWR sky130_fd_sc_hd__decap_4
X_10371_ clknet_leaf_21_clk _00501_ VGND VGND VPWR VPWR cpuregs\[25\]\[17\] sky130_fd_sc_hd__dfxtp_1
XFILLER_124_638 VGND VGND VPWR VPWR sky130_fd_sc_hd__decap_6
XFILLER_2_401 VPWR VGND VPWR VGND sky130_ef_sc_hd__decap_12
XFILLER_105_841 VPWR VGND VPWR VGND sky130_ef_sc_hd__decap_12
XFILLER_6_3 VPWR VGND VPWR VGND sky130_ef_sc_hd__decap_12
XFILLER_49_31 VPWR VGND VPWR VGND sky130_ef_sc_hd__decap_12
XFILLER_2_489 VGND VGND VPWR VPWR sky130_fd_sc_hd__decap_8
XFILLER_49_97 VGND VGND VPWR VPWR sky130_fd_sc_hd__decap_8
XTAP_TAPCELL_ROW_144_2638 VGND VPWR sky130_fd_sc_hd__tapvpwrvgnd_1
XFILLER_93_717 VGND VGND VPWR VPWR sky130_fd_sc_hd__decap_8
XFILLER_1_27 VPWR VGND VPWR VGND sky130_ef_sc_hd__decap_12
XFILLER_18_313 VGND VGND VPWR VPWR sky130_fd_sc_hd__fill_1
XFILLER_45_110 VGND VGND VPWR VPWR sky130_fd_sc_hd__fill_2
XFILLER_73_430 VGND VGND VPWR VPWR sky130_fd_sc_hd__fill_1
XFILLER_61_614 VGND VGND VPWR VPWR sky130_fd_sc_hd__fill_2
XTAP_TAPCELL_ROW_64_1353 VGND VPWR sky130_fd_sc_hd__tapvpwrvgnd_1
XFILLER_81_73 VGND VGND VPWR VPWR sky130_fd_sc_hd__decap_6
XFILLER_41_393 VGND VGND VPWR VPWR sky130_fd_sc_hd__decap_6
X_10707_ clknet_leaf_111_clk _00805_ VGND VGND VPWR VPWR mem_do_wdata sky130_fd_sc_hd__dfxtp_2
XFILLER_128_911 VGND VGND VPWR VPWR sky130_fd_sc_hd__fill_1
XFILLER_139_281 VGND VGND VPWR VPWR sky130_fd_sc_hd__decap_6
Xclkload117 clknet_leaf_66_clk VGND VGND VPWR VPWR clkload117/Y sky130_fd_sc_hd__inv_6
X_10638_ clknet_leaf_78_clk _00768_ VGND VGND VPWR VPWR count_cycle\[61\] sky130_fd_sc_hd__dfxtp_1
Xclkload128 clknet_leaf_84_clk VGND VGND VPWR VPWR clkload128/Y sky130_fd_sc_hd__inv_8
Xclkload106 clknet_leaf_106_clk VGND VGND VPWR VPWR clkload106/Y sky130_fd_sc_hd__clkinv_4
X_10569_ clknet_leaf_64_clk _00699_ VGND VGND VPWR VPWR reg_next_pc\[24\] sky130_fd_sc_hd__dfxtp_1
Xclkload139 clknet_leaf_80_clk VGND VGND VPWR VPWR clkload139/X sky130_fd_sc_hd__clkbuf_8
XFILLER_127_487 VPWR VGND VPWR VGND sky130_ef_sc_hd__decap_12
XFILLER_123_671 VGND VGND VPWR VPWR sky130_fd_sc_hd__fill_1
XFILLER_68_213 VPWR VGND VPWR VGND sky130_ef_sc_hd__decap_12
XFILLER_39_3 VPWR VGND VPWR VGND sky130_ef_sc_hd__decap_12
XFILLER_110_332 VPWR VGND VPWR VGND sky130_ef_sc_hd__decap_12
XFILLER_96_555 VGND VGND VPWR VPWR sky130_fd_sc_hd__decap_3
XFILLER_96_533 VGND VGND VPWR VPWR sky130_fd_sc_hd__fill_1
X_06800_ net179 _02721_ _03137_ _01641_ VGND VGND VPWR VPWR _03220_ sky130_fd_sc_hd__o211a_1
XFILLER_84_728 VGND VGND VPWR VPWR sky130_fd_sc_hd__fill_1
X_07780_ count_instr\[47\] _03658_ net34 VGND VGND VPWR VPWR _03660_ sky130_fd_sc_hd__o21ai_1
XFILLER_68_279 VPWR VGND VPWR VGND sky130_ef_sc_hd__decap_12
X_04992_ instr_sw instr_sh instr_sb _01619_ VGND VGND VPWR VPWR _01620_ sky130_fd_sc_hd__or4b_1
XFILLER_56_419 VGND VGND VPWR VPWR sky130_fd_sc_hd__fill_1
X_06731_ reg_pc\[15\] _02751_ _03153_ _02715_ VGND VGND VPWR VPWR _03154_ sky130_fd_sc_hd__a211o_1
XFILLER_77_791 VGND VGND VPWR VPWR sky130_fd_sc_hd__decap_6
Xinput4 mem_rdata[12] VGND VGND VPWR VPWR net4 sky130_fd_sc_hd__buf_1
XFILLER_37_633 VGND VGND VPWR VPWR sky130_fd_sc_hd__decap_4
X_09450_ _02670_ cpuregs\[19\]\[21\] _04863_ VGND VGND VPWR VPWR _01083_ sky130_fd_sc_hd__mux2_1
X_08401_ count_cycle\[52\] _04148_ net34 VGND VGND VPWR VPWR _04150_ sky130_fd_sc_hd__o21ai_1
X_06662_ _03086_ _03085_ VGND VGND VPWR VPWR _03087_ sky130_fd_sc_hd__and2b_1
XFILLER_52_603 VPWR VGND VPWR VGND sky130_ef_sc_hd__decap_12
XFILLER_25_839 VGND VGND VPWR VPWR sky130_fd_sc_hd__fill_1
XFILLER_36_165 VGND VGND VPWR VPWR sky130_fd_sc_hd__decap_6
X_05613_ net207 net175 VGND VGND VPWR VPWR _02196_ sky130_fd_sc_hd__and2b_1
X_06593_ cpuregs\[8\]\[10\] cpuregs\[9\]\[10\] cpuregs\[10\]\[10\] cpuregs\[11\]\[10\]
+ net263 net259 VGND VGND VPWR VPWR _03021_ sky130_fd_sc_hd__mux4_1
X_09381_ instr_jal decoded_imm_j\[5\] _04823_ mem_rdata_q\[25\] _04747_ VGND VGND
+ VPWR VPWR _04853_ sky130_fd_sc_hd__a221o_1
XFILLER_51_113 VGND VGND VPWR VPWR sky130_fd_sc_hd__decap_6
X_08332_ count_cycle\[26\] net417 _04106_ VGND VGND VPWR VPWR _00733_ sky130_fd_sc_hd__o21a_1
XTAP_TAPCELL_ROW_35_889 VGND VPWR sky130_fd_sc_hd__tapvpwrvgnd_1
X_05544_ _02125_ _02126_ VGND VGND VPWR VPWR _02127_ sky130_fd_sc_hd__and2b_1
XFILLER_20_533 VPWR VGND VPWR VGND sky130_ef_sc_hd__decap_12
X_08263_ count_cycle\[0\] count_cycle\[1\] count_cycle\[2\] VGND VGND VPWR VPWR _04062_
+ sky130_fd_sc_hd__and3_1
X_05475_ net187 net219 VGND VGND VPWR VPWR _02058_ sky130_fd_sc_hd__and2_1
X_07214_ latched_rd\[1\] latched_rd\[0\] _02580_ VGND VGND VPWR VPWR _03557_ sky130_fd_sc_hd__nand3b_4
X_08194_ _03986_ _03989_ _03999_ instr_jal VGND VGND VPWR VPWR _04001_ sky130_fd_sc_hd__o31a_1
XFILLER_118_421 VPWR VGND VPWR VGND sky130_ef_sc_hd__decap_12
XFILLER_20_577 VGND VGND VPWR VPWR sky130_fd_sc_hd__fill_2
XTAP_TAPCELL_ROW_95_1847 VGND VPWR sky130_fd_sc_hd__tapvpwrvgnd_1
X_07145_ _03550_ _03551_ VGND VGND VPWR VPWR _03552_ sky130_fd_sc_hd__nor2_4
X_07076_ cpuregs\[20\]\[28\] cpuregs\[21\]\[28\] cpuregs\[22\]\[28\] cpuregs\[23\]\[28\]
+ net266 net261 VGND VGND VPWR VPWR _03486_ sky130_fd_sc_hd__mux4_1
XTAP_TAPCELL_ROW_95_1858 VGND VPWR sky130_fd_sc_hd__tapvpwrvgnd_1
X_06027_ mem_rdata_q\[23\] net16 _01609_ VGND VGND VPWR VPWR _01117_ sky130_fd_sc_hd__mux2_1
XFILLER_86_29 VPWR VGND VPWR VGND sky130_ef_sc_hd__decap_12
XFILLER_120_129 VGND VGND VPWR VPWR sky130_fd_sc_hd__fill_2
XFILLER_114_693 VGND VGND VPWR VPWR sky130_fd_sc_hd__decap_6
XFILLER_102_888 VGND VGND VPWR VPWR sky130_fd_sc_hd__decap_4
X_07978_ _03798_ _03800_ _01551_ VGND VGND VPWR VPWR _03802_ sky130_fd_sc_hd__a21o_1
X_09717_ _02678_ cpuregs\[5\]\[23\] _04872_ VGND VGND VPWR VPWR _01373_ sky130_fd_sc_hd__mux2_1
XTAP_TAPCELL_ROW_126_2346 VGND VPWR sky130_fd_sc_hd__tapvpwrvgnd_1
X_06929_ net185 _03344_ net237 VGND VGND VPWR VPWR _00091_ sky130_fd_sc_hd__mux2_1
XFILLER_101_376 VGND VGND VPWR VPWR sky130_fd_sc_hd__decap_8
XFILLER_27_110 VGND VGND VPWR VPWR sky130_fd_sc_hd__fill_2
X_09648_ _02670_ cpuregs\[22\]\[21\] _04869_ VGND VGND VPWR VPWR _01307_ sky130_fd_sc_hd__mux2_1
XFILLER_83_783 VGND VGND VPWR VPWR sky130_fd_sc_hd__fill_1
XFILLER_27_165 VGND VGND VPWR VPWR sky130_fd_sc_hd__decap_3
XFILLER_43_625 VGND VGND VPWR VPWR sky130_fd_sc_hd__fill_2
X_09579_ cpuregs\[29\]\[18\] _02657_ _04867_ VGND VGND VPWR VPWR _01240_ sky130_fd_sc_hd__mux2_1
XFILLER_31_809 VPWR VGND VPWR VGND sky130_ef_sc_hd__decap_12
XFILLER_35_55 VGND VGND VPWR VPWR sky130_fd_sc_hd__fill_1
XFILLER_70_477 VPWR VGND VPWR VGND sky130_ef_sc_hd__decap_12
X_11610_ net124 VGND VGND VPWR VPWR net230 sky130_fd_sc_hd__clkbuf_1
XFILLER_24_861 VGND VGND VPWR VPWR sky130_fd_sc_hd__decap_6
XTAP_TAPCELL_ROW_46_1061 VGND VPWR sky130_fd_sc_hd__tapvpwrvgnd_1
XFILLER_143_3 VPWR VGND VPWR VGND sky130_ef_sc_hd__decap_12
XTAP_TAPCELL_ROW_104_1998 VGND VPWR sky130_fd_sc_hd__tapvpwrvgnd_1
XFILLER_51_680 VGND VGND VPWR VPWR sky130_fd_sc_hd__decap_3
XTAP_TAPCELL_ROW_13_539 VGND VPWR sky130_fd_sc_hd__tapvpwrvgnd_1
XFILLER_23_393 VGND VGND VPWR VPWR sky130_fd_sc_hd__decap_4
XTAP_TAPCELL_ROW_46_1072 VGND VPWR sky130_fd_sc_hd__tapvpwrvgnd_1
XFILLER_51_43 VPWR VGND VPWR VGND sky130_ef_sc_hd__decap_12
XFILLER_11_599 VPWR VGND VPWR VGND sky130_ef_sc_hd__decap_12
XFILLER_11_577 VGND VGND VPWR VPWR sky130_fd_sc_hd__fill_1
X_11472_ clknet_leaf_3_clk _01516_ VGND VGND VPWR VPWR cpuregs\[10\]\[6\] sky130_fd_sc_hd__dfxtp_1
XFILLER_7_559 VGND VGND VPWR VPWR sky130_fd_sc_hd__fill_1
X_10423_ clknet_leaf_142_clk _00553_ VGND VGND VPWR VPWR cpuregs\[17\]\[5\] sky130_fd_sc_hd__dfxtp_1
XFILLER_137_785 VPWR VGND VPWR VGND sky130_ef_sc_hd__decap_12
XFILLER_3_721 VGND VGND VPWR VPWR sky130_fd_sc_hd__decap_6
X_10354_ clknet_leaf_118_clk _00484_ VGND VGND VPWR VPWR cpuregs\[25\]\[0\] sky130_fd_sc_hd__dfxtp_1
XFILLER_124_435 VGND VGND VPWR VPWR sky130_fd_sc_hd__fill_1
X_10285_ clknet_leaf_35_clk _00415_ VGND VGND VPWR VPWR cpuregs\[15\]\[27\] sky130_fd_sc_hd__dfxtp_1
XFILLER_112_619 VGND VGND VPWR VPWR sky130_fd_sc_hd__decap_4
XFILLER_3_765 VPWR VGND VPWR VGND sky130_ef_sc_hd__decap_12
XFILLER_2_253 VPWR VGND VPWR VGND sky130_ef_sc_hd__decap_12
XFILLER_78_533 VGND VGND VPWR VPWR sky130_fd_sc_hd__decap_4
XFILLER_38_419 VGND VGND VPWR VPWR sky130_fd_sc_hd__fill_1
XFILLER_120_696 VGND VGND VPWR VPWR sky130_fd_sc_hd__decap_4
XFILLER_76_62 VGND VGND VPWR VPWR sky130_fd_sc_hd__fill_1
XFILLER_92_61 VGND VGND VPWR VPWR sky130_fd_sc_hd__decap_3
XFILLER_33_113 VGND VGND VPWR VPWR sky130_fd_sc_hd__decap_4
XPHY_EDGE_ROW_1_Left_155 VGND VGND VPWR VPWR sky130_fd_sc_hd__decap_3
XTAP_TAPCELL_ROW_32_837 VGND VPWR sky130_fd_sc_hd__tapvpwrvgnd_1
XTAP_TAPCELL_ROW_32_848 VGND VPWR sky130_fd_sc_hd__tapvpwrvgnd_1
X_05260_ latched_is_lh _01859_ _01857_ _01771_ VGND VGND VPWR VPWR _01860_ sky130_fd_sc_hd__a211o_4
XFILLER_143_700 VGND VGND VPWR VPWR sky130_fd_sc_hd__decap_3
X_05191_ count_instr\[42\] instr_rdinstrh net257 _01795_ VGND VGND VPWR VPWR _01796_
+ sky130_fd_sc_hd__a211o_1
XTAP_TAPCELL_ROW_77_1566 VGND VPWR sky130_fd_sc_hd__tapvpwrvgnd_1
XFILLER_142_221 VPWR VGND VPWR VGND sky130_ef_sc_hd__decap_12
X_08950_ _04625_ _04626_ _04266_ _04623_ VGND VGND VPWR VPWR _04627_ sky130_fd_sc_hd__o211a_1
XFILLER_69_500 VGND VGND VPWR VPWR sky130_fd_sc_hd__decap_4
X_08881_ cpuregs\[8\]\[22\] cpuregs\[9\]\[22\] cpuregs\[10\]\[22\] cpuregs\[11\]\[22\]
+ net276 net272 VGND VGND VPWR VPWR _04561_ sky130_fd_sc_hd__mux4_1
XPHY_EDGE_ROW_135_Right_135 VGND VGND VPWR VPWR sky130_fd_sc_hd__decap_3
XFILLER_97_853 VGND VGND VPWR VPWR sky130_fd_sc_hd__decap_4
XFILLER_97_831 VGND VGND VPWR VPWR sky130_fd_sc_hd__fill_2
XTAP_TAPCELL_ROW_90_1777 VGND VPWR sky130_fd_sc_hd__tapvpwrvgnd_1
XTAP_TAPCELL_ROW_90_1766 VGND VPWR sky130_fd_sc_hd__tapvpwrvgnd_1
X_07901_ _01628_ _03730_ _03731_ _01624_ reg_next_pc\[2\] VGND VGND VPWR VPWR _00677_
+ sky130_fd_sc_hd__a32o_1
XFILLER_97_897 VGND VGND VPWR VPWR sky130_fd_sc_hd__fill_1
XFILLER_97_864 VPWR VGND VPWR VGND sky130_ef_sc_hd__decap_12
XFILLER_96_363 VGND VGND VPWR VPWR sky130_fd_sc_hd__fill_1
XFILLER_84_503 VPWR VGND VPWR VGND sky130_ef_sc_hd__decap_12
X_07832_ reg_pc\[4\] _01624_ _01628_ _03691_ VGND VGND VPWR VPWR _00648_ sky130_fd_sc_hd__a22o_1
XFILLER_111_685 VPWR VGND VPWR VGND sky130_ef_sc_hd__decap_12
XFILLER_96_396 VGND VGND VPWR VPWR sky130_fd_sc_hd__fill_2
XFILLER_110_195 VGND VGND VPWR VPWR sky130_fd_sc_hd__fill_1
XTAP_TAPCELL_ROW_108_2065 VGND VPWR sky130_fd_sc_hd__tapvpwrvgnd_1
XTAP_TAPCELL_ROW_108_2054 VGND VPWR sky130_fd_sc_hd__tapvpwrvgnd_1
X_07763_ _03644_ count_instr\[40\] count_instr\[39\] count_instr\[41\] VGND VGND VPWR
+ VPWR _03649_ sky130_fd_sc_hd__and4_1
X_09502_ cpuregs\[31\]\[7\] _02612_ net240 VGND VGND VPWR VPWR _01165_ sky130_fd_sc_hd__mux2_1
X_04975_ mem_do_wdata mem_do_rdata net606 net171 VGND VGND VPWR VPWR _01605_ sky130_fd_sc_hd__o22a_1
XFILLER_112_49 VGND VGND VPWR VPWR sky130_fd_sc_hd__fill_2
XFILLER_112_27 VGND VGND VPWR VPWR sky130_fd_sc_hd__fill_1
X_06714_ _01564_ _02721_ VGND VGND VPWR VPWR _03137_ sky130_fd_sc_hd__nand2_1
X_07694_ _03600_ count_instr\[15\] count_instr\[14\] count_instr\[16\] VGND VGND VPWR
+ VPWR _03605_ sky130_fd_sc_hd__and4_1
X_06645_ cpuregs\[16\]\[12\] cpuregs\[17\]\[12\] cpuregs\[18\]\[12\] cpuregs\[19\]\[12\]
+ net263 net259 VGND VGND VPWR VPWR _03071_ sky130_fd_sc_hd__mux4_1
XFILLER_52_444 VGND VGND VPWR VPWR sky130_fd_sc_hd__decap_4
XFILLER_52_433 VGND VGND VPWR VPWR sky130_fd_sc_hd__decap_4
X_09433_ _02598_ cpuregs\[19\]\[4\] _04863_ VGND VGND VPWR VPWR _01066_ sky130_fd_sc_hd__mux2_1
XTAP_TAPCELL_ROW_121_2265 VGND VPWR sky130_fd_sc_hd__tapvpwrvgnd_1
X_09364_ instr_jal decoded_imm_j\[13\] _01589_ mem_rdata_q\[13\] VGND VGND VPWR VPWR
+ _04844_ sky130_fd_sc_hd__a22o_1
XFILLER_52_477 VGND VGND VPWR VPWR sky130_fd_sc_hd__decap_4
XFILLER_13_809 VPWR VGND VPWR VGND sky130_ef_sc_hd__decap_12
X_08315_ _04094_ _04095_ VGND VGND VPWR VPWR _00727_ sky130_fd_sc_hd__nor2_1
X_06576_ decoded_imm\[10\] net172 VGND VGND VPWR VPWR _03004_ sky130_fd_sc_hd__or2_1
XFILLER_40_639 VGND VGND VPWR VPWR sky130_fd_sc_hd__decap_4
XANTENNA_31 net222 VGND VGND VPWR VPWR sky130_fd_sc_hd__diode_2
X_09295_ net152 net114 _04206_ VGND VGND VPWR VPWR _00981_ sky130_fd_sc_hd__mux2_1
X_05527_ _02107_ _02109_ VGND VGND VPWR VPWR _02110_ sky130_fd_sc_hd__nor2_2
XANTENNA_20 net124 VGND VGND VPWR VPWR sky130_fd_sc_hd__diode_2
XFILLER_21_853 VPWR VGND VPWR VGND sky130_ef_sc_hd__decap_12
XFILLER_119_741 VPWR VGND VPWR VGND sky130_ef_sc_hd__decap_12
XANTENNA_42 net213 VGND VGND VPWR VPWR sky130_fd_sc_hd__diode_2
X_05458_ count_instr\[31\] instr_rdinstr count_cycle\[63\] instr_rdcycleh VGND VGND
+ VPWR VPWR _02042_ sky130_fd_sc_hd__a22o_1
X_08246_ _04041_ _04042_ _04048_ _01551_ VGND VGND VPWR VPWR _04049_ sky130_fd_sc_hd__o22a_1
XFILLER_21_897 VGND VGND VPWR VPWR sky130_fd_sc_hd__decap_3
X_08177_ _03974_ _03983_ _03984_ _03967_ VGND VGND VPWR VPWR _03985_ sky130_fd_sc_hd__a211o_1
XFILLER_118_251 VGND VGND VPWR VPWR sky130_fd_sc_hd__fill_1
XFILLER_118_240 VGND VGND VPWR VPWR sky130_fd_sc_hd__fill_2
XFILLER_146_593 VGND VGND VPWR VPWR sky130_fd_sc_hd__fill_1
XFILLER_134_722 VGND VGND VPWR VPWR sky130_fd_sc_hd__decap_4
XFILLER_119_785 VPWR VGND VPWR VGND sky130_ef_sc_hd__decap_12
XFILLER_118_262 VGND VGND VPWR VPWR sky130_fd_sc_hd__decap_6
X_05389_ cpu_state\[6\] _01860_ _01974_ _01978_ VGND VGND VPWR VPWR _01979_ sky130_fd_sc_hd__a31o_1
X_07128_ _01579_ _03535_ VGND VGND VPWR VPWR _03536_ sky130_fd_sc_hd__or2_1
XFILLER_21_57 VPWR VGND VPWR VGND sky130_ef_sc_hd__decap_12
XFILLER_137_57 VPWR VGND VPWR VGND sky130_ef_sc_hd__decap_12
X_07059_ _03464_ _03465_ _00014_ VGND VGND VPWR VPWR _03470_ sky130_fd_sc_hd__mux2_1
XFILLER_121_405 VGND VGND VPWR VPWR sky130_fd_sc_hd__decap_4
XFILLER_0_713 VGND VGND VPWR VPWR sky130_fd_sc_hd__decap_4
Xoutput160 net160 VGND VGND VPWR VPWR mem_wdata[3] sky130_fd_sc_hd__buf_2
XFILLER_121_449 VPWR VGND VPWR VGND sky130_ef_sc_hd__decap_12
XFILLER_88_853 VGND VGND VPWR VPWR sky130_fd_sc_hd__decap_4
Xoutput193 net193 VGND VGND VPWR VPWR pcpi_rs1[2] sky130_fd_sc_hd__buf_2
Xoutput182 net613 VGND VGND VPWR VPWR pcpi_rs1[1] sky130_fd_sc_hd__buf_2
X_10070_ clknet_leaf_137_clk _00200_ VGND VGND VPWR VPWR cpuregs\[2\]\[4\] sky130_fd_sc_hd__dfxtp_1
Xoutput171 net171 VGND VGND VPWR VPWR pcpi_rs1[0] sky130_fd_sc_hd__buf_2
XPHY_EDGE_ROW_102_Right_102 VGND VGND VPWR VPWR sky130_fd_sc_hd__decap_3
XFILLER_0_757 VGND VGND VPWR VPWR sky130_fd_sc_hd__fill_2
XFILLER_87_385 VGND VGND VPWR VPWR sky130_fd_sc_hd__decap_6
XFILLER_90_506 VGND VGND VPWR VPWR sky130_fd_sc_hd__decap_6
XFILLER_75_547 VPWR VGND VPWR VGND sky130_ef_sc_hd__decap_12
XFILLER_28_430 VPWR VGND VPWR VGND sky130_ef_sc_hd__decap_12
XTAP_TAPCELL_ROW_48_1101 VGND VPWR sky130_fd_sc_hd__tapvpwrvgnd_1
X_10972_ clknet_leaf_138_clk _01034_ VGND VGND VPWR VPWR cpuregs\[18\]\[4\] sky130_fd_sc_hd__dfxtp_1
XFILLER_46_65 VPWR VGND VPWR VGND sky130_ef_sc_hd__decap_12
XFILLER_71_742 VGND VGND VPWR VPWR sky130_fd_sc_hd__decap_3
XFILLER_55_293 VGND VGND VPWR VPWR sky130_fd_sc_hd__fill_2
XFILLER_15_113 VGND VGND VPWR VPWR sky130_fd_sc_hd__decap_3
XFILLER_16_636 VGND VGND VPWR VPWR sky130_fd_sc_hd__decap_8
XFILLER_62_53 VPWR VGND VPWR VGND sky130_ef_sc_hd__decap_12
XTAP_TAPCELL_ROW_61_1312 VGND VPWR sky130_fd_sc_hd__tapvpwrvgnd_1
XTAP_TAPCELL_ROW_61_1301 VGND VPWR sky130_fd_sc_hd__tapvpwrvgnd_1
XFILLER_30_116 VGND VGND VPWR VPWR sky130_fd_sc_hd__decap_4
XTAP_TAPCELL_ROW_139_2559 VGND VPWR sky130_fd_sc_hd__tapvpwrvgnd_1
XTAP_TAPCELL_ROW_139_2548 VGND VPWR sky130_fd_sc_hd__tapvpwrvgnd_1
XFILLER_129_505 VGND VGND VPWR VPWR sky130_fd_sc_hd__decap_8
XFILLER_8_813 VPWR VGND VPWR VGND sky130_ef_sc_hd__decap_12
XFILLER_30_138 VGND VGND VPWR VPWR sky130_fd_sc_hd__fill_2
XFILLER_7_323 VPWR VGND VPWR VGND sky130_ef_sc_hd__decap_12
XFILLER_7_15 VPWR VGND VPWR VGND sky130_ef_sc_hd__decap_12
X_11455_ clknet_leaf_77_clk _01499_ VGND VGND VPWR VPWR cpuregs\[0\]\[21\] sky130_fd_sc_hd__dfxtp_1
XTAP_TAPCELL_ROW_152_2759 VGND VPWR sky130_fd_sc_hd__tapvpwrvgnd_1
X_10406_ clknet_leaf_77_clk _00536_ VGND VGND VPWR VPWR cpuregs\[20\]\[20\] sky130_fd_sc_hd__dfxtp_1
XFILLER_7_389 VGND VGND VPWR VPWR sky130_fd_sc_hd__decap_3
XFILLER_98_606 VGND VGND VPWR VPWR sky130_fd_sc_hd__fill_1
X_11386_ clknet_leaf_22_clk _01430_ VGND VGND VPWR VPWR cpuregs\[7\]\[16\] sky130_fd_sc_hd__dfxtp_1
XTAP_TAPCELL_ROW_59_1274 VGND VPWR sky130_fd_sc_hd__tapvpwrvgnd_1
XFILLER_140_725 VPWR VGND VPWR VGND sky130_ef_sc_hd__decap_12
XFILLER_124_265 VGND VGND VPWR VPWR sky130_fd_sc_hd__fill_1
X_10337_ clknet_leaf_20_clk _00467_ VGND VGND VPWR VPWR cpuregs\[16\]\[15\] sky130_fd_sc_hd__dfxtp_1
XFILLER_3_573 VPWR VGND VPWR VGND sky130_ef_sc_hd__decap_12
XFILLER_124_287 VPWR VGND VPWR VGND sky130_ef_sc_hd__decap_12
XFILLER_105_490 VGND VGND VPWR VPWR sky130_fd_sc_hd__fill_1
XFILLER_79_853 VGND VGND VPWR VPWR sky130_fd_sc_hd__decap_4
X_10268_ clknet_leaf_13_clk _00398_ VGND VGND VPWR VPWR cpuregs\[15\]\[10\] sky130_fd_sc_hd__dfxtp_1
XFILLER_79_864 VPWR VGND VPWR VGND sky130_ef_sc_hd__decap_12
XTAP_TAPCELL_ROW_72_1485 VGND VPWR sky130_fd_sc_hd__tapvpwrvgnd_1
XFILLER_39_706 VPWR VGND VPWR VGND sky130_ef_sc_hd__decap_12
XFILLER_79_897 VGND VGND VPWR VPWR sky130_fd_sc_hd__decap_8
X_10199_ clknet_leaf_137_clk _00329_ VGND VGND VPWR VPWR cpuregs\[14\]\[5\] sky130_fd_sc_hd__dfxtp_1
XFILLER_19_430 VGND VGND VPWR VPWR sky130_fd_sc_hd__fill_1
XTAP_TAPCELL_ROW_37_918 VGND VPWR sky130_fd_sc_hd__tapvpwrvgnd_1
XTAP_TAPCELL_ROW_37_929 VGND VPWR sky130_fd_sc_hd__tapvpwrvgnd_1
XFILLER_47_772 VPWR VGND VPWR VGND sky130_ef_sc_hd__decap_12
XFILLER_62_720 VGND VGND VPWR VPWR sky130_fd_sc_hd__decap_8
XFILLER_46_282 VPWR VGND VPWR VGND sky130_ef_sc_hd__decap_12
XFILLER_34_477 VGND VGND VPWR VPWR sky130_fd_sc_hd__fill_1
X_06430_ _02806_ _02808_ _02863_ VGND VGND VPWR VPWR _02864_ sky130_fd_sc_hd__or3_1
XFILLER_62_797 VGND VGND VPWR VPWR sky130_fd_sc_hd__decap_8
XFILLER_22_639 VGND VGND VPWR VPWR sky130_fd_sc_hd__decap_4
XFILLER_148_825 VPWR VGND VPWR VGND sky130_ef_sc_hd__decap_12
XFILLER_21_149 VGND VGND VPWR VPWR sky130_fd_sc_hd__decap_6
X_06361_ _02793_ _02794_ _02795_ VGND VGND VPWR VPWR _02797_ sky130_fd_sc_hd__nand3_2
XFILLER_148_869 VPWR VGND VPWR VGND sky130_ef_sc_hd__decap_12
X_05312_ reg_pc\[20\] decoded_imm\[20\] VGND VGND VPWR VPWR _01907_ sky130_fd_sc_hd__or2_1
X_08100_ _01547_ reg_next_pc\[18\] _01645_ _03705_ VGND VGND VPWR VPWR _03915_ sky130_fd_sc_hd__a22o_1
X_09080_ net33 net134 net28 VGND VGND VPWR VPWR _04740_ sky130_fd_sc_hd__and3_1
X_06292_ cpuregs\[12\]\[0\] cpuregs\[13\]\[0\] cpuregs\[14\]\[0\] cpuregs\[15\]\[0\]
+ net264 net262 VGND VGND VPWR VPWR _02730_ sky130_fd_sc_hd__mux4_1
XFILLER_147_368 VGND VGND VPWR VPWR sky130_fd_sc_hd__decap_3
X_08031_ _03850_ VGND VGND VPWR VPWR _03851_ sky130_fd_sc_hd__inv_2
X_05243_ _01840_ _01841_ _01842_ VGND VGND VPWR VPWR _01844_ sky130_fd_sc_hd__and3_1
XFILLER_128_560 VGND VGND VPWR VPWR sky130_fd_sc_hd__decap_6
XFILLER_116_755 VGND VGND VPWR VPWR sky130_fd_sc_hd__fill_1
XTAP_TAPCELL_ROW_92_1806 VGND VPWR sky130_fd_sc_hd__tapvpwrvgnd_1
X_05174_ reg_pc\[9\] decoded_imm\[9\] VGND VGND VPWR VPWR _01780_ sky130_fd_sc_hd__or2_1
XPHY_EDGE_ROW_55_Left_209 VGND VGND VPWR VPWR sky130_fd_sc_hd__decap_3
XFILLER_89_617 VGND VGND VPWR VPWR sky130_fd_sc_hd__decap_3
X_09982_ clknet_leaf_11_clk _00112_ VGND VGND VPWR VPWR cpuregs\[12\]\[12\] sky130_fd_sc_hd__dfxtp_1
X_08933_ net219 _01585_ _04609_ _04610_ VGND VGND VPWR VPWR _00830_ sky130_fd_sc_hd__o22a_1
XFILLER_115_287 VGND VGND VPWR VPWR sky130_fd_sc_hd__fill_1
XFILLER_103_449 VPWR VGND VPWR VGND sky130_ef_sc_hd__decap_12
XFILLER_123_15 VPWR VGND VPWR VGND sky130_ef_sc_hd__decap_12
X_08864_ cpuregs\[28\]\[21\] cpuregs\[29\]\[21\] cpuregs\[30\]\[21\] cpuregs\[31\]\[21\]
+ _00007_ net274 VGND VGND VPWR VPWR _04545_ sky130_fd_sc_hd__mux4_1
XTAP_TAPCELL_ROW_123_2305 VGND VPWR sky130_fd_sc_hd__tapvpwrvgnd_1
X_07815_ count_instr\[60\] _03679_ _03681_ VGND VGND VPWR VPWR _00641_ sky130_fd_sc_hd__o21a_1
X_08795_ net270 _04479_ VGND VGND VPWR VPWR _04480_ sky130_fd_sc_hd__or2_1
XFILLER_57_547 VGND VGND VPWR VPWR sky130_fd_sc_hd__fill_2
XFILLER_38_750 VGND VGND VPWR VPWR sky130_fd_sc_hd__decap_6
X_04958_ instr_sltu instr_sltiu instr_bltu VGND VGND VPWR VPWR _00003_ sky130_fd_sc_hd__or3_1
XFILLER_72_506 VGND VGND VPWR VPWR sky130_fd_sc_hd__fill_2
X_07746_ _03638_ net34 _03637_ VGND VGND VPWR VPWR _00615_ sky130_fd_sc_hd__and3b_1
XPHY_EDGE_ROW_64_Left_218 VGND VGND VPWR VPWR sky130_fd_sc_hd__decap_3
XFILLER_25_411 VGND VGND VPWR VPWR sky130_fd_sc_hd__fill_1
X_09416_ _02665_ cpuregs\[18\]\[20\] _04862_ VGND VGND VPWR VPWR _01050_ sky130_fd_sc_hd__mux2_1
X_07677_ _03594_ net34 _03593_ VGND VGND VPWR VPWR _00590_ sky130_fd_sc_hd__and3b_1
X_06628_ reg_pc\[11\] _02751_ _03054_ _02715_ VGND VGND VPWR VPWR _03055_ sky130_fd_sc_hd__a211o_1
XTAP_TAPCELL_ROW_101_1946 VGND VPWR sky130_fd_sc_hd__tapvpwrvgnd_1
X_09347_ decoded_imm\[22\] _04746_ _04825_ _04835_ VGND VGND VPWR VPWR _01008_ sky130_fd_sc_hd__o22a_1
XFILLER_8_109 VPWR VGND VPWR VGND sky130_ef_sc_hd__decap_12
X_06559_ cpuregs\[24\]\[9\] cpuregs\[25\]\[9\] cpuregs\[26\]\[9\] cpuregs\[27\]\[9\]
+ net263 net259 VGND VGND VPWR VPWR _02988_ sky130_fd_sc_hd__mux4_1
XTAP_TAPCELL_ROW_43_1020 VGND VPWR sky130_fd_sc_hd__tapvpwrvgnd_1
X_09278_ net165 net127 _04206_ VGND VGND VPWR VPWR _00964_ sky130_fd_sc_hd__mux2_1
X_08229_ decoded_imm_j\[20\] _03717_ VGND VGND VPWR VPWR _04033_ sky130_fd_sc_hd__and2_1
XFILLER_153_305 VGND VGND VPWR VPWR sky130_fd_sc_hd__decap_3
XPHY_EDGE_ROW_73_Left_227 VGND VGND VPWR VPWR sky130_fd_sc_hd__decap_3
XTAP_TAPCELL_ROW_134_2478 VGND VPWR sky130_fd_sc_hd__tapvpwrvgnd_1
XFILLER_107_755 VPWR VGND VPWR VGND sky130_ef_sc_hd__decap_12
XFILLER_106_3 VGND VGND VPWR VPWR sky130_fd_sc_hd__decap_3
X_11240_ clknet_leaf_116_clk _01287_ VGND VGND VPWR VPWR cpuregs\[22\]\[1\] sky130_fd_sc_hd__dfxtp_1
X_11171_ clknet_leaf_39_clk _01218_ VGND VGND VPWR VPWR cpuregs\[23\]\[28\] sky130_fd_sc_hd__dfxtp_1
XFILLER_134_552 VGND VGND VPWR VPWR sky130_fd_sc_hd__fill_2
X_10122_ clknet_leaf_64_clk _00252_ VGND VGND VPWR VPWR cpuregs\[28\]\[24\] sky130_fd_sc_hd__dfxtp_1
X_10053_ clknet_leaf_70_clk _00183_ VGND VGND VPWR VPWR cpuregs\[13\]\[19\] sky130_fd_sc_hd__dfxtp_1
XFILLER_102_460 VPWR VGND VPWR VGND sky130_ef_sc_hd__decap_12
XFILLER_57_31 VPWR VGND VPWR VGND sky130_ef_sc_hd__decap_12
XTAP_TAPCELL_ROW_54_1193 VGND VPWR sky130_fd_sc_hd__tapvpwrvgnd_1
XFILLER_48_547 VGND VGND VPWR VPWR sky130_fd_sc_hd__decap_8
XPHY_EDGE_ROW_82_Left_236 VGND VGND VPWR VPWR sky130_fd_sc_hd__decap_3
XFILLER_76_889 VGND VGND VPWR VPWR sky130_fd_sc_hd__decap_6
XTAP_TAPCELL_ROW_3_381 VGND VPWR sky130_fd_sc_hd__tapvpwrvgnd_1
XFILLER_29_783 VGND VGND VPWR VPWR sky130_fd_sc_hd__fill_1
X_10955_ clknet_leaf_93_clk _01017_ VGND VGND VPWR VPWR decoded_imm\[13\] sky130_fd_sc_hd__dfxtp_2
XFILLER_44_764 VPWR VGND VPWR VGND sky130_ef_sc_hd__decap_12
X_10886_ clknet_leaf_30_clk _00948_ VGND VGND VPWR VPWR cpuregs\[1\]\[30\] sky130_fd_sc_hd__dfxtp_1
XFILLER_16_477 VGND VGND VPWR VPWR sky130_fd_sc_hd__decap_3
XFILLER_129_302 VGND VGND VPWR VPWR sky130_fd_sc_hd__decap_8
XTAP_TAPCELL_ROW_42_998 VGND VPWR sky130_fd_sc_hd__tapvpwrvgnd_1
XPHY_EDGE_ROW_91_Left_245 VGND VGND VPWR VPWR sky130_fd_sc_hd__decap_3
XFILLER_145_839 VGND VGND VPWR VPWR sky130_fd_sc_hd__fill_1
XTAP_TAPCELL_ROW_74_1514 VGND VPWR sky130_fd_sc_hd__tapvpwrvgnd_1
X_11438_ clknet_leaf_137_clk _01482_ VGND VGND VPWR VPWR cpuregs\[0\]\[4\] sky130_fd_sc_hd__dfxtp_1
XFILLER_125_552 VGND VGND VPWR VPWR sky130_fd_sc_hd__decap_8
X_11369_ clknet_leaf_135_clk _01413_ VGND VGND VPWR VPWR cpuregs\[6\]\[31\] sky130_fd_sc_hd__dfxtp_1
XFILLER_4_893 VPWR VGND VPWR VGND sky130_ef_sc_hd__decap_12
XFILLER_140_566 VPWR VGND VPWR VGND sky130_ef_sc_hd__decap_12
XFILLER_112_246 VGND VGND VPWR VPWR sky130_fd_sc_hd__decap_6
XFILLER_101_909 VGND VGND VPWR VPWR sky130_fd_sc_hd__decap_3
XFILLER_98_469 VGND VGND VPWR VPWR sky130_fd_sc_hd__decap_6
XFILLER_100_419 VGND VGND VPWR VPWR sky130_fd_sc_hd__fill_1
X_05930_ mem_wordsize\[1\] net119 net204 mem_wordsize\[2\] VGND VGND VPWR VPWR _02476_
+ sky130_fd_sc_hd__a22o_1
XFILLER_21_3 VPWR VGND VPWR VGND sky130_ef_sc_hd__decap_12
X_05861_ _02419_ _02414_ instr_sub VGND VGND VPWR VPWR _02420_ sky130_fd_sc_hd__mux2_1
XFILLER_39_558 VGND VGND VPWR VPWR sky130_fd_sc_hd__fill_2
XTAP_TAPCELL_ROW_105_2013 VGND VPWR sky130_fd_sc_hd__tapvpwrvgnd_1
X_07600_ cpuregs\[20\]\[17\] _02654_ net245 VGND VGND VPWR VPWR _00533_ sky130_fd_sc_hd__mux2_1
XFILLER_54_506 VGND VGND VPWR VPWR sky130_fd_sc_hd__decap_8
X_08580_ _01558_ _04269_ _04268_ _01560_ VGND VGND VPWR VPWR _04277_ sky130_fd_sc_hd__o211a_1
X_05792_ _02355_ _02357_ _02110_ VGND VGND VPWR VPWR _02358_ sky130_fd_sc_hd__o21ai_1
X_07531_ _02646_ cpuregs\[16\]\[15\] _03570_ VGND VGND VPWR VPWR _00467_ sky130_fd_sc_hd__mux2_1
XFILLER_62_550 VGND VGND VPWR VPWR sky130_fd_sc_hd__fill_2
XFILLER_50_701 VGND VGND VPWR VPWR sky130_fd_sc_hd__decap_3
XTAP_TAPCELL_ROW_85_1698 VGND VPWR sky130_fd_sc_hd__tapvpwrvgnd_1
XTAP_TAPCELL_ROW_85_1687 VGND VPWR sky130_fd_sc_hd__tapvpwrvgnd_1
X_07462_ cpuregs\[15\]\[13\] _02638_ net246 VGND VGND VPWR VPWR _00401_ sky130_fd_sc_hd__mux2_1
XFILLER_50_723 VGND VGND VPWR VPWR sky130_fd_sc_hd__decap_8
XFILLER_35_797 VPWR VGND VPWR VGND sky130_ef_sc_hd__decap_12
XFILLER_50_767 VGND VGND VPWR VPWR sky130_fd_sc_hd__decap_8
X_07393_ cpuregs\[14\]\[11\] _02630_ net247 VGND VGND VPWR VPWR _00335_ sky130_fd_sc_hd__mux2_1
X_06413_ cpuregs\[12\]\[4\] cpuregs\[13\]\[4\] cpuregs\[14\]\[4\] cpuregs\[15\]\[4\]
+ net264 net259 VGND VGND VPWR VPWR _02847_ sky130_fd_sc_hd__mux4_1
X_09201_ mem_rdata_q\[10\] net2 _01609_ VGND VGND VPWR VPWR _01104_ sky130_fd_sc_hd__mux2_1
X_09132_ instr_xori _04748_ _04754_ _04765_ VGND VGND VPWR VPWR _00864_ sky130_fd_sc_hd__a22o_1
XFILLER_50_789 VGND VGND VPWR VPWR sky130_fd_sc_hd__decap_6
X_06344_ _00016_ _02779_ VGND VGND VPWR VPWR _02780_ sky130_fd_sc_hd__nor2_1
XFILLER_148_677 VGND VGND VPWR VPWR sky130_fd_sc_hd__decap_6
XFILLER_136_806 VGND VGND VPWR VPWR sky130_fd_sc_hd__decap_6
Xrebuffer217 net602 VGND VGND VPWR VPWR net603 sky130_fd_sc_hd__dlygate4sd1_1
Xrebuffer206 net591 VGND VGND VPWR VPWR net592 sky130_fd_sc_hd__buf_1
XTAP_TAPCELL_ROW_20_648 VGND VPWR sky130_fd_sc_hd__tapvpwrvgnd_1
XFILLER_135_316 VPWR VGND VPWR VGND sky130_ef_sc_hd__decap_12
X_06275_ _01614_ _01621_ VGND VGND VPWR VPWR _02713_ sky130_fd_sc_hd__nor2_1
X_09063_ cpu_state\[2\] cpu_state\[6\] cpu_state\[4\] _04732_ VGND VGND VPWR VPWR
+ _04733_ sky130_fd_sc_hd__or4b_1
XTAP_TAPCELL_ROW_20_659 VGND VPWR sky130_fd_sc_hd__tapvpwrvgnd_1
XFILLER_151_809 VPWR VGND VPWR VGND sky130_ef_sc_hd__decap_12
XFILLER_116_530 VGND VGND VPWR VPWR sky130_fd_sc_hd__fill_2
XTAP_TAPCELL_ROW_116_2186 VGND VPWR sky130_fd_sc_hd__tapvpwrvgnd_1
X_05226_ reg_pc\[13\] decoded_imm\[13\] VGND VGND VPWR VPWR _01828_ sky130_fd_sc_hd__and2_1
X_08014_ _03699_ _03825_ VGND VGND VPWR VPWR _03835_ sky130_fd_sc_hd__and2b_1
XFILLER_144_861 VGND VGND VPWR VPWR sky130_fd_sc_hd__decap_6
XFILLER_78_19 VGND VGND VPWR VPWR sky130_fd_sc_hd__decap_8
X_05157_ cpu_state\[3\] _01756_ _01757_ _01764_ VGND VGND VPWR VPWR _04907_ sky130_fd_sc_hd__a31o_1
XFILLER_104_747 VGND VGND VPWR VPWR sky130_fd_sc_hd__decap_6
XFILLER_104_725 VGND VGND VPWR VPWR sky130_fd_sc_hd__fill_1
XFILLER_103_202 VGND VGND VPWR VPWR sky130_fd_sc_hd__decap_3
XPHY_EDGE_ROW_139_Left_293 VGND VGND VPWR VPWR sky130_fd_sc_hd__decap_3
XFILLER_104_769 VGND VGND VPWR VPWR sky130_fd_sc_hd__fill_1
X_09965_ clknet_leaf_56_clk _00095_ VGND VGND VPWR VPWR net189 sky130_fd_sc_hd__dfxtp_4
XFILLER_103_246 VPWR VGND VPWR VGND sky130_ef_sc_hd__decap_12
XFILLER_89_469 VGND VGND VPWR VPWR sky130_fd_sc_hd__decap_8
XFILLER_58_801 VGND VGND VPWR VPWR sky130_fd_sc_hd__decap_8
X_05088_ count_cycle\[2\] _01588_ net256 _01700_ VGND VGND VPWR VPWR _01701_ sky130_fd_sc_hd__o211a_1
X_09896_ cpuregs\[0\]\[26\] VGND VGND VPWR VPWR _01504_ sky130_fd_sc_hd__clkbuf_1
X_08916_ cpuregs\[16\]\[24\] cpuregs\[17\]\[24\] cpuregs\[18\]\[24\] cpuregs\[19\]\[24\]
+ net280 net274 VGND VGND VPWR VPWR _04594_ sky130_fd_sc_hd__mux4_1
XFILLER_76_119 VGND VGND VPWR VPWR sky130_fd_sc_hd__fill_1
X_08847_ cpuregs\[4\]\[20\] cpuregs\[5\]\[20\] cpuregs\[6\]\[20\] cpuregs\[7\]\[20\]
+ _00007_ net274 VGND VGND VPWR VPWR _04529_ sky130_fd_sc_hd__mux4_1
XFILLER_111_290 VGND VGND VPWR VPWR sky130_fd_sc_hd__fill_2
XFILLER_94_29 VPWR VGND VPWR VGND sky130_ef_sc_hd__decap_12
XFILLER_84_130 VGND VGND VPWR VPWR sky130_fd_sc_hd__fill_1
XFILLER_57_333 VGND VGND VPWR VPWR sky130_fd_sc_hd__decap_3
XFILLER_84_163 VGND VGND VPWR VPWR sky130_fd_sc_hd__decap_3
XFILLER_84_141 VGND VGND VPWR VPWR sky130_fd_sc_hd__fill_1
XFILLER_45_528 VGND VGND VPWR VPWR sky130_fd_sc_hd__fill_2
X_08778_ cpuregs\[12\]\[16\] cpuregs\[13\]\[16\] cpuregs\[14\]\[16\] cpuregs\[15\]\[16\]
+ net276 net272 VGND VGND VPWR VPWR _04464_ sky130_fd_sc_hd__mux4_1
XFILLER_73_848 VPWR VGND VPWR VGND sky130_ef_sc_hd__decap_12
X_07729_ count_instr\[28\] count_instr\[27\] _03624_ VGND VGND VPWR VPWR _03628_ sky130_fd_sc_hd__and3_1
X_10740_ clknet_leaf_19_clk _00837_ VGND VGND VPWR VPWR net227 sky130_fd_sc_hd__dfxtp_4
XFILLER_81_881 VGND VGND VPWR VPWR sky130_fd_sc_hd__decap_3
XFILLER_53_572 VGND VGND VPWR VPWR sky130_fd_sc_hd__decap_4
XFILLER_53_561 VGND VGND VPWR VPWR sky130_fd_sc_hd__decap_6
X_10671_ clknet_leaf_62_clk _04899_ VGND VGND VPWR VPWR reg_out\[29\] sky130_fd_sc_hd__dfxtp_1
XFILLER_13_458 VGND VGND VPWR VPWR sky130_fd_sc_hd__decap_4
XTAP_TAPCELL_ROW_136_2507 VGND VPWR sky130_fd_sc_hd__tapvpwrvgnd_1
XFILLER_43_66 VGND VGND VPWR VPWR sky130_fd_sc_hd__decap_4
XFILLER_127_839 VGND VGND VPWR VPWR sky130_fd_sc_hd__fill_1
XFILLER_5_602 VGND VGND VPWR VPWR sky130_fd_sc_hd__decap_8
XFILLER_153_113 VPWR VGND VPWR VGND sky130_ef_sc_hd__decap_12
X_11223_ clknet_leaf_22_clk _01270_ VGND VGND VPWR VPWR cpuregs\[3\]\[16\] sky130_fd_sc_hd__dfxtp_1
XTAP_TAPCELL_ROW_56_1222 VGND VPWR sky130_fd_sc_hd__tapvpwrvgnd_1
XTAP_TAPCELL_ROW_56_1233 VGND VPWR sky130_fd_sc_hd__tapvpwrvgnd_1
XFILLER_4_189 VGND VGND VPWR VPWR sky130_fd_sc_hd__decap_6
XFILLER_4_27 VGND VGND VPWR VPWR sky130_fd_sc_hd__fill_1
XFILLER_108_81 VGND VGND VPWR VPWR sky130_fd_sc_hd__decap_3
XFILLER_68_41 VGND VGND VPWR VPWR sky130_fd_sc_hd__decap_8
X_11154_ clknet_leaf_149_clk _01201_ VGND VGND VPWR VPWR cpuregs\[23\]\[11\] sky130_fd_sc_hd__dfxtp_1
XTAP_TAPCELL_ROW_8_462 VGND VPWR sky130_fd_sc_hd__tapvpwrvgnd_1
XFILLER_1_841 VPWR VGND VPWR VGND sky130_ef_sc_hd__decap_12
X_11085_ clknet_leaf_57_clk _01142_ VGND VGND VPWR VPWR cpuregs\[24\]\[16\] sky130_fd_sc_hd__dfxtp_1
XFILLER_68_85 VGND VGND VPWR VPWR sky130_fd_sc_hd__decap_6
X_10105_ clknet_leaf_142_clk _00235_ VGND VGND VPWR VPWR cpuregs\[28\]\[7\] sky130_fd_sc_hd__dfxtp_1
X_10036_ clknet_leaf_119_clk _00166_ VGND VGND VPWR VPWR cpuregs\[13\]\[2\] sky130_fd_sc_hd__dfxtp_1
XFILLER_48_388 VPWR VGND VPWR VGND sky130_ef_sc_hd__decap_12
X_10938_ clknet_leaf_94_clk _01000_ VGND VGND VPWR VPWR decoded_imm\[30\] sky130_fd_sc_hd__dfxtp_1
XFILLER_17_775 VGND VGND VPWR VPWR sky130_fd_sc_hd__decap_8
XFILLER_17_797 VPWR VGND VPWR VGND sky130_ef_sc_hd__decap_12
XTAP_TAPCELL_ROW_27_770 VGND VPWR sky130_fd_sc_hd__tapvpwrvgnd_1
XFILLER_32_701 VGND VGND VPWR VPWR sky130_fd_sc_hd__decap_4
XFILLER_71_391 VGND VGND VPWR VPWR sky130_fd_sc_hd__fill_1
X_10869_ clknet_leaf_28_clk _00931_ VGND VGND VPWR VPWR cpuregs\[1\]\[13\] sky130_fd_sc_hd__dfxtp_1
XFILLER_118_817 VGND VGND VPWR VPWR sky130_fd_sc_hd__fill_1
XFILLER_133_809 VPWR VGND VPWR VGND sky130_ef_sc_hd__decap_12
X_06060_ cpuregs\[24\]\[2\] cpuregs\[25\]\[2\] cpuregs\[26\]\[2\] cpuregs\[27\]\[2\]
+ net279 _00008_ VGND VGND VPWR VPWR _02533_ sky130_fd_sc_hd__mux4_1
XFILLER_126_861 VGND VGND VPWR VPWR sky130_fd_sc_hd__decap_6
X_05011_ _01634_ VGND VGND VPWR VPWR _00841_ sky130_fd_sc_hd__inv_2
XFILLER_141_853 VPWR VGND VPWR VGND sky130_ef_sc_hd__decap_12
XFILLER_125_393 VGND VGND VPWR VPWR sky130_fd_sc_hd__decap_3
XFILLER_98_233 VPWR VGND VPWR VGND sky130_ef_sc_hd__decap_12
XFILLER_141_897 VPWR VGND VPWR VGND sky130_ef_sc_hd__decap_12
X_09750_ _02678_ cpuregs\[6\]\[23\] _04873_ VGND VGND VPWR VPWR _01405_ sky130_fd_sc_hd__mux2_1
XFILLER_113_588 VPWR VGND VPWR VGND sky130_ef_sc_hd__decap_12
X_06962_ _03370_ _03372_ _03373_ _03374_ VGND VGND VPWR VPWR _03376_ sky130_fd_sc_hd__a31o_1
X_09681_ cpuregs\[4\]\[20\] _02665_ _04871_ VGND VGND VPWR VPWR _01338_ sky130_fd_sc_hd__mux2_1
X_05913_ _02463_ _02465_ VGND VGND VPWR VPWR alu_out\[30\] sky130_fd_sc_hd__or2_1
XFILLER_67_653 VGND VGND VPWR VPWR sky130_fd_sc_hd__decap_3
X_08701_ cpuregs\[4\]\[12\] cpuregs\[5\]\[12\] cpuregs\[6\]\[12\] cpuregs\[7\]\[12\]
+ net278 net273 VGND VGND VPWR VPWR _04391_ sky130_fd_sc_hd__mux4_1
X_06893_ cpuregs\[12\]\[21\] cpuregs\[13\]\[21\] cpuregs\[14\]\[21\] cpuregs\[15\]\[21\]
+ _00012_ _00013_ VGND VGND VPWR VPWR _03310_ sky130_fd_sc_hd__mux4_1
XTAP_TAPCELL_ROW_87_1727 VGND VPWR sky130_fd_sc_hd__tapvpwrvgnd_1
XTAP_TAPCELL_ROW_87_1716 VGND VPWR sky130_fd_sc_hd__tapvpwrvgnd_1
XFILLER_82_601 VPWR VGND VPWR VGND sky130_ef_sc_hd__decap_12
XFILLER_67_686 VPWR VGND VPWR VGND sky130_ef_sc_hd__decap_12
XFILLER_54_303 VGND VGND VPWR VPWR sky130_fd_sc_hd__decap_4
X_08632_ cpuregs\[8\]\[8\] cpuregs\[9\]\[8\] cpuregs\[10\]\[8\] cpuregs\[11\]\[8\]
+ net278 net273 VGND VGND VPWR VPWR _04326_ sky130_fd_sc_hd__mux4_1
X_05844_ net255 _02401_ _02402_ _02404_ VGND VGND VPWR VPWR alu_out\[22\] sky130_fd_sc_hd__a31o_1
XFILLER_82_645 VGND VGND VPWR VPWR sky130_fd_sc_hd__fill_2
XFILLER_81_100 VPWR VGND VPWR VGND sky130_ef_sc_hd__decap_12
XFILLER_54_336 VGND VGND VPWR VPWR sky130_fd_sc_hd__fill_2
X_05775_ _02149_ _02342_ VGND VGND VPWR VPWR _02343_ sky130_fd_sc_hd__nand2_1
X_08563_ decoded_imm\[4\] _01653_ _01585_ VGND VGND VPWR VPWR _04261_ sky130_fd_sc_hd__o21a_1
X_08494_ net78 net47 _04208_ VGND VGND VPWR VPWR _00792_ sky130_fd_sc_hd__mux2_1
XFILLER_120_27 VGND VGND VPWR VPWR sky130_fd_sc_hd__fill_1
XTAP_TAPCELL_ROW_25_729 VGND VPWR sky130_fd_sc_hd__tapvpwrvgnd_1
X_07514_ latched_rd\[2\] latched_rd\[3\] latched_rd\[4\] VGND VGND VPWR VPWR _03569_
+ sky130_fd_sc_hd__or3b_1
XFILLER_35_561 VGND VGND VPWR VPWR sky130_fd_sc_hd__fill_1
X_07445_ cpuregs\[27\]\[29\] _02704_ _03566_ VGND VGND VPWR VPWR _00385_ sky130_fd_sc_hd__mux2_1
XFILLER_35_594 VPWR VGND VPWR VGND sky130_ef_sc_hd__decap_12
X_07376_ _02696_ cpuregs\[9\]\[27\] _03563_ VGND VGND VPWR VPWR _00319_ sky130_fd_sc_hd__mux2_1
XTAP_TAPCELL_ROW_118_2226 VGND VPWR sky130_fd_sc_hd__tapvpwrvgnd_1
XTAP_TAPCELL_ROW_118_2215 VGND VPWR sky130_fd_sc_hd__tapvpwrvgnd_1
X_09115_ _04746_ _04749_ VGND VGND VPWR VPWR _04760_ sky130_fd_sc_hd__and2_1
XFILLER_13_69 VPWR VGND VPWR VGND sky130_ef_sc_hd__decap_12
X_06327_ net171 net193 _02721_ VGND VGND VPWR VPWR _02764_ sky130_fd_sc_hd__mux2_1
XFILLER_148_496 VGND VGND VPWR VPWR sky130_fd_sc_hd__fill_1
X_06258_ _02699_ cpuregs\[11\]\[28\] _02582_ VGND VGND VPWR VPWR _00065_ sky130_fd_sc_hd__mux2_1
XFILLER_129_69 VGND VGND VPWR VPWR sky130_fd_sc_hd__decap_6
X_09046_ cpuregs\[24\]\[31\] cpuregs\[25\]\[31\] cpuregs\[26\]\[31\] cpuregs\[27\]\[31\]
+ net276 net272 VGND VGND VPWR VPWR _04717_ sky130_fd_sc_hd__mux4_1
XFILLER_151_617 VGND VGND VPWR VPWR sky130_fd_sc_hd__decap_3
XTAP_TAPCELL_ROW_131_2426 VGND VPWR sky130_fd_sc_hd__tapvpwrvgnd_1
XFILLER_123_319 VGND VGND VPWR VPWR sky130_fd_sc_hd__fill_2
X_05209_ _01811_ VGND VGND VPWR VPWR _01812_ sky130_fd_sc_hd__inv_2
XPHY_EDGE_ROW_147_Left_301 VGND VGND VPWR VPWR sky130_fd_sc_hd__decap_3
X_06189_ reg_pc\[15\] reg_pc\[14\] _02636_ VGND VGND VPWR VPWR _02644_ sky130_fd_sc_hd__and3_2
XFILLER_145_57 VPWR VGND VPWR VGND sky130_ef_sc_hd__decap_12
XFILLER_104_555 VPWR VGND VPWR VGND sky130_ef_sc_hd__decap_12
XFILLER_104_533 VPWR VGND VPWR VGND sky130_ef_sc_hd__decap_12
XFILLER_89_244 VGND VGND VPWR VPWR sky130_fd_sc_hd__decap_8
XFILLER_78_907 VGND VGND VPWR VPWR sky130_fd_sc_hd__fill_1
XFILLER_1_137 VPWR VGND VPWR VGND sky130_ef_sc_hd__decap_12
XFILLER_131_363 VGND VGND VPWR VPWR sky130_fd_sc_hd__fill_2
X_09948_ clknet_leaf_133_clk _00078_ VGND VGND VPWR VPWR net202 sky130_fd_sc_hd__dfxtp_4
XTAP_TAPCELL_ROW_5_410 VGND VPWR sky130_fd_sc_hd__tapvpwrvgnd_1
XFILLER_58_620 VGND VGND VPWR VPWR sky130_fd_sc_hd__decap_8
XTAP_TAPCELL_ROW_51_1152 VGND VPWR sky130_fd_sc_hd__tapvpwrvgnd_1
XTAP_TAPCELL_ROW_51_1141 VGND VPWR sky130_fd_sc_hd__tapvpwrvgnd_1
XTAP_TAPCELL_ROW_129_2399 VGND VPWR sky130_fd_sc_hd__tapvpwrvgnd_1
XTAP_TAPCELL_ROW_129_2388 VGND VPWR sky130_fd_sc_hd__tapvpwrvgnd_1
X_09879_ cpuregs\[0\]\[9\] VGND VGND VPWR VPWR _01487_ sky130_fd_sc_hd__clkbuf_1
XTAP_TAPCELL_ROW_142_2599 VGND VPWR sky130_fd_sc_hd__tapvpwrvgnd_1
XFILLER_73_689 VGND VGND VPWR VPWR sky130_fd_sc_hd__decap_8
XFILLER_14_701 VPWR VGND VPWR VGND sky130_ef_sc_hd__decap_12
X_10723_ clknet_leaf_19_clk _00820_ VGND VGND VPWR VPWR net208 sky130_fd_sc_hd__dfxtp_2
XFILLER_53_391 VGND VGND VPWR VPWR sky130_fd_sc_hd__fill_1
XFILLER_13_244 VGND VGND VPWR VPWR sky130_fd_sc_hd__fill_2
XFILLER_14_778 VPWR VGND VPWR VGND sky130_ef_sc_hd__decap_12
X_10654_ clknet_leaf_96_clk _04881_ VGND VGND VPWR VPWR reg_out\[12\] sky130_fd_sc_hd__dfxtp_1
XFILLER_127_614 VGND VGND VPWR VPWR sky130_fd_sc_hd__fill_2
XFILLER_127_603 VGND VGND VPWR VPWR sky130_fd_sc_hd__fill_2
X_10585_ clknet_leaf_104_clk _00715_ VGND VGND VPWR VPWR count_cycle\[8\] sky130_fd_sc_hd__dfxtp_1
XFILLER_126_113 VGND VGND VPWR VPWR sky130_fd_sc_hd__fill_1
Xclkload29 clknet_leaf_137_clk VGND VGND VPWR VPWR clkload29/Y sky130_fd_sc_hd__bufinv_16
Xclkload18 clknet_leaf_151_clk VGND VGND VPWR VPWR clkload18/Y sky130_fd_sc_hd__inv_8
XFILLER_142_606 VGND VGND VPWR VPWR sky130_fd_sc_hd__fill_1
XFILLER_5_465 VGND VGND VPWR VPWR sky130_fd_sc_hd__fill_1
XTAP_TAPCELL_ROW_149_2709 VGND VPWR sky130_fd_sc_hd__tapvpwrvgnd_1
XFILLER_142_628 VPWR VGND VPWR VGND sky130_ef_sc_hd__decap_12
XFILLER_108_883 VPWR VGND VPWR VGND sky130_ef_sc_hd__decap_12
XFILLER_107_382 VGND VGND VPWR VPWR sky130_fd_sc_hd__fill_1
XFILLER_123_853 VPWR VGND VPWR VGND sky130_ef_sc_hd__decap_12
X_11206_ clknet_leaf_16_clk _01253_ VGND VGND VPWR VPWR cpuregs\[29\]\[31\] sky130_fd_sc_hd__dfxtp_1
XFILLER_150_661 VGND VGND VPWR VPWR sky130_fd_sc_hd__decap_8
X_11137_ clknet_leaf_41_clk _01184_ VGND VGND VPWR VPWR cpuregs\[31\]\[26\] sky130_fd_sc_hd__dfxtp_1
XFILLER_123_897 VPWR VGND VPWR VGND sky130_ef_sc_hd__decap_12
XFILLER_96_726 VGND VGND VPWR VPWR sky130_fd_sc_hd__decap_6
XFILLER_68_406 VGND VGND VPWR VPWR sky130_fd_sc_hd__fill_1
XFILLER_95_225 VGND VGND VPWR VPWR sky130_fd_sc_hd__decap_4
XFILLER_0_181 VPWR VGND VPWR VGND sky130_ef_sc_hd__decap_12
X_11068_ clknet_leaf_88_clk _01125_ VGND VGND VPWR VPWR mem_rdata_q\[31\] sky130_fd_sc_hd__dfxtp_2
XFILLER_76_461 VGND VGND VPWR VPWR sky130_fd_sc_hd__decap_3
X_10019_ clknet_leaf_21_clk _00149_ VGND VGND VPWR VPWR cpuregs\[30\]\[17\] sky130_fd_sc_hd__dfxtp_1
XTAP_TAPCELL_ROW_69_1435 VGND VPWR sky130_fd_sc_hd__tapvpwrvgnd_1
XFILLER_63_111 VGND VGND VPWR VPWR sky130_fd_sc_hd__fill_1
XFILLER_36_325 VGND VGND VPWR VPWR sky130_fd_sc_hd__decap_3
XFILLER_24_509 VGND VGND VPWR VPWR sky130_fd_sc_hd__decap_4
XFILLER_36_369 VGND VGND VPWR VPWR sky130_fd_sc_hd__fill_1
XFILLER_52_829 VGND VGND VPWR VPWR sky130_fd_sc_hd__decap_4
X_05560_ net607 net108 VGND VGND VPWR VPWR _02143_ sky130_fd_sc_hd__xor2_1
XFILLER_17_561 VGND VGND VPWR VPWR sky130_fd_sc_hd__fill_1
XTAP_TAPCELL_ROW_82_1646 VGND VPWR sky130_fd_sc_hd__tapvpwrvgnd_1
XFILLER_149_205 VPWR VGND VPWR VGND sky130_ef_sc_hd__decap_12
X_05491_ net192 net224 VGND VGND VPWR VPWR _02074_ sky130_fd_sc_hd__nor2_1
X_07230_ cpuregs\[13\]\[14\] _02641_ net251 VGND VGND VPWR VPWR _00178_ sky130_fd_sc_hd__mux2_1
X_07161_ cpuregs\[12\]\[15\] _02646_ net253 VGND VGND VPWR VPWR _00115_ sky130_fd_sc_hd__mux2_1
XFILLER_117_135 VGND VGND VPWR VPWR sky130_fd_sc_hd__fill_1
X_06112_ _02579_ _02581_ VGND VGND VPWR VPWR _02582_ sky130_fd_sc_hd__or2_4
XFILLER_133_617 VGND VGND VPWR VPWR sky130_fd_sc_hd__fill_1
XTAP_TAPCELL_ROW_113_2134 VGND VPWR sky130_fd_sc_hd__tapvpwrvgnd_1
X_07092_ decoded_imm\[29\] net192 VGND VGND VPWR VPWR _03501_ sky130_fd_sc_hd__nor2_1
XTAP_TAPCELL_ROW_113_2145 VGND VPWR sky130_fd_sc_hd__tapvpwrvgnd_1
XFILLER_105_319 VGND VGND VPWR VPWR sky130_fd_sc_hd__decap_3
X_06043_ _01637_ _01639_ reg_sh\[2\] VGND VGND VPWR VPWR _02516_ sky130_fd_sc_hd__a21oi_1
XFILLER_5_81 VPWR VGND VPWR VGND sky130_ef_sc_hd__decap_12
XFILLER_101_503 VGND VGND VPWR VPWR sky130_fd_sc_hd__fill_1
XFILLER_86_203 VGND VGND VPWR VPWR sky130_fd_sc_hd__fill_1
X_09802_ _02621_ cpuregs\[8\]\[9\] _04875_ VGND VGND VPWR VPWR _01455_ sky130_fd_sc_hd__mux2_1
XFILLER_87_759 VGND VGND VPWR VPWR sky130_fd_sc_hd__fill_2
X_07994_ _01549_ _03816_ VGND VGND VPWR VPWR _00685_ sky130_fd_sc_hd__nor2_1
X_06945_ cpuregs\[12\]\[23\] cpuregs\[13\]\[23\] cpuregs\[14\]\[23\] cpuregs\[15\]\[23\]
+ net267 net260 VGND VGND VPWR VPWR _03360_ sky130_fd_sc_hd__mux4_1
X_09733_ _02607_ cpuregs\[6\]\[6\] _04873_ VGND VGND VPWR VPWR _01388_ sky130_fd_sc_hd__mux2_1
XFILLER_39_130 VGND VGND VPWR VPWR sky130_fd_sc_hd__fill_1
XFILLER_131_15 VPWR VGND VPWR VGND sky130_ef_sc_hd__decap_12
X_06876_ reg_pc\[20\] _02751_ _03293_ _02715_ VGND VGND VPWR VPWR _03294_ sky130_fd_sc_hd__a211o_1
X_09664_ cpuregs\[4\]\[3\] _02593_ net238 VGND VGND VPWR VPWR _01321_ sky130_fd_sc_hd__mux2_1
XFILLER_27_314 VGND VGND VPWR VPWR sky130_fd_sc_hd__fill_2
XFILLER_28_837 VPWR VGND VPWR VGND sky130_ef_sc_hd__decap_12
X_05827_ _02217_ _02388_ instr_sub VGND VGND VPWR VPWR _02389_ sky130_fd_sc_hd__o21ai_1
X_09595_ _02588_ cpuregs\[3\]\[1\] _04868_ VGND VGND VPWR VPWR _01255_ sky130_fd_sc_hd__mux2_1
X_08615_ _04304_ _04305_ _01558_ VGND VGND VPWR VPWR _04310_ sky130_fd_sc_hd__mux2_1
XFILLER_43_818 VGND VGND VPWR VPWR sky130_fd_sc_hd__decap_8
XFILLER_70_637 VGND VGND VPWR VPWR sky130_fd_sc_hd__decap_6
XFILLER_36_881 VPWR VGND VPWR VGND sky130_ef_sc_hd__decap_12
X_05758_ instr_sub _02154_ _02327_ _02326_ VGND VGND VPWR VPWR _02328_ sky130_fd_sc_hd__o31a_1
X_08546_ cpuregs\[16\]\[1\] cpuregs\[17\]\[1\] cpuregs\[18\]\[1\] cpuregs\[19\]\[1\]
+ net279 _00008_ VGND VGND VPWR VPWR _04247_ sky130_fd_sc_hd__mux4_1
X_08477_ net91 net60 _04208_ VGND VGND VPWR VPWR _00775_ sky130_fd_sc_hd__mux2_1
X_05689_ _02237_ _02267_ _02140_ VGND VGND VPWR VPWR _02268_ sky130_fd_sc_hd__o21ba_1
XFILLER_149_750 VPWR VGND VPWR VGND sky130_ef_sc_hd__decap_12
X_07428_ cpuregs\[27\]\[12\] _02633_ _03566_ VGND VGND VPWR VPWR _00368_ sky130_fd_sc_hd__mux2_1
XFILLER_109_603 VPWR VGND VPWR VGND sky130_ef_sc_hd__decap_12
X_07359_ _02624_ cpuregs\[9\]\[10\] _03563_ VGND VGND VPWR VPWR _00302_ sky130_fd_sc_hd__mux2_1
XFILLER_10_269 VPWR VGND VPWR VGND sky130_ef_sc_hd__decap_12
XPHY_EDGE_ROW_149_Right_149 VGND VGND VPWR VPWR sky130_fd_sc_hd__decap_3
X_10370_ clknet_leaf_57_clk _00500_ VGND VGND VPWR VPWR cpuregs\[25\]\[16\] sky130_fd_sc_hd__dfxtp_1
X_09029_ cpuregs\[24\]\[30\] cpuregs\[25\]\[30\] cpuregs\[26\]\[30\] cpuregs\[27\]\[30\]
+ net275 net271 VGND VGND VPWR VPWR _04701_ sky130_fd_sc_hd__mux4_1
XFILLER_2_413 VGND VGND VPWR VPWR sky130_fd_sc_hd__decap_6
XFILLER_105_853 VGND VGND VPWR VPWR sky130_fd_sc_hd__decap_4
XFILLER_131_160 VGND VGND VPWR VPWR sky130_fd_sc_hd__decap_8
XFILLER_105_897 VGND VGND VPWR VPWR sky130_fd_sc_hd__decap_3
XFILLER_49_43 VPWR VGND VPWR VGND sky130_ef_sc_hd__decap_12
XFILLER_104_396 VPWR VGND VPWR VGND sky130_ef_sc_hd__decap_12
XFILLER_77_225 VPWR VGND VPWR VGND sky130_ef_sc_hd__decap_12
XTAP_TAPCELL_ROW_144_2639 VGND VPWR sky130_fd_sc_hd__tapvpwrvgnd_1
XTAP_TAPCELL_ROW_144_2628 VGND VPWR sky130_fd_sc_hd__tapvpwrvgnd_1
XFILLER_120_867 VGND VGND VPWR VPWR sky130_fd_sc_hd__fill_1
XFILLER_1_39 VPWR VGND VPWR VGND sky130_ef_sc_hd__decap_12
XFILLER_61_626 VGND VGND VPWR VPWR sky130_fd_sc_hd__fill_1
XFILLER_81_30 VPWR VGND VPWR VGND sky130_ef_sc_hd__decap_12
XTAP_TAPCELL_ROW_64_1354 VGND VPWR sky130_fd_sc_hd__tapvpwrvgnd_1
X_10706_ clknet_leaf_102_clk _00804_ VGND VGND VPWR VPWR mem_do_rdata sky130_fd_sc_hd__dfxtp_4
Xclkload118 clknet_leaf_67_clk VGND VGND VPWR VPWR clkload118/X sky130_fd_sc_hd__clkbuf_4
XFILLER_127_422 VPWR VGND VPWR VGND sky130_ef_sc_hd__decap_12
X_10637_ clknet_leaf_82_clk _00767_ VGND VGND VPWR VPWR count_cycle\[60\] sky130_fd_sc_hd__dfxtp_1
Xclkload107 clknet_leaf_107_clk VGND VGND VPWR VPWR clkload107/Y sky130_fd_sc_hd__inv_8
XFILLER_10_781 VPWR VGND VPWR VGND sky130_ef_sc_hd__decap_12
X_10568_ clknet_leaf_64_clk _00698_ VGND VGND VPWR VPWR reg_next_pc\[23\] sky130_fd_sc_hd__dfxtp_1
XPHY_EDGE_ROW_116_Right_116 VGND VGND VPWR VPWR sky130_fd_sc_hd__decap_3
Xclkload129 clknet_leaf_85_clk VGND VGND VPWR VPWR clkload129/Y sky130_fd_sc_hd__inv_6
XFILLER_127_499 VGND VGND VPWR VPWR sky130_fd_sc_hd__decap_4
X_10499_ clknet_leaf_86_clk _00629_ VGND VGND VPWR VPWR count_instr\[48\] sky130_fd_sc_hd__dfxtp_1
XFILLER_107_190 VGND VGND VPWR VPWR sky130_fd_sc_hd__fill_2
XFILLER_111_856 VGND VGND VPWR VPWR sky130_fd_sc_hd__fill_2
XFILLER_110_322 VGND VGND VPWR VPWR sky130_fd_sc_hd__fill_1
XFILLER_68_225 VPWR VGND VPWR VGND sky130_ef_sc_hd__decap_12
XFILLER_110_344 VGND VGND VPWR VPWR sky130_fd_sc_hd__fill_1
XFILLER_96_589 VGND VGND VPWR VPWR sky130_fd_sc_hd__decap_3
X_04991_ mem_do_wdata net34 cpu_state\[5\] _01614_ VGND VGND VPWR VPWR _01619_ sky130_fd_sc_hd__and4b_1
X_06730_ _00015_ _03149_ _03152_ _02735_ VGND VGND VPWR VPWR _03153_ sky130_fd_sc_hd__o211a_1
Xinput5 mem_rdata[13] VGND VGND VPWR VPWR net5 sky130_fd_sc_hd__buf_1
X_06661_ _03057_ _03061_ _03084_ _01621_ VGND VGND VPWR VPWR _03086_ sky130_fd_sc_hd__a31o_1
X_08400_ count_cycle\[50\] _04144_ count_cycle\[52\] count_cycle\[51\] VGND VGND VPWR
+ VPWR _04149_ sky130_fd_sc_hd__and4_1
XFILLER_91_272 VGND VGND VPWR VPWR sky130_fd_sc_hd__decap_8
X_05612_ _01561_ net204 _02119_ _02194_ VGND VGND VPWR VPWR _02195_ sky130_fd_sc_hd__o31a_1
XFILLER_52_615 VPWR VGND VPWR VGND sky130_ef_sc_hd__decap_12
XFILLER_18_881 VPWR VGND VPWR VGND sky130_ef_sc_hd__decap_12
X_09380_ decoded_imm\[6\] _04746_ _04852_ VGND VGND VPWR VPWR _01024_ sky130_fd_sc_hd__o21a_1
X_06592_ cpuregs\[16\]\[10\] cpuregs\[17\]\[10\] cpuregs\[18\]\[10\] cpuregs\[19\]\[10\]
+ net263 net259 VGND VGND VPWR VPWR _03020_ sky130_fd_sc_hd__mux4_1
X_08331_ count_cycle\[26\] net416 _01549_ VGND VGND VPWR VPWR _04106_ sky130_fd_sc_hd__a21oi_1
XFILLER_51_169 VPWR VGND VPWR VGND sky130_ef_sc_hd__decap_12
X_05543_ net196 net122 VGND VGND VPWR VPWR _02126_ sky130_fd_sc_hd__or2_1
X_05474_ _02053_ _02055_ VGND VGND VPWR VPWR _02057_ sky130_fd_sc_hd__or2_1
XTAP_TAPCELL_ROW_15_570 VGND VPWR sky130_fd_sc_hd__tapvpwrvgnd_1
XFILLER_33_895 VGND VGND VPWR VPWR sky130_fd_sc_hd__fill_1
X_08262_ count_cycle\[0\] count_cycle\[1\] count_cycle\[2\] VGND VGND VPWR VPWR _04061_
+ sky130_fd_sc_hd__a21o_1
XFILLER_137_219 VGND VGND VPWR VPWR sky130_fd_sc_hd__decap_4
X_07213_ cpuregs\[30\]\[31\] _02712_ net252 VGND VGND VPWR VPWR _00163_ sky130_fd_sc_hd__mux2_1
XFILLER_20_545 VPWR VGND VPWR VGND sky130_ef_sc_hd__decap_12
X_08193_ _03986_ _03989_ _03999_ VGND VGND VPWR VPWR _04000_ sky130_fd_sc_hd__o21ai_1
XFILLER_118_433 VGND VGND VPWR VPWR sky130_fd_sc_hd__decap_4
X_07144_ latched_rd\[4\] latched_rd\[3\] latched_rd\[2\] VGND VGND VPWR VPWR _03551_
+ sky130_fd_sc_hd__nand3b_4
XFILLER_106_617 VGND VGND VPWR VPWR sky130_fd_sc_hd__decap_8
X_07075_ _02714_ _03481_ _03483_ _03484_ VGND VGND VPWR VPWR _03485_ sky130_fd_sc_hd__or4_1
XTAP_TAPCELL_ROW_95_1859 VGND VPWR sky130_fd_sc_hd__tapvpwrvgnd_1
XTAP_TAPCELL_ROW_95_1848 VGND VPWR sky130_fd_sc_hd__tapvpwrvgnd_1
XFILLER_10_15 VPWR VGND VPWR VGND sky130_ef_sc_hd__decap_12
XFILLER_133_447 VGND VGND VPWR VPWR sky130_fd_sc_hd__fill_1
XFILLER_126_15 VPWR VGND VPWR VGND sky130_ef_sc_hd__decap_12
X_06026_ decoded_imm_j\[2\] _01116_ _02513_ VGND VGND VPWR VPWR _00029_ sky130_fd_sc_hd__mux2_1
XFILLER_126_59 VGND VGND VPWR VPWR sky130_fd_sc_hd__fill_1
XFILLER_87_501 VGND VGND VPWR VPWR sky130_fd_sc_hd__decap_3
XFILLER_59_225 VPWR VGND VPWR VGND sky130_ef_sc_hd__decap_12
X_07977_ _03798_ _03800_ VGND VGND VPWR VPWR _03801_ sky130_fd_sc_hd__nor2_1
X_09716_ _02675_ cpuregs\[5\]\[22\] _04872_ VGND VGND VPWR VPWR _01372_ sky130_fd_sc_hd__mux2_1
XTAP_TAPCELL_ROW_126_2347 VGND VPWR sky130_fd_sc_hd__tapvpwrvgnd_1
X_06928_ _03325_ _03326_ _03328_ _03343_ VGND VGND VPWR VPWR _03344_ sky130_fd_sc_hd__o31a_1
XFILLER_68_781 VGND VGND VPWR VPWR sky130_fd_sc_hd__decap_4
XFILLER_19_57 VPWR VGND VPWR VGND sky130_ef_sc_hd__decap_12
XFILLER_71_902 VGND VGND VPWR VPWR sky130_fd_sc_hd__fill_2
XFILLER_28_645 VGND VGND VPWR VPWR sky130_fd_sc_hd__fill_1
X_09647_ _02665_ cpuregs\[22\]\[20\] _04869_ VGND VGND VPWR VPWR _01306_ sky130_fd_sc_hd__mux2_1
X_06859_ _02744_ _03192_ _03276_ _02714_ VGND VGND VPWR VPWR _03277_ sky130_fd_sc_hd__a31o_1
XFILLER_83_773 VGND VGND VPWR VPWR sky130_fd_sc_hd__fill_1
XFILLER_43_615 VGND VGND VPWR VPWR sky130_fd_sc_hd__fill_1
X_09578_ cpuregs\[29\]\[17\] _02654_ net239 VGND VGND VPWR VPWR _01239_ sky130_fd_sc_hd__mux2_1
X_08529_ _00009_ _04230_ _04229_ _01559_ VGND VGND VPWR VPWR _04231_ sky130_fd_sc_hd__o211a_1
XFILLER_30_309 VGND VGND VPWR VPWR sky130_fd_sc_hd__decap_6
XTAP_TAPCELL_ROW_46_1062 VGND VPWR sky130_fd_sc_hd__tapvpwrvgnd_1
XTAP_TAPCELL_ROW_104_1999 VGND VPWR sky130_fd_sc_hd__tapvpwrvgnd_1
XTAP_TAPCELL_ROW_104_1988 VGND VPWR sky130_fd_sc_hd__tapvpwrvgnd_1
XFILLER_70_489 VGND VGND VPWR VPWR sky130_fd_sc_hd__decap_4
XFILLER_11_501 VGND VGND VPWR VPWR sky130_fd_sc_hd__decap_3
XTAP_TAPCELL_ROW_46_1073 VGND VPWR sky130_fd_sc_hd__tapvpwrvgnd_1
XFILLER_136_3 VPWR VGND VPWR VGND sky130_ef_sc_hd__decap_12
XFILLER_7_505 VGND VGND VPWR VPWR sky130_fd_sc_hd__decap_4
XFILLER_51_55 VGND VGND VPWR VPWR sky130_fd_sc_hd__fill_1
X_11471_ clknet_leaf_145_clk _01515_ VGND VGND VPWR VPWR cpuregs\[10\]\[5\] sky130_fd_sc_hd__dfxtp_1
X_10422_ clknet_leaf_134_clk _00552_ VGND VGND VPWR VPWR cpuregs\[17\]\[4\] sky130_fd_sc_hd__dfxtp_1
XFILLER_137_797 VPWR VGND VPWR VGND sky130_ef_sc_hd__decap_12
XFILLER_109_477 VPWR VGND VPWR VGND sky130_ef_sc_hd__decap_12
X_10353_ clknet_leaf_14_clk _00483_ VGND VGND VPWR VPWR cpuregs\[16\]\[31\] sky130_fd_sc_hd__dfxtp_1
XFILLER_2_221 VPWR VGND VPWR VGND sky130_ef_sc_hd__decap_12
X_10284_ clknet_leaf_40_clk _00414_ VGND VGND VPWR VPWR cpuregs\[15\]\[26\] sky130_fd_sc_hd__dfxtp_1
XFILLER_3_777 VGND VGND VPWR VPWR sky130_fd_sc_hd__decap_6
XFILLER_2_265 VPWR VGND VPWR VGND sky130_ef_sc_hd__decap_12
XFILLER_120_642 VGND VGND VPWR VPWR sky130_fd_sc_hd__fill_2
XFILLER_78_589 VPWR VGND VPWR VGND sky130_ef_sc_hd__decap_12
XFILLER_76_85 VPWR VGND VPWR VGND sky130_ef_sc_hd__decap_12
XFILLER_93_559 VGND VGND VPWR VPWR sky130_fd_sc_hd__fill_1
XFILLER_73_261 VGND VGND VPWR VPWR sky130_fd_sc_hd__decap_3
XFILLER_34_604 VGND VGND VPWR VPWR sky130_fd_sc_hd__fill_2
XFILLER_73_272 VGND VGND VPWR VPWR sky130_fd_sc_hd__decap_8
XFILLER_15_895 VGND VGND VPWR VPWR sky130_fd_sc_hd__fill_1
XFILLER_30_810 VGND VGND VPWR VPWR sky130_fd_sc_hd__fill_2
XTAP_TAPCELL_ROW_32_838 VGND VPWR sky130_fd_sc_hd__tapvpwrvgnd_1
XTAP_TAPCELL_ROW_32_849 VGND VPWR sky130_fd_sc_hd__tapvpwrvgnd_1
XFILLER_42_670 VGND VGND VPWR VPWR sky130_fd_sc_hd__decap_4
XFILLER_41_191 VGND VGND VPWR VPWR sky130_fd_sc_hd__fill_1
XFILLER_128_742 VPWR VGND VPWR VGND sky130_ef_sc_hd__decap_12
X_05190_ count_instr\[10\] instr_rdinstr count_cycle\[42\] instr_rdcycleh VGND VGND
+ VPWR VPWR _01795_ sky130_fd_sc_hd__a22o_1
XFILLER_115_414 VGND VGND VPWR VPWR sky130_fd_sc_hd__decap_8
XTAP_TAPCELL_ROW_77_1556 VGND VPWR sky130_fd_sc_hd__tapvpwrvgnd_1
XFILLER_115_447 VGND VGND VPWR VPWR sky130_fd_sc_hd__fill_1
XTAP_TAPCELL_ROW_77_1567 VGND VPWR sky130_fd_sc_hd__tapvpwrvgnd_1
XFILLER_88_309 VGND VGND VPWR VPWR sky130_fd_sc_hd__fill_2
X_08880_ cpuregs\[12\]\[22\] cpuregs\[13\]\[22\] cpuregs\[14\]\[22\] cpuregs\[15\]\[22\]
+ net276 net272 VGND VGND VPWR VPWR _04560_ sky130_fd_sc_hd__mux4_1
XPHY_EDGE_ROW_102_Left_256 VGND VGND VPWR VPWR sky130_fd_sc_hd__decap_3
XTAP_TAPCELL_ROW_90_1767 VGND VPWR sky130_fd_sc_hd__tapvpwrvgnd_1
XFILLER_69_512 VGND VGND VPWR VPWR sky130_fd_sc_hd__fill_2
X_07900_ net405 _03688_ VGND VGND VPWR VPWR _03731_ sky130_fd_sc_hd__or2_1
XFILLER_111_653 VGND VGND VPWR VPWR sky130_fd_sc_hd__fill_2
XFILLER_110_141 VGND VGND VPWR VPWR sky130_fd_sc_hd__decap_3
XFILLER_110_130 VGND VGND VPWR VPWR sky130_fd_sc_hd__decap_8
XFILLER_97_876 VGND VGND VPWR VPWR sky130_fd_sc_hd__decap_8
XTAP_TAPCELL_ROW_90_1778 VGND VPWR sky130_fd_sc_hd__tapvpwrvgnd_1
X_07831_ _02594_ reg_next_pc\[4\] _02482_ VGND VGND VPWR VPWR _03691_ sky130_fd_sc_hd__mux2_2
XFILLER_111_697 VPWR VGND VPWR VGND sky130_ef_sc_hd__decap_12
XFILLER_84_515 VPWR VGND VPWR VGND sky130_ef_sc_hd__decap_12
XFILLER_38_910 VGND VGND VPWR VPWR sky130_fd_sc_hd__fill_2
XFILLER_110_185 VGND VGND VPWR VPWR sky130_fd_sc_hd__fill_1
XTAP_TAPCELL_ROW_108_2066 VGND VPWR sky130_fd_sc_hd__tapvpwrvgnd_1
XTAP_TAPCELL_ROW_108_2055 VGND VPWR sky130_fd_sc_hd__tapvpwrvgnd_1
XFILLER_84_559 VGND VGND VPWR VPWR sky130_fd_sc_hd__decap_4
X_07762_ _03648_ net34 _03647_ VGND VGND VPWR VPWR _00621_ sky130_fd_sc_hd__and3b_1
X_04974_ net171 mem_wordsize\[2\] mem_wordsize\[0\] VGND VGND VPWR VPWR _01604_ sky130_fd_sc_hd__a21o_1
X_09501_ cpuregs\[31\]\[6\] _02607_ net240 VGND VGND VPWR VPWR _01164_ sky130_fd_sc_hd__mux2_1
X_06713_ _01621_ _03135_ VGND VGND VPWR VPWR _03136_ sky130_fd_sc_hd__nor2_1
X_07693_ _03604_ net34 _03603_ VGND VGND VPWR VPWR _00596_ sky130_fd_sc_hd__and3b_1
X_06644_ cpuregs\[20\]\[12\] cpuregs\[21\]\[12\] cpuregs\[22\]\[12\] cpuregs\[23\]\[12\]
+ net263 net259 VGND VGND VPWR VPWR _03070_ sky130_fd_sc_hd__mux4_1
X_09432_ _02593_ cpuregs\[19\]\[3\] _04863_ VGND VGND VPWR VPWR _01065_ sky130_fd_sc_hd__mux2_1
XFILLER_24_114 VGND VGND VPWR VPWR sky130_fd_sc_hd__fill_1
XTAP_TAPCELL_ROW_121_2266 VGND VPWR sky130_fd_sc_hd__tapvpwrvgnd_1
XFILLER_80_776 VGND VGND VPWR VPWR sky130_fd_sc_hd__decap_4
X_09363_ decoded_imm\[14\] _04746_ _04824_ _04843_ VGND VGND VPWR VPWR _01016_ sky130_fd_sc_hd__o22a_1
X_06575_ net202 _02725_ _03003_ VGND VGND VPWR VPWR _00078_ sky130_fd_sc_hd__a21o_1
XPHY_EDGE_ROW_111_Left_265 VGND VGND VPWR VPWR sky130_fd_sc_hd__decap_3
X_05526_ net179 net211 VGND VGND VPWR VPWR _02109_ sky130_fd_sc_hd__and2_1
X_08314_ count_cycle\[20\] _04092_ net34 VGND VGND VPWR VPWR _04095_ sky130_fd_sc_hd__o21ai_1
XFILLER_21_821 VPWR VGND VPWR VGND sky130_ef_sc_hd__decap_12
X_09294_ net151 net113 _04206_ VGND VGND VPWR VPWR _00980_ sky130_fd_sc_hd__mux2_1
XANTENNA_10 _03556_ VGND VGND VPWR VPWR sky130_fd_sc_hd__diode_2
XANTENNA_32 _01543_ VGND VGND VPWR VPWR sky130_fd_sc_hd__diode_2
XANTENNA_21 net125 VGND VGND VPWR VPWR sky130_fd_sc_hd__diode_2
XFILLER_21_865 VPWR VGND VPWR VGND sky130_ef_sc_hd__decap_12
XANTENNA_43 net216 VGND VGND VPWR VPWR sky130_fd_sc_hd__diode_2
X_08245_ _04044_ _04046_ _04047_ VGND VGND VPWR VPWR _04048_ sky130_fd_sc_hd__a21o_1
X_05457_ net25 _01665_ _01856_ VGND VGND VPWR VPWR _02041_ sky130_fd_sc_hd__a21o_1
X_08176_ _03710_ _03711_ decoded_imm_j\[20\] VGND VGND VPWR VPWR _03984_ sky130_fd_sc_hd__o21a_1
XFILLER_119_753 VPWR VGND VPWR VGND sky130_ef_sc_hd__decap_12
X_05388_ _01674_ _01976_ _01977_ net188 cpu_state\[4\] VGND VGND VPWR VPWR _01978_
+ sky130_fd_sc_hd__a32o_1
XFILLER_119_797 VPWR VGND VPWR VGND sky130_ef_sc_hd__decap_12
X_07127_ cpuregs\[28\]\[30\] cpuregs\[29\]\[30\] cpuregs\[30\]\[30\] cpuregs\[31\]\[30\]
+ net265 net260 VGND VGND VPWR VPWR _03535_ sky130_fd_sc_hd__mux4_1
XFILLER_21_69 VPWR VGND VPWR VGND sky130_ef_sc_hd__decap_12
XFILLER_137_69 VPWR VGND VPWR VGND sky130_ef_sc_hd__decap_12
XFILLER_118_285 VPWR VGND VPWR VGND sky130_ef_sc_hd__decap_12
X_07058_ _00014_ _03463_ _00016_ VGND VGND VPWR VPWR _03469_ sky130_fd_sc_hd__o21a_1
XPHY_EDGE_ROW_120_Left_274 VGND VGND VPWR VPWR sky130_fd_sc_hd__decap_3
Xoutput150 net150 VGND VGND VPWR VPWR mem_wdata[23] sky130_fd_sc_hd__buf_2
Xoutput161 net161 VGND VGND VPWR VPWR mem_wdata[4] sky130_fd_sc_hd__buf_2
Xoutput183 net183 VGND VGND VPWR VPWR pcpi_rs1[20] sky130_fd_sc_hd__buf_2
Xoutput194 net194 VGND VGND VPWR VPWR pcpi_rs1[30] sky130_fd_sc_hd__buf_2
X_06009_ reg_out\[27\] reg_next_pc\[27\] net596 VGND VGND VPWR VPWR _02508_ sky130_fd_sc_hd__mux2_1
XFILLER_121_428 VGND VGND VPWR VPWR sky130_fd_sc_hd__decap_3
XFILLER_114_480 VGND VGND VPWR VPWR sky130_fd_sc_hd__fill_2
XFILLER_88_821 VGND VGND VPWR VPWR sky130_fd_sc_hd__fill_2
Xoutput172 net172 VGND VGND VPWR VPWR pcpi_rs1[10] sky130_fd_sc_hd__buf_2
XFILLER_153_57 VPWR VGND VPWR VGND sky130_ef_sc_hd__decap_12
XFILLER_87_342 VGND VGND VPWR VPWR sky130_fd_sc_hd__decap_6
XFILLER_0_769 VGND VGND VPWR VPWR sky130_fd_sc_hd__decap_4
XFILLER_75_559 VGND VGND VPWR VPWR sky130_fd_sc_hd__fill_1
XFILLER_28_442 VPWR VGND VPWR VGND sky130_ef_sc_hd__decap_12
XFILLER_46_11 VPWR VGND VPWR VGND sky130_ef_sc_hd__decap_12
XTAP_TAPCELL_ROW_48_1102 VGND VPWR sky130_fd_sc_hd__tapvpwrvgnd_1
X_10971_ clknet_leaf_124_clk _01033_ VGND VGND VPWR VPWR cpuregs\[18\]\[3\] sky130_fd_sc_hd__dfxtp_1
XTAP_TAPCELL_ROW_39_960 VGND VPWR sky130_fd_sc_hd__tapvpwrvgnd_1
XFILLER_46_77 VGND VGND VPWR VPWR sky130_fd_sc_hd__decap_6
XFILLER_15_125 VPWR VGND VPWR VGND sky130_ef_sc_hd__decap_12
XFILLER_43_423 VGND VGND VPWR VPWR sky130_fd_sc_hd__decap_8
XFILLER_70_253 VGND VGND VPWR VPWR sky130_fd_sc_hd__fill_1
XFILLER_71_798 VGND VGND VPWR VPWR sky130_fd_sc_hd__decap_3
XTAP_TAPCELL_ROW_61_1313 VGND VPWR sky130_fd_sc_hd__tapvpwrvgnd_1
XTAP_TAPCELL_ROW_61_1302 VGND VPWR sky130_fd_sc_hd__tapvpwrvgnd_1
XFILLER_24_681 VPWR VGND VPWR VGND sky130_ef_sc_hd__decap_12
XTAP_TAPCELL_ROW_139_2549 VGND VPWR sky130_fd_sc_hd__tapvpwrvgnd_1
XFILLER_62_76 VGND VGND VPWR VPWR sky130_fd_sc_hd__decap_8
XFILLER_62_65 VGND VGND VPWR VPWR sky130_fd_sc_hd__fill_2
XFILLER_11_364 VGND VGND VPWR VPWR sky130_fd_sc_hd__fill_1
XFILLER_8_825 VPWR VGND VPWR VGND sky130_ef_sc_hd__decap_12
XFILLER_7_27 VPWR VGND VPWR VGND sky130_ef_sc_hd__decap_12
X_11454_ clknet_leaf_77_clk _01498_ VGND VGND VPWR VPWR cpuregs\[0\]\[20\] sky130_fd_sc_hd__dfxtp_1
XFILLER_8_869 VPWR VGND VPWR VGND sky130_ef_sc_hd__decap_12
XFILLER_7_335 VGND VGND VPWR VPWR sky130_fd_sc_hd__fill_1
Xwire244 _04799_ VGND VGND VPWR VPWR net244 sky130_fd_sc_hd__buf_12
X_10405_ clknet_leaf_76_clk _00535_ VGND VGND VPWR VPWR cpuregs\[20\]\[19\] sky130_fd_sc_hd__dfxtp_1
XFILLER_125_723 VGND VGND VPWR VPWR sky130_fd_sc_hd__decap_4
X_11385_ clknet_leaf_15_clk _01429_ VGND VGND VPWR VPWR cpuregs\[7\]\[15\] sky130_fd_sc_hd__dfxtp_1
XTAP_TAPCELL_ROW_59_1275 VGND VPWR sky130_fd_sc_hd__tapvpwrvgnd_1
X_10336_ clknet_leaf_27_clk _00466_ VGND VGND VPWR VPWR cpuregs\[16\]\[14\] sky130_fd_sc_hd__dfxtp_1
XFILLER_3_541 VPWR VGND VPWR VGND sky130_ef_sc_hd__decap_12
XFILLER_152_586 VGND VGND VPWR VPWR sky130_fd_sc_hd__fill_2
XFILLER_124_299 VGND VGND VPWR VPWR sky130_fd_sc_hd__decap_8
Xclkbuf_4_9_0_clk clknet_0_clk VGND VGND VPWR VPWR clknet_4_9_0_clk sky130_fd_sc_hd__clkbuf_8
XFILLER_3_585 VPWR VGND VPWR VGND sky130_ef_sc_hd__decap_12
X_10267_ clknet_leaf_0_clk _00397_ VGND VGND VPWR VPWR cpuregs\[15\]\[9\] sky130_fd_sc_hd__dfxtp_1
XFILLER_79_876 VGND VGND VPWR VPWR sky130_fd_sc_hd__decap_6
XTAP_TAPCELL_ROW_72_1486 VGND VPWR sky130_fd_sc_hd__tapvpwrvgnd_1
XFILLER_39_718 VGND VGND VPWR VPWR sky130_fd_sc_hd__fill_1
XFILLER_94_813 VGND VGND VPWR VPWR sky130_fd_sc_hd__fill_2
XFILLER_66_537 VGND VGND VPWR VPWR sky130_fd_sc_hd__decap_8
XFILLER_39_729 VGND VGND VPWR VPWR sky130_fd_sc_hd__decap_3
X_10198_ clknet_leaf_136_clk _00328_ VGND VGND VPWR VPWR cpuregs\[14\]\[4\] sky130_fd_sc_hd__dfxtp_1
XFILLER_81_529 VPWR VGND VPWR VGND sky130_ef_sc_hd__decap_12
XFILLER_19_475 VPWR VGND VPWR VGND sky130_ef_sc_hd__decap_12
XTAP_TAPCELL_ROW_37_919 VGND VPWR sky130_fd_sc_hd__tapvpwrvgnd_1
XFILLER_74_570 VGND VGND VPWR VPWR sky130_fd_sc_hd__fill_1
XTAP_TAPCELL_ROW_17_610 VGND VPWR sky130_fd_sc_hd__tapvpwrvgnd_1
XFILLER_46_294 VPWR VGND VPWR VGND sky130_ef_sc_hd__decap_12
XFILLER_99_3 VGND VGND VPWR VPWR sky130_fd_sc_hd__fill_2
XFILLER_21_106 VGND VGND VPWR VPWR sky130_fd_sc_hd__decap_6
X_06360_ _02793_ _02794_ _02795_ VGND VGND VPWR VPWR _02796_ sky130_fd_sc_hd__a21o_1
XFILLER_148_837 VPWR VGND VPWR VGND sky130_ef_sc_hd__decap_12
X_05311_ cpu_state\[3\] _01901_ _01905_ _01906_ VGND VGND VPWR VPWR _04888_ sky130_fd_sc_hd__a211o_1
X_06291_ cpuregs\[8\]\[0\] cpuregs\[9\]\[0\] cpuregs\[10\]\[0\] cpuregs\[11\]\[0\]
+ net264 net262 VGND VGND VPWR VPWR _02729_ sky130_fd_sc_hd__mux4_1
X_08030_ _03844_ _03849_ VGND VGND VPWR VPWR _03850_ sky130_fd_sc_hd__or2_1
X_05242_ _01840_ _01841_ _01842_ VGND VGND VPWR VPWR _01843_ sky130_fd_sc_hd__a21o_1
Xinput30 mem_rdata[7] VGND VGND VPWR VPWR net30 sky130_fd_sc_hd__buf_1
XFILLER_116_701 VGND VGND VPWR VPWR sky130_fd_sc_hd__decap_8
XFILLER_115_211 VPWR VGND VPWR VGND sky130_ef_sc_hd__decap_12
XTAP_TAPCELL_ROW_92_1807 VGND VPWR sky130_fd_sc_hd__tapvpwrvgnd_1
X_05173_ reg_pc\[9\] decoded_imm\[9\] VGND VGND VPWR VPWR _01779_ sky130_fd_sc_hd__nand2_1
XFILLER_107_28 VPWR VGND VPWR VGND sky130_ef_sc_hd__decap_12
X_09981_ clknet_leaf_147_clk _00111_ VGND VGND VPWR VPWR cpuregs\[12\]\[11\] sky130_fd_sc_hd__dfxtp_1
XFILLER_143_586 VGND VGND VPWR VPWR sky130_fd_sc_hd__decap_3
XFILLER_115_299 VGND VGND VPWR VPWR sky130_fd_sc_hd__fill_1
X_08932_ decoded_imm\[24\] _01654_ _01586_ VGND VGND VPWR VPWR _04610_ sky130_fd_sc_hd__a21o_1
X_08863_ net270 _04543_ VGND VGND VPWR VPWR _04544_ sky130_fd_sc_hd__or2_1
XFILLER_69_364 VPWR VGND VPWR VGND sky130_ef_sc_hd__decap_12
XFILLER_123_27 VPWR VGND VPWR VGND sky130_ef_sc_hd__decap_12
X_07814_ count_instr\[60\] _03679_ _01549_ VGND VGND VPWR VPWR _03681_ sky130_fd_sc_hd__a21oi_1
XFILLER_96_194 VGND VGND VPWR VPWR sky130_fd_sc_hd__fill_2
X_08794_ cpuregs\[24\]\[17\] cpuregs\[25\]\[17\] cpuregs\[26\]\[17\] cpuregs\[27\]\[17\]
+ net277 net272 VGND VGND VPWR VPWR _04479_ sky130_fd_sc_hd__mux4_1
XFILLER_57_559 VGND VGND VPWR VPWR sky130_fd_sc_hd__fill_1
XFILLER_57_537 VGND VGND VPWR VPWR sky130_fd_sc_hd__decap_6
XTAP_TAPCELL_ROW_123_2306 VGND VPWR sky130_fd_sc_hd__tapvpwrvgnd_1
X_04957_ instr_rdinstrh instr_rdcycleh instr_rdinstr VGND VGND VPWR VPWR _01588_ sky130_fd_sc_hd__or3_4
X_07745_ count_instr\[34\] count_instr\[33\] _03634_ VGND VGND VPWR VPWR _03638_ sky130_fd_sc_hd__and3_1
XFILLER_38_773 VGND VGND VPWR VPWR sky130_fd_sc_hd__fill_1
XFILLER_53_732 VGND VGND VPWR VPWR sky130_fd_sc_hd__fill_1
XFILLER_37_261 VGND VGND VPWR VPWR sky130_fd_sc_hd__fill_1
X_09415_ _02662_ cpuregs\[18\]\[19\] _04862_ VGND VGND VPWR VPWR _01049_ sky130_fd_sc_hd__mux2_1
X_07676_ count_instr\[9\] count_instr\[8\] net410 VGND VGND VPWR VPWR _03594_ sky130_fd_sc_hd__and3_1
XFILLER_52_253 VGND VGND VPWR VPWR sky130_fd_sc_hd__decap_8
XFILLER_41_905 VGND VGND VPWR VPWR sky130_fd_sc_hd__decap_3
X_06627_ _00015_ _03050_ _03053_ _02735_ VGND VGND VPWR VPWR _03054_ sky130_fd_sc_hd__o211a_2
XTAP_TAPCELL_ROW_101_1947 VGND VPWR sky130_fd_sc_hd__tapvpwrvgnd_1
X_09346_ mem_rdata_q\[22\] _01589_ VGND VGND VPWR VPWR _04835_ sky130_fd_sc_hd__and2_1
X_06558_ _01622_ _02979_ _02980_ _02982_ _02986_ VGND VGND VPWR VPWR _02987_ sky130_fd_sc_hd__a41o_1
XFILLER_52_297 VGND VGND VPWR VPWR sky130_fd_sc_hd__decap_8
XFILLER_12_139 VGND VGND VPWR VPWR sky130_fd_sc_hd__fill_1
XTAP_TAPCELL_ROW_43_1021 VGND VPWR sky130_fd_sc_hd__tapvpwrvgnd_1
XFILLER_138_325 VGND VGND VPWR VPWR sky130_fd_sc_hd__decap_4
XFILLER_138_303 VGND VGND VPWR VPWR sky130_fd_sc_hd__decap_4
X_05509_ _02090_ _02091_ VGND VGND VPWR VPWR _02092_ sky130_fd_sc_hd__nor2_1
X_09277_ net164 net126 _04206_ VGND VGND VPWR VPWR _00963_ sky130_fd_sc_hd__mux2_1
X_06489_ _00015_ _02917_ _02920_ _02735_ VGND VGND VPWR VPWR _02921_ sky130_fd_sc_hd__o211a_1
X_08228_ _04012_ _04013_ _04020_ _04031_ VGND VGND VPWR VPWR _04032_ sky130_fd_sc_hd__a31o_1
XFILLER_32_79 VGND VGND VPWR VPWR sky130_fd_sc_hd__decap_4
XFILLER_153_317 VGND VGND VPWR VPWR sky130_fd_sc_hd__fill_1
XTAP_TAPCELL_ROW_134_2468 VGND VPWR sky130_fd_sc_hd__tapvpwrvgnd_1
XFILLER_119_561 VPWR VGND VPWR VGND sky130_ef_sc_hd__decap_12
XFILLER_5_839 VGND VGND VPWR VPWR sky130_fd_sc_hd__fill_1
XTAP_TAPCELL_ROW_134_2479 VGND VPWR sky130_fd_sc_hd__tapvpwrvgnd_1
XFILLER_134_542 VGND VGND VPWR VPWR sky130_fd_sc_hd__fill_2
X_08159_ _03967_ _03968_ _03966_ VGND VGND VPWR VPWR _03969_ sky130_fd_sc_hd__o21ai_1
XFILLER_119_594 VPWR VGND VPWR VGND sky130_ef_sc_hd__decap_12
X_11170_ clknet_leaf_36_clk _01217_ VGND VGND VPWR VPWR cpuregs\[23\]\[27\] sky130_fd_sc_hd__dfxtp_1
XFILLER_107_778 VGND VGND VPWR VPWR sky130_fd_sc_hd__decap_6
XFILLER_107_767 VGND VGND VPWR VPWR sky130_fd_sc_hd__decap_4
X_10121_ clknet_leaf_51_clk _00251_ VGND VGND VPWR VPWR cpuregs\[28\]\[23\] sky130_fd_sc_hd__dfxtp_1
XFILLER_121_225 VGND VGND VPWR VPWR sky130_fd_sc_hd__decap_4
X_10052_ clknet_leaf_54_clk _00182_ VGND VGND VPWR VPWR cpuregs\[13\]\[18\] sky130_fd_sc_hd__dfxtp_1
XFILLER_102_472 VGND VGND VPWR VPWR sky130_fd_sc_hd__decap_4
XFILLER_88_684 VGND VGND VPWR VPWR sky130_fd_sc_hd__decap_3
XFILLER_76_835 VPWR VGND VPWR VGND sky130_ef_sc_hd__decap_12
XFILLER_57_43 VPWR VGND VPWR VGND sky130_ef_sc_hd__decap_12
XTAP_TAPCELL_ROW_54_1194 VGND VPWR sky130_fd_sc_hd__tapvpwrvgnd_1
XFILLER_87_194 VGND VGND VPWR VPWR sky130_fd_sc_hd__fill_1
XTAP_TAPCELL_ROW_3_382 VGND VPWR sky130_fd_sc_hd__tapvpwrvgnd_1
XFILLER_90_359 VGND VGND VPWR VPWR sky130_fd_sc_hd__decap_4
X_10954_ clknet_leaf_93_clk _01016_ VGND VGND VPWR VPWR decoded_imm\[14\] sky130_fd_sc_hd__dfxtp_2
XFILLER_44_776 VGND VGND VPWR VPWR sky130_fd_sc_hd__fill_1
X_10885_ clknet_leaf_36_clk _00947_ VGND VGND VPWR VPWR cpuregs\[1\]\[29\] sky130_fd_sc_hd__dfxtp_1
XFILLER_43_275 VGND VGND VPWR VPWR sky130_fd_sc_hd__decap_4
XTAP_TAPCELL_ROW_42_999 VGND VPWR sky130_fd_sc_hd__tapvpwrvgnd_1
XFILLER_8_633 VGND VGND VPWR VPWR sky130_fd_sc_hd__fill_2
XFILLER_138_881 VPWR VGND VPWR VGND sky130_ef_sc_hd__decap_12
XTAP_TAPCELL_ROW_22_690 VGND VPWR sky130_fd_sc_hd__tapvpwrvgnd_1
X_11437_ clknet_leaf_123_clk _01481_ VGND VGND VPWR VPWR cpuregs\[0\]\[3\] sky130_fd_sc_hd__dfxtp_1
X_11368_ clknet_leaf_29_clk _01412_ VGND VGND VPWR VPWR cpuregs\[6\]\[30\] sky130_fd_sc_hd__dfxtp_1
XTAP_TAPCELL_ROW_74_1515 VGND VPWR sky130_fd_sc_hd__tapvpwrvgnd_1
XFILLER_4_861 VGND VGND VPWR VPWR sky130_fd_sc_hd__decap_6
XFILLER_153_895 VGND VGND VPWR VPWR sky130_fd_sc_hd__fill_1
X_10319_ clknet_leaf_34_clk _00449_ VGND VGND VPWR VPWR cpuregs\[26\]\[29\] sky130_fd_sc_hd__dfxtp_1
X_11299_ clknet_leaf_41_clk _01346_ VGND VGND VPWR VPWR cpuregs\[4\]\[28\] sky130_fd_sc_hd__dfxtp_1
XFILLER_3_393 VPWR VGND VPWR VGND sky130_ef_sc_hd__decap_12
XFILLER_140_589 VPWR VGND VPWR VGND sky130_ef_sc_hd__decap_12
XFILLER_140_578 VGND VGND VPWR VPWR sky130_fd_sc_hd__decap_8
XFILLER_100_409 VGND VGND VPWR VPWR sky130_fd_sc_hd__decap_3
XFILLER_85_109 VGND VGND VPWR VPWR sky130_fd_sc_hd__decap_3
XFILLER_79_695 VGND VGND VPWR VPWR sky130_fd_sc_hd__decap_4
XFILLER_79_673 VPWR VGND VPWR VGND sky130_ef_sc_hd__decap_12
X_05860_ _02085_ _02088_ _02362_ _02415_ _02418_ VGND VGND VPWR VPWR _02419_ sky130_fd_sc_hd__a41o_1
XFILLER_94_643 VGND VGND VPWR VPWR sky130_fd_sc_hd__fill_1
XFILLER_14_3 VPWR VGND VPWR VGND sky130_ef_sc_hd__decap_12
XTAP_TAPCELL_ROW_105_2014 VGND VPWR sky130_fd_sc_hd__tapvpwrvgnd_1
X_05791_ _01563_ net210 _02356_ instr_sub VGND VGND VPWR VPWR _02357_ sky130_fd_sc_hd__o211a_1
X_07530_ _02641_ cpuregs\[16\]\[14\] _03570_ VGND VGND VPWR VPWR _00466_ sky130_fd_sc_hd__mux2_1
XFILLER_81_337 VGND VGND VPWR VPWR sky130_fd_sc_hd__decap_8
XFILLER_90_882 VGND VGND VPWR VPWR sky130_fd_sc_hd__fill_1
XTAP_TAPCELL_ROW_85_1699 VGND VPWR sky130_fd_sc_hd__tapvpwrvgnd_1
XTAP_TAPCELL_ROW_85_1688 VGND VPWR sky130_fd_sc_hd__tapvpwrvgnd_1
X_07461_ cpuregs\[15\]\[12\] _02633_ net246 VGND VGND VPWR VPWR _00400_ sky130_fd_sc_hd__mux2_1
XFILLER_62_573 VPWR VGND VPWR VGND sky130_ef_sc_hd__decap_12
XFILLER_34_253 VPWR VGND VPWR VGND sky130_ef_sc_hd__decap_12
XFILLER_50_757 VGND VGND VPWR VPWR sky130_fd_sc_hd__decap_4
XFILLER_50_746 VGND VGND VPWR VPWR sky130_fd_sc_hd__fill_2
X_07392_ cpuregs\[14\]\[10\] _02624_ net247 VGND VGND VPWR VPWR _00334_ sky130_fd_sc_hd__mux2_1
X_06412_ cpuregs\[8\]\[4\] cpuregs\[9\]\[4\] cpuregs\[10\]\[4\] cpuregs\[11\]\[4\]
+ net264 net259 VGND VGND VPWR VPWR _02846_ sky130_fd_sc_hd__mux4_1
X_09200_ decoded_rd\[2\] _01103_ _02513_ VGND VGND VPWR VPWR _00900_ sky130_fd_sc_hd__mux2_1
XFILLER_147_111 VGND VGND VPWR VPWR sky130_fd_sc_hd__fill_1
X_09131_ instr_sltiu _04748_ _04765_ _04766_ VGND VGND VPWR VPWR _00863_ sky130_fd_sc_hd__a22o_1
X_06343_ _02777_ _02778_ _01579_ VGND VGND VPWR VPWR _02779_ sky130_fd_sc_hd__mux2_1
XFILLER_148_645 VGND VGND VPWR VPWR sky130_fd_sc_hd__decap_8
Xrebuffer207 net592 VGND VGND VPWR VPWR net593 sky130_fd_sc_hd__dlymetal6s2s_1
X_09062_ instr_rdcycle _01552_ _01588_ _04218_ cpu_state\[1\] VGND VGND VPWR VPWR
+ _04732_ sky130_fd_sc_hd__o32a_1
XTAP_TAPCELL_ROW_20_649 VGND VPWR sky130_fd_sc_hd__tapvpwrvgnd_1
Xrebuffer218 net602 VGND VGND VPWR VPWR net604 sky130_fd_sc_hd__dlygate4sd1_1
X_06274_ _02712_ cpuregs\[11\]\[31\] _02582_ VGND VGND VPWR VPWR _00068_ sky130_fd_sc_hd__mux2_1
XFILLER_135_328 VGND VGND VPWR VPWR sky130_fd_sc_hd__decap_8
XFILLER_118_27 VGND VGND VPWR VPWR sky130_fd_sc_hd__fill_1
XTAP_TAPCELL_ROW_116_2187 VGND VPWR sky130_fd_sc_hd__tapvpwrvgnd_1
X_08013_ _03825_ _03699_ VGND VGND VPWR VPWR _03834_ sky130_fd_sc_hd__and2b_1
X_05225_ cpu_state\[4\] net174 _01822_ _01824_ _01827_ VGND VGND VPWR VPWR _04881_
+ sky130_fd_sc_hd__a2111o_1
XFILLER_150_309 VPWR VGND VPWR VGND sky130_ef_sc_hd__decap_12
X_05156_ cpu_state\[4\] net200 _01760_ cpu_state\[6\] _01763_ VGND VGND VPWR VPWR
+ _01764_ sky130_fd_sc_hd__a221o_1
XFILLER_103_214 VGND VGND VPWR VPWR sky130_fd_sc_hd__decap_8
XFILLER_134_15 VPWR VGND VPWR VGND sky130_ef_sc_hd__decap_12
X_09964_ clknet_4_12_0_clk _00094_ VGND VGND VPWR VPWR net188 sky130_fd_sc_hd__dfxtp_4
XFILLER_103_258 VGND VGND VPWR VPWR sky130_fd_sc_hd__fill_1
X_05087_ count_instr\[2\] instr_rdinstr net257 _01699_ VGND VGND VPWR VPWR _01700_
+ sky130_fd_sc_hd__a211o_1
X_09895_ cpuregs\[0\]\[25\] VGND VGND VPWR VPWR _01503_ sky130_fd_sc_hd__clkbuf_1
X_08915_ cpuregs\[20\]\[24\] cpuregs\[21\]\[24\] cpuregs\[22\]\[24\] cpuregs\[23\]\[24\]
+ net280 net274 VGND VGND VPWR VPWR _04593_ sky130_fd_sc_hd__mux4_1
X_08846_ cpuregs\[24\]\[20\] cpuregs\[25\]\[20\] cpuregs\[26\]\[20\] cpuregs\[27\]\[20\]
+ _00007_ net274 VGND VGND VPWR VPWR _04528_ sky130_fd_sc_hd__mux4_1
XFILLER_72_304 VGND VGND VPWR VPWR sky130_fd_sc_hd__decap_4
X_05989_ reg_out\[17\] reg_next_pc\[17\] net596 VGND VGND VPWR VPWR _02498_ sky130_fd_sc_hd__mux2_1
X_08777_ net270 _04462_ VGND VGND VPWR VPWR _04463_ sky130_fd_sc_hd__or2_1
XFILLER_84_175 VGND VGND VPWR VPWR sky130_fd_sc_hd__fill_2
XFILLER_73_838 VGND VGND VPWR VPWR sky130_fd_sc_hd__fill_2
XTAP_TAPCELL_ROW_0_330 VGND VPWR sky130_fd_sc_hd__tapvpwrvgnd_1
XFILLER_27_57 VGND VGND VPWR VPWR sky130_fd_sc_hd__decap_8
X_07728_ count_instr\[27\] _03624_ count_instr\[28\] VGND VGND VPWR VPWR _03627_ sky130_fd_sc_hd__a21o_1
XFILLER_53_551 VGND VGND VPWR VPWR sky130_fd_sc_hd__decap_8
XFILLER_14_905 VGND VGND VPWR VPWR sky130_fd_sc_hd__decap_4
XFILLER_53_584 VPWR VGND VPWR VGND sky130_ef_sc_hd__decap_12
X_07659_ count_instr\[3\] count_instr\[2\] _03579_ VGND VGND VPWR VPWR _03583_ sky130_fd_sc_hd__and3_1
X_10670_ clknet_leaf_66_clk _04898_ VGND VGND VPWR VPWR reg_out\[28\] sky130_fd_sc_hd__dfxtp_1
XFILLER_9_408 VGND VGND VPWR VPWR sky130_fd_sc_hd__fill_1
XTAP_TAPCELL_ROW_136_2508 VGND VPWR sky130_fd_sc_hd__tapvpwrvgnd_1
X_09329_ mem_rdata_q\[31\] _01589_ _04746_ _04825_ _04826_ VGND VGND VPWR VPWR _00999_
+ sky130_fd_sc_hd__a32o_1
XTAP_TAPCELL_ROW_153_2800 VGND VPWR sky130_fd_sc_hd__tapvpwrvgnd_1
XFILLER_21_470 VGND VGND VPWR VPWR sky130_fd_sc_hd__fill_2
XFILLER_21_481 VPWR VGND VPWR VGND sky130_ef_sc_hd__decap_12
XFILLER_153_125 VPWR VGND VPWR VGND sky130_ef_sc_hd__decap_12
XFILLER_138_188 VGND VGND VPWR VPWR sky130_fd_sc_hd__decap_8
XFILLER_153_169 VPWR VGND VPWR VGND sky130_ef_sc_hd__decap_12
X_11222_ clknet_leaf_25_clk _01269_ VGND VGND VPWR VPWR cpuregs\[3\]\[15\] sky130_fd_sc_hd__dfxtp_1
XTAP_TAPCELL_ROW_56_1223 VGND VPWR sky130_fd_sc_hd__tapvpwrvgnd_1
XFILLER_135_895 VGND VGND VPWR VPWR sky130_fd_sc_hd__fill_1
XTAP_TAPCELL_ROW_56_1234 VGND VPWR sky130_fd_sc_hd__tapvpwrvgnd_1
XFILLER_134_394 VGND VGND VPWR VPWR sky130_fd_sc_hd__fill_1
X_11153_ clknet_leaf_12_clk _01200_ VGND VGND VPWR VPWR cpuregs\[23\]\[10\] sky130_fd_sc_hd__dfxtp_1
XTAP_TAPCELL_ROW_8_463 VGND VPWR sky130_fd_sc_hd__tapvpwrvgnd_1
XTAP_TAPCELL_ROW_8_452 VGND VPWR sky130_fd_sc_hd__tapvpwrvgnd_1
XFILLER_1_853 VPWR VGND VPWR VGND sky130_ef_sc_hd__decap_12
X_11084_ clknet_leaf_16_clk _01141_ VGND VGND VPWR VPWR cpuregs\[24\]\[15\] sky130_fd_sc_hd__dfxtp_1
XFILLER_1_897 VGND VGND VPWR VPWR sky130_fd_sc_hd__decap_8
X_10104_ clknet_leaf_1_clk _00234_ VGND VGND VPWR VPWR cpuregs\[28\]\[6\] sky130_fd_sc_hd__dfxtp_1
XFILLER_49_835 VGND VGND VPWR VPWR sky130_fd_sc_hd__decap_4
XFILLER_0_385 VGND VGND VPWR VPWR sky130_fd_sc_hd__decap_3
X_10035_ clknet_leaf_112_clk _00165_ VGND VGND VPWR VPWR cpuregs\[13\]\[1\] sky130_fd_sc_hd__dfxtp_1
XFILLER_84_41 VGND VGND VPWR VPWR sky130_fd_sc_hd__decap_6
XFILLER_76_676 VPWR VGND VPWR VGND sky130_ef_sc_hd__decap_12
XFILLER_63_337 VGND VGND VPWR VPWR sky130_fd_sc_hd__decap_6
XFILLER_84_85 VGND VGND VPWR VPWR sky130_fd_sc_hd__decap_4
XFILLER_63_359 VGND VGND VPWR VPWR sky130_fd_sc_hd__decap_8
XFILLER_17_765 VGND VGND VPWR VPWR sky130_fd_sc_hd__fill_1
X_10937_ clknet_leaf_94_clk _00999_ VGND VGND VPWR VPWR decoded_imm\[31\] sky130_fd_sc_hd__dfxtp_1
XTAP_TAPCELL_ROW_27_760 VGND VPWR sky130_fd_sc_hd__tapvpwrvgnd_1
XTAP_TAPCELL_ROW_27_771 VGND VPWR sky130_fd_sc_hd__tapvpwrvgnd_1
XFILLER_31_201 VGND VGND VPWR VPWR sky130_fd_sc_hd__fill_1
XTAP_TAPCELL_ROW_67_1396 VGND VPWR sky130_fd_sc_hd__tapvpwrvgnd_1
X_10868_ clknet_leaf_6_clk _00930_ VGND VGND VPWR VPWR cpuregs\[1\]\[12\] sky130_fd_sc_hd__dfxtp_1
XFILLER_129_122 VPWR VGND VPWR VGND sky130_ef_sc_hd__decap_12
X_10799_ clknet_leaf_97_clk _00864_ VGND VGND VPWR VPWR instr_xori sky130_fd_sc_hd__dfxtp_1
XFILLER_145_626 VGND VGND VPWR VPWR sky130_fd_sc_hd__decap_3
XFILLER_145_615 VGND VGND VPWR VPWR sky130_fd_sc_hd__fill_1
XFILLER_145_659 VGND VGND VPWR VPWR sky130_fd_sc_hd__decap_4
XFILLER_132_309 VGND VGND VPWR VPWR sky130_fd_sc_hd__decap_4
X_05010_ _01621_ _01633_ VGND VGND VPWR VPWR _01634_ sky130_fd_sc_hd__or2_1
XFILLER_141_821 VPWR VGND VPWR VGND sky130_ef_sc_hd__decap_12
XFILLER_113_523 VGND VGND VPWR VPWR sky130_fd_sc_hd__decap_8
XFILLER_141_865 VPWR VGND VPWR VGND sky130_ef_sc_hd__decap_12
XFILLER_99_757 VGND VGND VPWR VPWR sky130_fd_sc_hd__decap_4
XFILLER_98_245 VGND VGND VPWR VPWR sky130_fd_sc_hd__decap_6
X_06961_ _03370_ _03372_ _03373_ _03374_ VGND VGND VPWR VPWR _03375_ sky130_fd_sc_hd__nand4_1
XFILLER_67_610 VGND VGND VPWR VPWR sky130_fd_sc_hd__decap_6
X_09680_ cpuregs\[4\]\[19\] _02662_ _04871_ VGND VGND VPWR VPWR _01337_ sky130_fd_sc_hd__mux2_1
XFILLER_100_239 VPWR VGND VPWR VGND sky130_ef_sc_hd__decap_12
X_05912_ _02068_ _02238_ _02240_ _02070_ _02464_ VGND VGND VPWR VPWR _02465_ sky130_fd_sc_hd__a221o_1
XFILLER_79_481 VPWR VGND VPWR VGND sky130_ef_sc_hd__decap_12
X_08700_ cpuregs\[24\]\[12\] cpuregs\[25\]\[12\] cpuregs\[26\]\[12\] cpuregs\[27\]\[12\]
+ net277 net271 VGND VGND VPWR VPWR _04390_ sky130_fd_sc_hd__mux4_1
X_06892_ cpuregs\[8\]\[21\] cpuregs\[9\]\[21\] cpuregs\[10\]\[21\] cpuregs\[11\]\[21\]
+ net267 _00013_ VGND VGND VPWR VPWR _03309_ sky130_fd_sc_hd__mux4_1
XFILLER_104_29 VPWR VGND VPWR VGND sky130_ef_sc_hd__decap_12
XTAP_TAPCELL_ROW_87_1728 VGND VPWR sky130_fd_sc_hd__tapvpwrvgnd_1
XTAP_TAPCELL_ROW_87_1717 VGND VPWR sky130_fd_sc_hd__tapvpwrvgnd_1
X_08631_ _01558_ _04324_ VGND VGND VPWR VPWR _04325_ sky130_fd_sc_hd__or2_1
X_05843_ _02086_ _02238_ _02240_ _02088_ _02403_ VGND VGND VPWR VPWR _02404_ sky130_fd_sc_hd__a221o_1
XFILLER_82_613 VGND VGND VPWR VPWR sky130_fd_sc_hd__fill_1
XFILLER_67_698 VGND VGND VPWR VPWR sky130_fd_sc_hd__fill_2
X_05774_ _02341_ _02340_ instr_sub VGND VGND VPWR VPWR _02342_ sky130_fd_sc_hd__mux2_1
XFILLER_54_359 VGND VGND VPWR VPWR sky130_fd_sc_hd__decap_4
X_08562_ _01653_ _02576_ VGND VGND VPWR VPWR _04260_ sky130_fd_sc_hd__nand2_1
X_08493_ net77 net46 _04208_ VGND VGND VPWR VPWR _00791_ sky130_fd_sc_hd__mux2_1
X_07513_ cpuregs\[26\]\[31\] _02712_ _03568_ VGND VGND VPWR VPWR _00451_ sky130_fd_sc_hd__mux2_1
XFILLER_35_551 VGND VGND VPWR VPWR sky130_fd_sc_hd__decap_8
X_07444_ cpuregs\[27\]\[28\] _02699_ _03566_ VGND VGND VPWR VPWR _00384_ sky130_fd_sc_hd__mux2_1
XFILLER_13_15 VPWR VGND VPWR VGND sky130_ef_sc_hd__decap_12
X_07375_ _02691_ cpuregs\[9\]\[26\] _03563_ VGND VGND VPWR VPWR _00318_ sky130_fd_sc_hd__mux2_1
XFILLER_129_15 VPWR VGND VPWR VGND sky130_ef_sc_hd__decap_12
XTAP_TAPCELL_ROW_118_2227 VGND VPWR sky130_fd_sc_hd__tapvpwrvgnd_1
XTAP_TAPCELL_ROW_118_2216 VGND VPWR sky130_fd_sc_hd__tapvpwrvgnd_1
XFILLER_109_829 VGND VGND VPWR VPWR sky130_fd_sc_hd__decap_4
XFILLER_108_317 VGND VGND VPWR VPWR sky130_fd_sc_hd__fill_1
X_09114_ instr_jalr _02514_ _04744_ _04759_ VGND VGND VPWR VPWR _00853_ sky130_fd_sc_hd__a22o_1
X_06326_ reg_pc\[1\] _02751_ _02762_ _02735_ VGND VGND VPWR VPWR _02763_ sky130_fd_sc_hd__a22o_1
X_06257_ _02697_ _02698_ _02584_ VGND VGND VPWR VPWR _02699_ sky130_fd_sc_hd__mux2_8
X_09045_ cpuregs\[28\]\[31\] cpuregs\[29\]\[31\] cpuregs\[30\]\[31\] cpuregs\[31\]\[31\]
+ net276 net272 VGND VGND VPWR VPWR _04716_ sky130_fd_sc_hd__mux4_1
XTAP_TAPCELL_ROW_131_2427 VGND VPWR sky130_fd_sc_hd__tapvpwrvgnd_1
XFILLER_123_309 VGND VGND VPWR VPWR sky130_fd_sc_hd__fill_1
X_05208_ reg_pc\[12\] decoded_imm\[12\] VGND VGND VPWR VPWR _01811_ sky130_fd_sc_hd__nand2_1
XFILLER_104_501 VGND VGND VPWR VPWR sky130_fd_sc_hd__decap_4
X_06188_ reg_pc\[14\] _02636_ reg_pc\[15\] VGND VGND VPWR VPWR _02643_ sky130_fd_sc_hd__a21oi_1
XFILLER_1_105 VGND VGND VPWR VPWR sky130_fd_sc_hd__decap_6
XFILLER_150_139 VGND VGND VPWR VPWR sky130_fd_sc_hd__fill_1
XFILLER_145_69 VPWR VGND VPWR VGND sky130_ef_sc_hd__decap_12
XFILLER_143_191 VPWR VGND VPWR VGND sky130_ef_sc_hd__decap_12
XFILLER_104_545 VGND VGND VPWR VPWR sky130_fd_sc_hd__fill_1
X_05139_ net171 mem_wordsize\[1\] _01747_ VGND VGND VPWR VPWR _01748_ sky130_fd_sc_hd__and3_1
XFILLER_1_149 VPWR VGND VPWR VGND sky130_ef_sc_hd__decap_12
X_09947_ clknet_leaf_133_clk _00077_ VGND VGND VPWR VPWR net201 sky130_fd_sc_hd__dfxtp_4
XFILLER_49_109 VGND VGND VPWR VPWR sky130_fd_sc_hd__decap_3
XTAP_TAPCELL_ROW_5_411 VGND VPWR sky130_fd_sc_hd__tapvpwrvgnd_1
XTAP_TAPCELL_ROW_51_1153 VGND VPWR sky130_fd_sc_hd__tapvpwrvgnd_1
XTAP_TAPCELL_ROW_51_1142 VGND VPWR sky130_fd_sc_hd__tapvpwrvgnd_1
XTAP_TAPCELL_ROW_146_2670 VGND VPWR sky130_fd_sc_hd__tapvpwrvgnd_1
XTAP_TAPCELL_ROW_129_2389 VGND VPWR sky130_fd_sc_hd__tapvpwrvgnd_1
XFILLER_85_440 VGND VGND VPWR VPWR sky130_fd_sc_hd__decap_8
X_09878_ cpuregs\[0\]\[8\] VGND VGND VPWR VPWR _01486_ sky130_fd_sc_hd__clkbuf_1
X_08829_ cpuregs\[24\]\[19\] cpuregs\[25\]\[19\] cpuregs\[26\]\[19\] cpuregs\[27\]\[19\]
+ net280 net274 VGND VGND VPWR VPWR _04512_ sky130_fd_sc_hd__mux4_1
XFILLER_58_698 VGND VGND VPWR VPWR sky130_fd_sc_hd__fill_2
XFILLER_45_315 VGND VGND VPWR VPWR sky130_fd_sc_hd__decap_3
XFILLER_46_827 VGND VGND VPWR VPWR sky130_fd_sc_hd__fill_1
XFILLER_61_808 VGND VGND VPWR VPWR sky130_fd_sc_hd__fill_2
XFILLER_45_337 VPWR VGND VPWR VGND sky130_ef_sc_hd__decap_12
XFILLER_14_713 VGND VGND VPWR VPWR sky130_fd_sc_hd__fill_1
Xclkbuf_leaf_146_clk clknet_4_2_0_clk VGND VGND VPWR VPWR clknet_leaf_146_clk sky130_fd_sc_hd__clkbuf_8
X_10722_ clknet_leaf_18_clk _00819_ VGND VGND VPWR VPWR net207 sky130_fd_sc_hd__dfxtp_2
X_10653_ clknet_leaf_104_clk _04880_ VGND VGND VPWR VPWR reg_out\[11\] sky130_fd_sc_hd__dfxtp_1
XFILLER_13_278 VGND VGND VPWR VPWR sky130_fd_sc_hd__fill_2
X_10584_ clknet_leaf_107_clk _00714_ VGND VGND VPWR VPWR count_cycle\[7\] sky130_fd_sc_hd__dfxtp_1
Xclkload19 clknet_leaf_3_clk VGND VGND VPWR VPWR clkload19/Y sky130_fd_sc_hd__clkinv_2
XFILLER_126_136 VGND VGND VPWR VPWR sky130_fd_sc_hd__decap_4
XFILLER_119_81 VGND VGND VPWR VPWR sky130_fd_sc_hd__decap_3
XFILLER_114_309 VGND VGND VPWR VPWR sky130_fd_sc_hd__decap_3
XFILLER_141_128 VGND VGND VPWR VPWR sky130_fd_sc_hd__decap_3
XFILLER_123_821 VPWR VGND VPWR VGND sky130_ef_sc_hd__decap_12
XFILLER_108_895 VPWR VGND VPWR VGND sky130_ef_sc_hd__decap_12
XFILLER_5_499 VGND VGND VPWR VPWR sky130_fd_sc_hd__decap_4
XFILLER_123_865 VPWR VGND VPWR VGND sky130_ef_sc_hd__decap_12
X_11205_ clknet_leaf_23_clk _01252_ VGND VGND VPWR VPWR cpuregs\[29\]\[30\] sky130_fd_sc_hd__dfxtp_1
X_11136_ clknet_leaf_49_clk _01183_ VGND VGND VPWR VPWR cpuregs\[31\]\[25\] sky130_fd_sc_hd__dfxtp_1
XFILLER_96_716 VGND VGND VPWR VPWR sky130_fd_sc_hd__fill_1
XFILLER_95_204 VGND VGND VPWR VPWR sky130_fd_sc_hd__decap_4
X_11067_ clknet_leaf_94_clk _01124_ VGND VGND VPWR VPWR mem_rdata_q\[30\] sky130_fd_sc_hd__dfxtp_2
XFILLER_0_193 VGND VGND VPWR VPWR sky130_fd_sc_hd__decap_3
X_10018_ clknet_leaf_19_clk _00148_ VGND VGND VPWR VPWR cpuregs\[30\]\[16\] sky130_fd_sc_hd__dfxtp_1
XTAP_TAPCELL_ROW_69_1436 VGND VPWR sky130_fd_sc_hd__tapvpwrvgnd_1
XFILLER_37_838 VGND VGND VPWR VPWR sky130_fd_sc_hd__fill_2
XFILLER_63_167 VGND VGND VPWR VPWR sky130_fd_sc_hd__fill_1
XFILLER_45_871 VPWR VGND VPWR VGND sky130_ef_sc_hd__decap_12
XTAP_TAPCELL_ROW_82_1647 VGND VPWR sky130_fd_sc_hd__tapvpwrvgnd_1
XTAP_TAPCELL_ROW_82_1636 VGND VPWR sky130_fd_sc_hd__tapvpwrvgnd_1
XFILLER_60_841 VGND VGND VPWR VPWR sky130_fd_sc_hd__decap_6
Xclkbuf_leaf_137_clk clknet_4_2_0_clk VGND VGND VPWR VPWR clknet_leaf_137_clk sky130_fd_sc_hd__clkbuf_8
XFILLER_149_217 VGND VGND VPWR VPWR sky130_fd_sc_hd__decap_6
X_05490_ net192 net224 VGND VGND VPWR VPWR _02073_ sky130_fd_sc_hd__nand2_1
XFILLER_20_749 VGND VGND VPWR VPWR sky130_fd_sc_hd__decap_6
X_07160_ cpuregs\[12\]\[14\] _02641_ net253 VGND VGND VPWR VPWR _00114_ sky130_fd_sc_hd__mux2_1
XFILLER_145_434 VPWR VGND VPWR VGND sky130_ef_sc_hd__decap_12
X_07091_ net237 _03485_ _03500_ _03474_ VGND VGND VPWR VPWR _00097_ sky130_fd_sc_hd__a31o_1
XFILLER_9_783 VGND VGND VPWR VPWR sky130_fd_sc_hd__fill_1
X_06111_ latched_rd\[1\] latched_rd\[0\] _02580_ VGND VGND VPWR VPWR _02581_ sky130_fd_sc_hd__nand3_4
X_06042_ _01634_ _02515_ VGND VGND VPWR VPWR _00000_ sky130_fd_sc_hd__nand2_1
XTAP_TAPCELL_ROW_113_2146 VGND VPWR sky130_fd_sc_hd__tapvpwrvgnd_1
XTAP_TAPCELL_ROW_113_2135 VGND VPWR sky130_fd_sc_hd__tapvpwrvgnd_1
XTAP_TAPCELL_ROW_97_1890 VGND VPWR sky130_fd_sc_hd__tapvpwrvgnd_1
XTAP_TAPCELL_ROW_10_490 VGND VPWR sky130_fd_sc_hd__tapvpwrvgnd_1
XFILLER_132_139 VGND VGND VPWR VPWR sky130_fd_sc_hd__fill_1
XFILLER_141_673 VGND VGND VPWR VPWR sky130_fd_sc_hd__decap_8
XFILLER_113_375 VPWR VGND VPWR VGND sky130_ef_sc_hd__decap_12
XFILLER_87_738 VGND VGND VPWR VPWR sky130_fd_sc_hd__decap_4
XFILLER_87_716 VPWR VGND VPWR VGND sky130_ef_sc_hd__decap_12
X_09801_ _02616_ cpuregs\[8\]\[8\] _04875_ VGND VGND VPWR VPWR _01454_ sky130_fd_sc_hd__mux2_1
XFILLER_5_93 VPWR VGND VPWR VGND sky130_ef_sc_hd__decap_12
X_07993_ _03575_ _03814_ _03815_ VGND VGND VPWR VPWR _03816_ sky130_fd_sc_hd__a21oi_1
X_09732_ _02603_ cpuregs\[6\]\[5\] _04873_ VGND VGND VPWR VPWR _01387_ sky130_fd_sc_hd__mux2_1
X_06944_ cpuregs\[0\]\[23\] cpuregs\[1\]\[23\] cpuregs\[2\]\[23\] cpuregs\[3\]\[23\]
+ net267 net260 VGND VGND VPWR VPWR _03359_ sky130_fd_sc_hd__mux4_1
X_06875_ _00015_ _03289_ _03292_ _02735_ VGND VGND VPWR VPWR _03293_ sky130_fd_sc_hd__o211a_1
XFILLER_67_462 VGND VGND VPWR VPWR sky130_fd_sc_hd__decap_3
XFILLER_55_635 VPWR VGND VPWR VGND sky130_ef_sc_hd__decap_12
X_09663_ cpuregs\[4\]\[2\] _02590_ net238 VGND VGND VPWR VPWR _01320_ sky130_fd_sc_hd__mux2_1
XFILLER_28_849 VPWR VGND VPWR VGND sky130_ef_sc_hd__decap_12
XFILLER_131_27 VPWR VGND VPWR VGND sky130_ef_sc_hd__decap_12
X_05826_ _02092_ _02382_ VGND VGND VPWR VPWR _02388_ sky130_fd_sc_hd__nor2_1
XFILLER_82_421 VGND VGND VPWR VPWR sky130_fd_sc_hd__decap_8
X_08614_ _00009_ _04301_ net269 VGND VGND VPWR VPWR _04309_ sky130_fd_sc_hd__o21a_1
X_09594_ _02586_ cpuregs\[3\]\[0\] _04868_ VGND VGND VPWR VPWR _01254_ sky130_fd_sc_hd__mux2_1
XFILLER_27_348 VGND VGND VPWR VPWR sky130_fd_sc_hd__decap_4
XFILLER_70_605 VGND VGND VPWR VPWR sky130_fd_sc_hd__fill_1
X_08545_ cpuregs\[20\]\[1\] cpuregs\[21\]\[1\] cpuregs\[22\]\[1\] cpuregs\[23\]\[1\]
+ _00007_ _00008_ VGND VGND VPWR VPWR _04246_ sky130_fd_sc_hd__mux4_1
X_05757_ _02155_ _02317_ VGND VGND VPWR VPWR _02327_ sky130_fd_sc_hd__and2b_1
XFILLER_51_841 VPWR VGND VPWR VGND sky130_ef_sc_hd__decap_12
XFILLER_35_370 VPWR VGND VPWR VGND sky130_ef_sc_hd__decap_12
XFILLER_36_893 VGND VGND VPWR VPWR sky130_fd_sc_hd__decap_8
Xclkbuf_leaf_128_clk clknet_4_8_0_clk VGND VGND VPWR VPWR clknet_leaf_128_clk sky130_fd_sc_hd__clkbuf_8
XFILLER_51_874 VGND VGND VPWR VPWR sky130_fd_sc_hd__fill_2
X_08476_ net90 net59 _04208_ VGND VGND VPWR VPWR _00774_ sky130_fd_sc_hd__mux2_1
X_05688_ _02139_ _02239_ VGND VGND VPWR VPWR _02267_ sky130_fd_sc_hd__nor2_1
X_07427_ cpuregs\[27\]\[11\] _02630_ _03566_ VGND VGND VPWR VPWR _00367_ sky130_fd_sc_hd__mux2_1
XFILLER_149_762 VPWR VGND VPWR VGND sky130_ef_sc_hd__decap_12
XFILLER_109_615 VGND VGND VPWR VPWR sky130_fd_sc_hd__fill_1
XFILLER_10_226 VPWR VGND VPWR VGND sky130_ef_sc_hd__decap_12
X_07358_ _02621_ cpuregs\[9\]\[9\] _03563_ VGND VGND VPWR VPWR _00301_ sky130_fd_sc_hd__mux2_1
X_06309_ net171 decoded_imm\[0\] VGND VGND VPWR VPWR _02747_ sky130_fd_sc_hd__or2_1
X_07289_ cpuregs\[28\]\[7\] _02612_ net249 VGND VGND VPWR VPWR _00235_ sky130_fd_sc_hd__mux2_1
XFILLER_105_810 VGND VGND VPWR VPWR sky130_fd_sc_hd__fill_2
X_09028_ cpuregs\[28\]\[30\] cpuregs\[29\]\[30\] cpuregs\[30\]\[30\] cpuregs\[31\]\[30\]
+ net275 net271 VGND VGND VPWR VPWR _04700_ sky130_fd_sc_hd__mux4_1
XFILLER_151_437 VGND VGND VPWR VPWR sky130_fd_sc_hd__fill_2
XFILLER_116_180 VPWR VGND VPWR VGND sky130_ef_sc_hd__decap_12
XFILLER_120_813 VPWR VGND VPWR VGND sky130_ef_sc_hd__decap_12
XFILLER_105_876 VGND VGND VPWR VPWR sky130_fd_sc_hd__fill_2
XFILLER_78_727 VGND VGND VPWR VPWR sky130_fd_sc_hd__decap_6
XFILLER_49_55 VGND VGND VPWR VPWR sky130_fd_sc_hd__fill_1
XFILLER_104_375 VPWR VGND VPWR VGND sky130_ef_sc_hd__decap_12
XFILLER_77_237 VGND VGND VPWR VPWR sky130_fd_sc_hd__decap_4
XTAP_TAPCELL_ROW_144_2629 VGND VPWR sky130_fd_sc_hd__tapvpwrvgnd_1
XFILLER_105_61 VGND VGND VPWR VPWR sky130_fd_sc_hd__fill_1
XFILLER_92_218 VPWR VGND VPWR VGND sky130_ef_sc_hd__decap_12
XFILLER_18_304 VGND VGND VPWR VPWR sky130_fd_sc_hd__decap_4
XTAP_TAPCELL_ROW_29_800 VGND VPWR sky130_fd_sc_hd__tapvpwrvgnd_1
XFILLER_85_281 VPWR VGND VPWR VGND sky130_ef_sc_hd__decap_12
XFILLER_73_454 VPWR VGND VPWR VGND sky130_ef_sc_hd__decap_12
XFILLER_65_65 VGND VGND VPWR VPWR sky130_fd_sc_hd__decap_3
XFILLER_46_668 VGND VGND VPWR VPWR sky130_fd_sc_hd__fill_1
Xclkbuf_leaf_119_clk clknet_4_8_0_clk VGND VGND VPWR VPWR clknet_leaf_119_clk sky130_fd_sc_hd__clkbuf_8
XFILLER_81_42 VPWR VGND VPWR VGND sky130_ef_sc_hd__decap_12
XTAP_TAPCELL_ROW_64_1355 VGND VPWR sky130_fd_sc_hd__tapvpwrvgnd_1
X_10705_ clknet_leaf_102_clk _00803_ VGND VGND VPWR VPWR mem_do_rinst sky130_fd_sc_hd__dfxtp_2
XFILLER_146_209 VGND VGND VPWR VPWR sky130_fd_sc_hd__decap_4
X_10636_ clknet_leaf_82_clk _00766_ VGND VGND VPWR VPWR count_cycle\[59\] sky130_fd_sc_hd__dfxtp_1
Xclkload119 clknet_leaf_68_clk VGND VGND VPWR VPWR clkload119/Y sky130_fd_sc_hd__clkinv_4
XFILLER_127_434 VGND VGND VPWR VPWR sky130_fd_sc_hd__decap_4
Xclkload108 clknet_leaf_108_clk VGND VGND VPWR VPWR clkload108/Y sky130_fd_sc_hd__inv_6
XFILLER_14_91 VGND VGND VPWR VPWR sky130_fd_sc_hd__fill_1
X_10567_ clknet_leaf_63_clk _00697_ VGND VGND VPWR VPWR reg_next_pc\[22\] sky130_fd_sc_hd__dfxtp_1
XFILLER_10_793 VPWR VGND VPWR VGND sky130_ef_sc_hd__decap_12
XFILLER_6_742 VPWR VGND VPWR VGND sky130_ef_sc_hd__decap_12
X_10498_ clknet_leaf_86_clk _00628_ VGND VGND VPWR VPWR count_instr\[47\] sky130_fd_sc_hd__dfxtp_1
XFILLER_53_7 VGND VGND VPWR VPWR sky130_fd_sc_hd__fill_2
XFILLER_114_139 VGND VGND VPWR VPWR sky130_fd_sc_hd__fill_1
XFILLER_123_673 VGND VGND VPWR VPWR sky130_fd_sc_hd__decap_4
XFILLER_111_813 VGND VGND VPWR VPWR sky130_fd_sc_hd__decap_6
XFILLER_69_727 VGND VGND VPWR VPWR sky130_fd_sc_hd__fill_1
XFILLER_111_835 VGND VGND VPWR VPWR sky130_fd_sc_hd__decap_4
XFILLER_68_237 VPWR VGND VPWR VGND sky130_ef_sc_hd__decap_12
XFILLER_84_719 VGND VGND VPWR VPWR sky130_fd_sc_hd__fill_2
XFILLER_77_760 VGND VGND VPWR VPWR sky130_fd_sc_hd__fill_1
X_04990_ mem_do_rdata _01617_ _01614_ cpu_state\[6\] VGND VGND VPWR VPWR _01618_ sky130_fd_sc_hd__o211a_1
X_11119_ clknet_leaf_136_clk _01166_ VGND VGND VPWR VPWR cpuregs\[31\]\[8\] sky130_fd_sc_hd__dfxtp_1
Xinput6 mem_rdata[14] VGND VGND VPWR VPWR net6 sky130_fd_sc_hd__buf_1
X_06660_ _03057_ _03061_ _03084_ VGND VGND VPWR VPWR _03085_ sky130_fd_sc_hd__a21o_1
XFILLER_64_421 VPWR VGND VPWR VGND sky130_ef_sc_hd__decap_12
XFILLER_49_495 VGND VGND VPWR VPWR sky130_fd_sc_hd__decap_8
XFILLER_92_785 VGND VGND VPWR VPWR sky130_fd_sc_hd__fill_1
X_05611_ net205 net173 VGND VGND VPWR VPWR _02194_ sky130_fd_sc_hd__nand2b_1
XFILLER_52_627 VPWR VGND VPWR VGND sky130_ef_sc_hd__decap_12
XFILLER_24_307 VGND VGND VPWR VPWR sky130_fd_sc_hd__fill_1
XFILLER_101_19 VPWR VGND VPWR VGND sky130_ef_sc_hd__decap_12
X_06591_ cpuregs\[20\]\[10\] cpuregs\[21\]\[10\] cpuregs\[22\]\[10\] cpuregs\[23\]\[10\]
+ net263 net259 VGND VGND VPWR VPWR _03019_ sky130_fd_sc_hd__mux4_1
XFILLER_18_893 VPWR VGND VPWR VGND sky130_ef_sc_hd__decap_12
XFILLER_33_841 VPWR VGND VPWR VGND sky130_ef_sc_hd__decap_12
X_08330_ _04104_ _04105_ VGND VGND VPWR VPWR _00732_ sky130_fd_sc_hd__nor2_1
X_05542_ net196 net122 VGND VGND VPWR VPWR _02125_ sky130_fd_sc_hd__and2_1
X_05473_ _02053_ _02055_ VGND VGND VPWR VPWR _02056_ sky130_fd_sc_hd__nor2_1
XFILLER_60_693 VGND VGND VPWR VPWR sky130_fd_sc_hd__fill_1
XTAP_TAPCELL_ROW_15_571 VGND VPWR sky130_fd_sc_hd__tapvpwrvgnd_1
X_08261_ net453 net455 _04060_ VGND VGND VPWR VPWR _00708_ sky130_fd_sc_hd__a21oi_1
X_07212_ cpuregs\[30\]\[30\] _02709_ net252 VGND VGND VPWR VPWR _00162_ sky130_fd_sc_hd__mux2_1
XFILLER_20_557 VPWR VGND VPWR VGND sky130_ef_sc_hd__decap_12
X_08192_ _03997_ _03998_ VGND VGND VPWR VPWR _03999_ sky130_fd_sc_hd__nor2_1
XFILLER_146_776 VPWR VGND VPWR VGND sky130_ef_sc_hd__decap_12
XFILLER_134_905 VGND VGND VPWR VPWR sky130_fd_sc_hd__decap_4
X_07143_ latched_rd\[1\] latched_rd\[0\] _02580_ _03549_ VGND VGND VPWR VPWR _03550_
+ sky130_fd_sc_hd__or4bb_4
XFILLER_133_415 VGND VGND VPWR VPWR sky130_fd_sc_hd__decap_8
X_07074_ net190 _02721_ _03405_ _01641_ VGND VGND VPWR VPWR _03484_ sky130_fd_sc_hd__o211a_1
XTAP_TAPCELL_ROW_95_1849 VGND VPWR sky130_fd_sc_hd__tapvpwrvgnd_1
XFILLER_10_27 VGND VGND VPWR VPWR sky130_fd_sc_hd__fill_1
XFILLER_126_27 VGND VGND VPWR VPWR sky130_fd_sc_hd__fill_1
X_06025_ mem_rdata_q\[22\] net15 _01609_ VGND VGND VPWR VPWR _01116_ sky130_fd_sc_hd__mux2_1
XFILLER_59_237 VGND VGND VPWR VPWR sky130_fd_sc_hd__decap_3
XFILLER_142_15 VPWR VGND VPWR VGND sky130_ef_sc_hd__decap_12
XFILLER_68_760 VPWR VGND VPWR VGND sky130_ef_sc_hd__decap_12
X_07976_ _03775_ _03777_ _03788_ _03789_ _03799_ VGND VGND VPWR VPWR _03800_ sky130_fd_sc_hd__o311ai_4
X_09715_ _02670_ cpuregs\[5\]\[21\] _04872_ VGND VGND VPWR VPWR _01371_ sky130_fd_sc_hd__mux2_1
XTAP_TAPCELL_ROW_126_2348 VGND VPWR sky130_fd_sc_hd__tapvpwrvgnd_1
X_06927_ reg_pc\[22\] _02751_ _03342_ _02715_ VGND VGND VPWR VPWR _03343_ sky130_fd_sc_hd__a211o_1
XFILLER_68_793 VGND VGND VPWR VPWR sky130_fd_sc_hd__decap_8
XFILLER_19_69 VPWR VGND VPWR VGND sky130_ef_sc_hd__decap_12
X_09646_ _02662_ cpuregs\[22\]\[19\] _04869_ VGND VGND VPWR VPWR _01305_ sky130_fd_sc_hd__mux2_1
XFILLER_110_890 VPWR VGND VPWR VGND sky130_ef_sc_hd__decap_12
XFILLER_67_281 VPWR VGND VPWR VGND sky130_ef_sc_hd__decap_12
X_06858_ net187 net254 VGND VGND VPWR VPWR _03276_ sky130_fd_sc_hd__or2_1
XFILLER_83_785 VPWR VGND VPWR VGND sky130_ef_sc_hd__decap_12
XFILLER_55_454 VPWR VGND VPWR VGND sky130_ef_sc_hd__decap_12
X_05809_ _02372_ _02371_ instr_sub VGND VGND VPWR VPWR _02373_ sky130_fd_sc_hd__mux2_1
X_06789_ _00015_ _03206_ _03209_ _02735_ VGND VGND VPWR VPWR _03210_ sky130_fd_sc_hd__o211a_1
X_09577_ cpuregs\[29\]\[16\] _02649_ net239 VGND VGND VPWR VPWR _01238_ sky130_fd_sc_hd__mux2_1
XFILLER_70_424 VPWR VGND VPWR VGND sky130_ef_sc_hd__decap_12
XFILLER_35_57 VGND VGND VPWR VPWR sky130_fd_sc_hd__fill_2
X_08528_ cpuregs\[16\]\[0\] cpuregs\[17\]\[0\] cpuregs\[18\]\[0\] cpuregs\[19\]\[0\]
+ net279 _00008_ VGND VGND VPWR VPWR _04230_ sky130_fd_sc_hd__mux4_1
XFILLER_35_79 VGND VGND VPWR VPWR sky130_fd_sc_hd__decap_8
XTAP_TAPCELL_ROW_104_1989 VGND VPWR sky130_fd_sc_hd__tapvpwrvgnd_1
X_08459_ net260 _04195_ VGND VGND VPWR VPWR _04196_ sky130_fd_sc_hd__nor2_1
XTAP_TAPCELL_ROW_34_880 VGND VPWR sky130_fd_sc_hd__tapvpwrvgnd_1
XTAP_TAPCELL_ROW_46_1063 VGND VPWR sky130_fd_sc_hd__tapvpwrvgnd_1
XTAP_TAPCELL_ROW_46_1074 VGND VPWR sky130_fd_sc_hd__tapvpwrvgnd_1
XPHY_EDGE_ROW_14_Right_14 VGND VGND VPWR VPWR sky130_fd_sc_hd__decap_3
XFILLER_129_3 VPWR VGND VPWR VGND sky130_ef_sc_hd__decap_12
X_11470_ clknet_leaf_136_clk _01514_ VGND VGND VPWR VPWR cpuregs\[10\]\[4\] sky130_fd_sc_hd__dfxtp_1
X_10421_ clknet_leaf_124_clk _00551_ VGND VGND VPWR VPWR cpuregs\[17\]\[3\] sky130_fd_sc_hd__dfxtp_1
XFILLER_136_253 VGND VGND VPWR VPWR sky130_fd_sc_hd__decap_8
XFILLER_109_489 VGND VGND VPWR VPWR sky130_fd_sc_hd__decap_3
X_10352_ clknet_leaf_33_clk _00482_ VGND VGND VPWR VPWR cpuregs\[16\]\[30\] sky130_fd_sc_hd__dfxtp_1
XFILLER_152_757 VPWR VGND VPWR VGND sky130_ef_sc_hd__decap_12
XFILLER_151_223 VGND VGND VPWR VPWR sky130_fd_sc_hd__fill_1
X_10283_ clknet_leaf_48_clk _00413_ VGND VGND VPWR VPWR cpuregs\[15\]\[25\] sky130_fd_sc_hd__dfxtp_1
XFILLER_105_662 VGND VGND VPWR VPWR sky130_fd_sc_hd__decap_3
XFILLER_2_233 VPWR VGND VPWR VGND sky130_ef_sc_hd__decap_12
XFILLER_104_150 VPWR VGND VPWR VGND sky130_ef_sc_hd__decap_12
XFILLER_78_546 VGND VGND VPWR VPWR sky130_fd_sc_hd__decap_8
XFILLER_2_277 VPWR VGND VPWR VGND sky130_ef_sc_hd__decap_12
XPHY_EDGE_ROW_23_Right_23 VGND VGND VPWR VPWR sky130_fd_sc_hd__decap_3
XFILLER_116_82 VGND VGND VPWR VPWR sky130_fd_sc_hd__fill_2
XFILLER_104_194 VGND VGND VPWR VPWR sky130_fd_sc_hd__fill_2
XFILLER_120_687 VGND VGND VPWR VPWR sky130_fd_sc_hd__fill_2
XFILLER_74_752 VGND VGND VPWR VPWR sky130_fd_sc_hd__decap_4
XFILLER_58_270 VGND VGND VPWR VPWR sky130_fd_sc_hd__fill_1
XFILLER_18_112 VGND VGND VPWR VPWR sky130_fd_sc_hd__decap_4
XFILLER_73_251 VGND VGND VPWR VPWR sky130_fd_sc_hd__fill_1
XFILLER_18_145 VGND VGND VPWR VPWR sky130_fd_sc_hd__fill_1
XFILLER_92_41 VPWR VGND VPWR VGND sky130_ef_sc_hd__decap_12
XFILLER_92_85 VGND VGND VPWR VPWR sky130_fd_sc_hd__fill_2
XFILLER_14_340 VGND VGND VPWR VPWR sky130_fd_sc_hd__fill_1
XFILLER_15_841 VPWR VGND VPWR VGND sky130_ef_sc_hd__decap_12
XPHY_EDGE_ROW_32_Right_32 VGND VGND VPWR VPWR sky130_fd_sc_hd__decap_3
XTAP_TAPCELL_ROW_32_839 VGND VPWR sky130_fd_sc_hd__tapvpwrvgnd_1
XTAP_TAPCELL_ROW_12_530 VGND VPWR sky130_fd_sc_hd__tapvpwrvgnd_1
XFILLER_128_754 VGND VGND VPWR VPWR sky130_fd_sc_hd__fill_2
X_10619_ clknet_leaf_105_clk _00749_ VGND VGND VPWR VPWR count_cycle\[42\] sky130_fd_sc_hd__dfxtp_1
XFILLER_143_724 VGND VGND VPWR VPWR sky130_fd_sc_hd__decap_4
XFILLER_142_201 VGND VGND VPWR VPWR sky130_fd_sc_hd__fill_1
XTAP_TAPCELL_ROW_77_1557 VGND VPWR sky130_fd_sc_hd__tapvpwrvgnd_1
XTAP_TAPCELL_ROW_77_1568 VGND VPWR sky130_fd_sc_hd__tapvpwrvgnd_1
XFILLER_143_779 VGND VGND VPWR VPWR sky130_fd_sc_hd__decap_4
XPHY_EDGE_ROW_41_Right_41 VGND VGND VPWR VPWR sky130_fd_sc_hd__decap_3
XFILLER_44_3 VGND VGND VPWR VPWR sky130_fd_sc_hd__fill_2
XTAP_TAPCELL_ROW_90_1768 VGND VPWR sky130_fd_sc_hd__tapvpwrvgnd_1
XFILLER_97_888 VGND VGND VPWR VPWR sky130_fd_sc_hd__decap_4
XTAP_TAPCELL_ROW_90_1779 VGND VPWR sky130_fd_sc_hd__tapvpwrvgnd_1
XFILLER_57_719 VGND VGND VPWR VPWR sky130_fd_sc_hd__decap_8
X_07830_ reg_pc\[3\] _01624_ _01628_ _03689_ VGND VGND VPWR VPWR _00647_ sky130_fd_sc_hd__a22o_1
XFILLER_110_153 VGND VGND VPWR VPWR sky130_fd_sc_hd__decap_3
XFILLER_84_527 VGND VGND VPWR VPWR sky130_fd_sc_hd__decap_4
X_07761_ count_instr\[40\] count_instr\[39\] _03644_ VGND VGND VPWR VPWR _03648_ sky130_fd_sc_hd__and3_1
XFILLER_110_197 VGND VGND VPWR VPWR sky130_fd_sc_hd__decap_3
XTAP_TAPCELL_ROW_108_2067 VGND VPWR sky130_fd_sc_hd__tapvpwrvgnd_1
XTAP_TAPCELL_ROW_108_2056 VGND VPWR sky130_fd_sc_hd__tapvpwrvgnd_1
X_06712_ _03133_ _03134_ VGND VGND VPWR VPWR _03135_ sky130_fd_sc_hd__xor2_1
X_04973_ _01602_ VGND VGND VPWR VPWR _01603_ sky130_fd_sc_hd__inv_2
X_09500_ cpuregs\[31\]\[5\] _02603_ net240 VGND VGND VPWR VPWR _01163_ sky130_fd_sc_hd__mux2_1
XFILLER_2_83 VGND VGND VPWR VPWR sky130_fd_sc_hd__fill_1
XFILLER_112_29 VPWR VGND VPWR VGND sky130_ef_sc_hd__decap_12
X_07692_ count_instr\[15\] count_instr\[14\] _03600_ VGND VGND VPWR VPWR _03604_ sky130_fd_sc_hd__and3_1
XFILLER_65_785 VGND VGND VPWR VPWR sky130_fd_sc_hd__decap_4
XFILLER_64_251 VGND VGND VPWR VPWR sky130_fd_sc_hd__fill_1
XFILLER_64_262 VGND VGND VPWR VPWR sky130_fd_sc_hd__decap_3
X_06643_ cpuregs\[8\]\[12\] cpuregs\[9\]\[12\] cpuregs\[10\]\[12\] cpuregs\[11\]\[12\]
+ net263 net259 VGND VGND VPWR VPWR _03069_ sky130_fd_sc_hd__mux4_1
XPHY_EDGE_ROW_50_Right_50 VGND VGND VPWR VPWR sky130_fd_sc_hd__decap_3
X_09431_ _02590_ cpuregs\[19\]\[2\] _04863_ VGND VGND VPWR VPWR _01064_ sky130_fd_sc_hd__mux2_1
XTAP_TAPCELL_ROW_121_2267 VGND VPWR sky130_fd_sc_hd__tapvpwrvgnd_1
X_09362_ instr_jal decoded_imm_j\[14\] _01589_ mem_rdata_q\[14\] VGND VGND VPWR VPWR
+ _04843_ sky130_fd_sc_hd__a22o_1
X_06574_ _02714_ _02984_ _02987_ _03002_ net236 VGND VGND VPWR VPWR _03003_ sky130_fd_sc_hd__o311a_1
X_05525_ net179 net211 VGND VGND VPWR VPWR _02108_ sky130_fd_sc_hd__or2_1
X_08313_ count_cycle\[20\] _04092_ VGND VGND VPWR VPWR _04094_ sky130_fd_sc_hd__and2_1
XFILLER_33_682 VGND VGND VPWR VPWR sky130_fd_sc_hd__decap_6
X_09293_ net150 net112 _04206_ VGND VGND VPWR VPWR _00979_ sky130_fd_sc_hd__mux2_1
XANTENNA_22 net180 VGND VGND VPWR VPWR sky130_fd_sc_hd__diode_2
XANTENNA_11 _04711_ VGND VGND VPWR VPWR sky130_fd_sc_hd__diode_2
XFILLER_21_833 VGND VGND VPWR VPWR sky130_fd_sc_hd__decap_6
XANTENNA_44 net270 VGND VGND VPWR VPWR sky130_fd_sc_hd__diode_2
XANTENNA_33 _02499_ VGND VGND VPWR VPWR sky130_fd_sc_hd__diode_2
X_08244_ _04044_ _04045_ _04043_ VGND VGND VPWR VPWR _04047_ sky130_fd_sc_hd__a21oi_1
X_05456_ _02027_ _02030_ _02038_ _01543_ VGND VGND VPWR VPWR _02040_ sky130_fd_sc_hd__a31o_1
XFILLER_20_365 VPWR VGND VPWR VGND sky130_ef_sc_hd__decap_12
XFILLER_21_877 VPWR VGND VPWR VGND sky130_ef_sc_hd__decap_12
X_08175_ _03943_ _03945_ _03955_ _03966_ _03940_ VGND VGND VPWR VPWR _03983_ sky130_fd_sc_hd__o2111a_1
XFILLER_119_765 VPWR VGND VPWR VGND sky130_ef_sc_hd__decap_12
XFILLER_107_905 VGND VGND VPWR VPWR sky130_fd_sc_hd__decap_3
X_05387_ count_cycle\[25\] _01588_ VGND VGND VPWR VPWR _01977_ sky130_fd_sc_hd__or2_1
XFILLER_21_15 VPWR VGND VPWR VGND sky130_ef_sc_hd__decap_12
XFILLER_137_15 VPWR VGND VPWR VGND sky130_ef_sc_hd__decap_12
X_07126_ cpuregs\[16\]\[30\] cpuregs\[17\]\[30\] cpuregs\[18\]\[30\] cpuregs\[19\]\[30\]
+ net266 net261 VGND VGND VPWR VPWR _03534_ sky130_fd_sc_hd__mux4_1
XFILLER_134_757 VPWR VGND VPWR VGND sky130_ef_sc_hd__decap_12
XFILLER_133_223 VGND VGND VPWR VPWR sky130_fd_sc_hd__fill_1
XFILLER_118_297 VGND VGND VPWR VPWR sky130_fd_sc_hd__fill_2
XFILLER_106_426 VGND VGND VPWR VPWR sky130_fd_sc_hd__decap_4
Xoutput151 net151 VGND VGND VPWR VPWR mem_wdata[24] sky130_fd_sc_hd__buf_2
X_07057_ _03459_ _03460_ _03466_ _03467_ _01579_ _01581_ VGND VGND VPWR VPWR _03468_
+ sky130_fd_sc_hd__mux4_1
XFILLER_88_811 VGND VGND VPWR VPWR sky130_fd_sc_hd__fill_1
Xoutput140 net140 VGND VGND VPWR VPWR mem_wdata[14] sky130_fd_sc_hd__buf_2
Xoutput184 net184 VGND VGND VPWR VPWR pcpi_rs1[21] sky130_fd_sc_hd__buf_2
X_06008_ net189 _02507_ _01582_ VGND VGND VPWR VPWR net82 sky130_fd_sc_hd__mux2_1
Xoutput195 net195 VGND VGND VPWR VPWR pcpi_rs1[31] sky130_fd_sc_hd__buf_2
XFILLER_87_310 VPWR VGND VPWR VGND sky130_ef_sc_hd__decap_12
Xoutput173 net173 VGND VGND VPWR VPWR pcpi_rs1[11] sky130_fd_sc_hd__buf_2
Xoutput162 net162 VGND VGND VPWR VPWR mem_wdata[5] sky130_fd_sc_hd__buf_2
XFILLER_99_192 VGND VGND VPWR VPWR sky130_fd_sc_hd__decap_6
XFILLER_0_748 VGND VGND VPWR VPWR sky130_fd_sc_hd__decap_4
XFILLER_153_69 VPWR VGND VPWR VGND sky130_ef_sc_hd__decap_12
XFILLER_75_516 VGND VGND VPWR VPWR sky130_fd_sc_hd__decap_8
X_07959_ _03783_ _03784_ net34 VGND VGND VPWR VPWR _00682_ sky130_fd_sc_hd__o21a_1
XFILLER_46_23 VGND VGND VPWR VPWR sky130_fd_sc_hd__decap_4
XFILLER_56_752 VGND VGND VPWR VPWR sky130_fd_sc_hd__decap_4
XTAP_TAPCELL_ROW_48_1103 VGND VPWR sky130_fd_sc_hd__tapvpwrvgnd_1
X_10970_ clknet_leaf_124_clk _01032_ VGND VGND VPWR VPWR cpuregs\[18\]\[2\] sky130_fd_sc_hd__dfxtp_1
XFILLER_28_454 VPWR VGND VPWR VGND sky130_ef_sc_hd__decap_12
XTAP_TAPCELL_ROW_39_950 VGND VPWR sky130_fd_sc_hd__tapvpwrvgnd_1
XTAP_TAPCELL_ROW_39_961 VGND VPWR sky130_fd_sc_hd__tapvpwrvgnd_1
X_09629_ _02590_ cpuregs\[22\]\[2\] _04869_ VGND VGND VPWR VPWR _01288_ sky130_fd_sc_hd__mux2_1
XTAP_TAPCELL_ROW_61_1314 VGND VPWR sky130_fd_sc_hd__tapvpwrvgnd_1
XTAP_TAPCELL_ROW_61_1303 VGND VPWR sky130_fd_sc_hd__tapvpwrvgnd_1
XFILLER_12_811 VGND VGND VPWR VPWR sky130_fd_sc_hd__fill_1
Xclkbuf_leaf_50_clk clknet_4_7_0_clk VGND VGND VPWR VPWR clknet_leaf_50_clk sky130_fd_sc_hd__clkbuf_8
XFILLER_24_693 VGND VGND VPWR VPWR sky130_fd_sc_hd__decap_6
XFILLER_8_837 VPWR VGND VPWR VGND sky130_ef_sc_hd__decap_12
X_11453_ clknet_leaf_71_clk _01497_ VGND VGND VPWR VPWR cpuregs\[0\]\[19\] sky130_fd_sc_hd__dfxtp_1
XFILLER_7_39 VPWR VGND VPWR VGND sky130_ef_sc_hd__decap_12
X_10404_ clknet_leaf_53_clk _00534_ VGND VGND VPWR VPWR cpuregs\[20\]\[18\] sky130_fd_sc_hd__dfxtp_1
X_11384_ clknet_leaf_29_clk _01428_ VGND VGND VPWR VPWR cpuregs\[7\]\[14\] sky130_fd_sc_hd__dfxtp_1
XTAP_TAPCELL_ROW_59_1276 VGND VPWR sky130_fd_sc_hd__tapvpwrvgnd_1
XFILLER_152_565 VGND VGND VPWR VPWR sky130_fd_sc_hd__fill_1
X_10335_ clknet_leaf_8_clk _00465_ VGND VGND VPWR VPWR cpuregs\[16\]\[13\] sky130_fd_sc_hd__dfxtp_1
XFILLER_11_81 VPWR VGND VPWR VGND sky130_ef_sc_hd__decap_12
XFILLER_3_553 VGND VGND VPWR VPWR sky130_fd_sc_hd__decap_6
XFILLER_97_129 VGND VGND VPWR VPWR sky130_fd_sc_hd__fill_2
XFILLER_3_597 VGND VGND VPWR VPWR sky130_fd_sc_hd__decap_8
X_10266_ clknet_leaf_13_clk _00396_ VGND VGND VPWR VPWR cpuregs\[15\]\[8\] sky130_fd_sc_hd__dfxtp_1
XFILLER_78_354 VGND VGND VPWR VPWR sky130_fd_sc_hd__decap_8
XTAP_TAPCELL_ROW_72_1487 VGND VPWR sky130_fd_sc_hd__tapvpwrvgnd_1
XTAP_TAPCELL_ROW_72_1476 VGND VPWR sky130_fd_sc_hd__tapvpwrvgnd_1
XFILLER_120_451 VGND VGND VPWR VPWR sky130_fd_sc_hd__decap_4
XFILLER_78_387 VGND VGND VPWR VPWR sky130_fd_sc_hd__fill_2
XFILLER_78_365 VPWR VGND VPWR VGND sky130_ef_sc_hd__decap_12
X_10197_ clknet_leaf_139_clk _00327_ VGND VGND VPWR VPWR cpuregs\[14\]\[3\] sky130_fd_sc_hd__dfxtp_1
XFILLER_94_869 VPWR VGND VPWR VGND sky130_ef_sc_hd__decap_12
XFILLER_94_847 VGND VGND VPWR VPWR sky130_fd_sc_hd__decap_4
XFILLER_38_229 VGND VGND VPWR VPWR sky130_fd_sc_hd__decap_6
XFILLER_19_465 VGND VGND VPWR VPWR sky130_fd_sc_hd__decap_4
XFILLER_46_251 VGND VGND VPWR VPWR sky130_fd_sc_hd__fill_1
XFILLER_47_752 VGND VGND VPWR VPWR sky130_fd_sc_hd__decap_8
XTAP_TAPCELL_ROW_17_600 VGND VPWR sky130_fd_sc_hd__tapvpwrvgnd_1
XTAP_TAPCELL_ROW_17_611 VGND VPWR sky130_fd_sc_hd__tapvpwrvgnd_1
XFILLER_19_487 VGND VGND VPWR VPWR sky130_fd_sc_hd__decap_3
XFILLER_62_755 VGND VGND VPWR VPWR sky130_fd_sc_hd__fill_1
XFILLER_15_682 VGND VGND VPWR VPWR sky130_fd_sc_hd__fill_2
Xclkbuf_leaf_41_clk clknet_4_5_0_clk VGND VGND VPWR VPWR clknet_leaf_41_clk sky130_fd_sc_hd__clkbuf_8
XFILLER_148_849 VPWR VGND VPWR VGND sky130_ef_sc_hd__decap_12
X_05310_ cpu_state\[6\] _01860_ _01902_ cpu_state\[4\] net181 VGND VGND VPWR VPWR
+ _01906_ sky130_fd_sc_hd__a32o_1
X_06290_ _02726_ _02727_ net258 VGND VGND VPWR VPWR _02728_ sky130_fd_sc_hd__mux2_1
XFILLER_147_337 VGND VGND VPWR VPWR sky130_fd_sc_hd__decap_6
X_05241_ _01821_ _01830_ _01831_ _01828_ VGND VGND VPWR VPWR _01842_ sky130_fd_sc_hd__a211o_1
Xinput20 mem_rdata[27] VGND VGND VPWR VPWR net20 sky130_fd_sc_hd__buf_2
Xinput31 mem_rdata[8] VGND VGND VPWR VPWR net31 sky130_fd_sc_hd__dlymetal6s2s_1
X_05172_ cpu_state\[3\] _01769_ _01770_ _01778_ VGND VGND VPWR VPWR _04908_ sky130_fd_sc_hd__a31o_1
XFILLER_115_223 VGND VGND VPWR VPWR sky130_fd_sc_hd__fill_1
XTAP_TAPCELL_ROW_92_1808 VGND VPWR sky130_fd_sc_hd__tapvpwrvgnd_1
X_09980_ clknet_leaf_13_clk _00110_ VGND VGND VPWR VPWR cpuregs\[12\]\[10\] sky130_fd_sc_hd__dfxtp_1
X_08931_ _04607_ _04608_ _04266_ _04605_ VGND VGND VPWR VPWR _04609_ sky130_fd_sc_hd__o211a_1
X_08862_ cpuregs\[16\]\[21\] cpuregs\[17\]\[21\] cpuregs\[18\]\[21\] cpuregs\[19\]\[21\]
+ _00007_ net274 VGND VGND VPWR VPWR _04543_ sky130_fd_sc_hd__mux4_1
X_07813_ _03679_ _03680_ VGND VGND VPWR VPWR _00640_ sky130_fd_sc_hd__nor2_1
XFILLER_69_376 VGND VGND VPWR VPWR sky130_fd_sc_hd__decap_8
XFILLER_123_39 VPWR VGND VPWR VGND sky130_ef_sc_hd__decap_12
X_08793_ cpuregs\[28\]\[17\] cpuregs\[29\]\[17\] cpuregs\[30\]\[17\] cpuregs\[31\]\[17\]
+ net277 net272 VGND VGND VPWR VPWR _04478_ sky130_fd_sc_hd__mux4_1
XTAP_TAPCELL_ROW_123_2307 VGND VPWR sky130_fd_sc_hd__tapvpwrvgnd_1
X_04956_ instr_rdinstrh instr_rdcycleh instr_rdinstr VGND VGND VPWR VPWR _01587_ sky130_fd_sc_hd__nor3_4
X_07744_ count_instr\[33\] _03634_ count_instr\[34\] VGND VGND VPWR VPWR _03637_ sky130_fd_sc_hd__a21o_1
XFILLER_53_700 VGND VGND VPWR VPWR sky130_fd_sc_hd__decap_3
X_07675_ count_instr\[8\] net392 count_instr\[9\] VGND VGND VPWR VPWR _03593_ sky130_fd_sc_hd__a21o_1
XFILLER_16_15 VPWR VGND VPWR VGND sky130_ef_sc_hd__decap_12
X_09414_ _02657_ cpuregs\[18\]\[18\] _04862_ VGND VGND VPWR VPWR _01048_ sky130_fd_sc_hd__mux2_1
XFILLER_80_541 VPWR VGND VPWR VGND sky130_ef_sc_hd__decap_12
X_06626_ _03048_ _03051_ _03052_ _00016_ _01580_ VGND VGND VPWR VPWR _03053_ sky130_fd_sc_hd__a221o_1
Xclkbuf_leaf_32_clk clknet_4_5_0_clk VGND VGND VPWR VPWR clknet_leaf_32_clk sky130_fd_sc_hd__clkbuf_8
XTAP_TAPCELL_ROW_101_1948 VGND VPWR sky130_fd_sc_hd__tapvpwrvgnd_1
X_09345_ decoded_imm\[23\] _04746_ _04825_ _04834_ VGND VGND VPWR VPWR _01007_ sky130_fd_sc_hd__o22a_1
X_06557_ net198 _02721_ _02744_ _02985_ VGND VGND VPWR VPWR _02986_ sky130_fd_sc_hd__o211a_1
XTAP_TAPCELL_ROW_43_1022 VGND VPWR sky130_fd_sc_hd__tapvpwrvgnd_1
X_09276_ net163 net125 _04206_ VGND VGND VPWR VPWR _00962_ sky130_fd_sc_hd__mux2_1
X_05508_ net183 net215 VGND VGND VPWR VPWR _02091_ sky130_fd_sc_hd__nor2_1
X_06488_ _02912_ _02918_ _02919_ _01581_ _01580_ VGND VGND VPWR VPWR _02920_ sky130_fd_sc_hd__a221o_1
XFILLER_120_7 VPWR VGND VPWR VGND sky130_ef_sc_hd__decap_12
X_08227_ _03712_ _03713_ _03714_ _03716_ decoded_imm_j\[20\] VGND VGND VPWR VPWR _04031_
+ sky130_fd_sc_hd__o41a_1
X_05439_ cpu_state\[6\] _01860_ _02021_ cpu_state\[4\] net192 VGND VGND VPWR VPWR
+ _02025_ sky130_fd_sc_hd__a32o_1
XFILLER_20_162 VGND VGND VPWR VPWR sky130_fd_sc_hd__fill_1
XFILLER_32_69 VGND VGND VPWR VPWR sky130_fd_sc_hd__fill_1
XFILLER_119_573 VGND VGND VPWR VPWR sky130_fd_sc_hd__decap_8
XFILLER_119_551 VGND VGND VPWR VPWR sky130_fd_sc_hd__decap_8
XFILLER_4_306 VGND VGND VPWR VPWR sky130_fd_sc_hd__fill_2
XFILLER_20_195 VGND VGND VPWR VPWR sky130_fd_sc_hd__fill_1
XFILLER_153_329 VGND VGND VPWR VPWR sky130_fd_sc_hd__decap_3
XTAP_TAPCELL_ROW_151_2750 VGND VPWR sky130_fd_sc_hd__tapvpwrvgnd_1
XTAP_TAPCELL_ROW_134_2469 VGND VPWR sky130_fd_sc_hd__tapvpwrvgnd_1
X_08158_ _03948_ _03954_ VGND VGND VPWR VPWR _03968_ sky130_fd_sc_hd__nor2_1
XFILLER_122_705 VGND VGND VPWR VPWR sky130_fd_sc_hd__fill_1
X_07109_ _03509_ _03510_ _03514_ _03515_ _01579_ _01581_ VGND VGND VPWR VPWR _03518_
+ sky130_fd_sc_hd__mux4_1
X_08089_ _03576_ _03904_ VGND VGND VPWR VPWR _03905_ sky130_fd_sc_hd__nor2_1
X_10120_ clknet_leaf_51_clk _00250_ VGND VGND VPWR VPWR cpuregs\[28\]\[22\] sky130_fd_sc_hd__dfxtp_1
XFILLER_121_259 VGND VGND VPWR VPWR sky130_fd_sc_hd__decap_4
XFILLER_88_652 VPWR VGND VPWR VGND sky130_ef_sc_hd__decap_12
X_10051_ clknet_leaf_25_clk _00181_ VGND VGND VPWR VPWR cpuregs\[13\]\[17\] sky130_fd_sc_hd__dfxtp_1
Xclkbuf_leaf_99_clk clknet_4_9_0_clk VGND VGND VPWR VPWR clknet_leaf_99_clk sky130_fd_sc_hd__clkbuf_8
XFILLER_0_545 VGND VGND VPWR VPWR sky130_fd_sc_hd__decap_4
XTAP_TAPCELL_ROW_54_1195 VGND VPWR sky130_fd_sc_hd__tapvpwrvgnd_1
XFILLER_0_589 VPWR VGND VPWR VGND sky130_ef_sc_hd__decap_12
XFILLER_76_847 VGND VGND VPWR VPWR sky130_fd_sc_hd__fill_1
XFILLER_75_324 VPWR VGND VPWR VGND sky130_ef_sc_hd__decap_12
XFILLER_57_55 VGND VGND VPWR VPWR sky130_fd_sc_hd__fill_1
XFILLER_90_305 VGND VGND VPWR VPWR sky130_fd_sc_hd__decap_3
XTAP_TAPCELL_ROW_3_372 VGND VPWR sky130_fd_sc_hd__tapvpwrvgnd_1
XFILLER_91_839 VGND VGND VPWR VPWR sky130_fd_sc_hd__fill_1
X_10953_ clknet_leaf_88_clk _01015_ VGND VGND VPWR VPWR decoded_imm\[15\] sky130_fd_sc_hd__dfxtp_2
XTAP_TAPCELL_ROW_3_383 VGND VPWR sky130_fd_sc_hd__tapvpwrvgnd_1
XFILLER_28_251 VGND VGND VPWR VPWR sky130_fd_sc_hd__fill_1
XFILLER_44_755 VGND VGND VPWR VPWR sky130_fd_sc_hd__fill_1
X_10884_ clknet_leaf_39_clk _00946_ VGND VGND VPWR VPWR cpuregs\[1\]\[28\] sky130_fd_sc_hd__dfxtp_1
XFILLER_31_405 VGND VGND VPWR VPWR sky130_fd_sc_hd__decap_6
Xclkbuf_leaf_23_clk clknet_4_4_0_clk VGND VGND VPWR VPWR clknet_leaf_23_clk sky130_fd_sc_hd__clkbuf_8
XFILLER_31_449 VPWR VGND VPWR VGND sky130_ef_sc_hd__decap_12
XFILLER_43_298 VGND VGND VPWR VPWR sky130_fd_sc_hd__decap_6
XFILLER_129_326 VGND VGND VPWR VPWR sky130_fd_sc_hd__decap_8
XFILLER_7_111 VGND VGND VPWR VPWR sky130_fd_sc_hd__fill_1
XTAP_TAPCELL_ROW_22_680 VGND VPWR sky130_fd_sc_hd__tapvpwrvgnd_1
XFILLER_144_307 VGND VGND VPWR VPWR sky130_fd_sc_hd__fill_1
XTAP_TAPCELL_ROW_22_691 VGND VPWR sky130_fd_sc_hd__tapvpwrvgnd_1
XFILLER_153_841 VGND VGND VPWR VPWR sky130_fd_sc_hd__fill_2
XFILLER_138_893 VPWR VGND VPWR VGND sky130_ef_sc_hd__decap_12
X_11436_ clknet_leaf_121_clk _01480_ VGND VGND VPWR VPWR cpuregs\[0\]\[2\] sky130_fd_sc_hd__dfxtp_1
XFILLER_153_874 VGND VGND VPWR VPWR sky130_fd_sc_hd__decap_4
X_11367_ clknet_leaf_32_clk _01411_ VGND VGND VPWR VPWR cpuregs\[6\]\[29\] sky130_fd_sc_hd__dfxtp_1
XTAP_TAPCELL_ROW_74_1516 VGND VPWR sky130_fd_sc_hd__tapvpwrvgnd_1
X_10318_ clknet_leaf_41_clk _00448_ VGND VGND VPWR VPWR cpuregs\[26\]\[28\] sky130_fd_sc_hd__dfxtp_1
XFILLER_112_215 VGND VGND VPWR VPWR sky130_fd_sc_hd__fill_1
XFILLER_3_361 VPWR VGND VPWR VGND sky130_ef_sc_hd__decap_12
X_11298_ clknet_leaf_35_clk _01345_ VGND VGND VPWR VPWR cpuregs\[4\]\[27\] sky130_fd_sc_hd__dfxtp_1
X_10249_ clknet_leaf_52_clk _00379_ VGND VGND VPWR VPWR cpuregs\[27\]\[23\] sky130_fd_sc_hd__dfxtp_1
XFILLER_79_685 VGND VGND VPWR VPWR sky130_fd_sc_hd__fill_1
XFILLER_67_825 VGND VGND VPWR VPWR sky130_fd_sc_hd__fill_1
XFILLER_39_505 VPWR VGND VPWR VGND sky130_ef_sc_hd__decap_12
XFILLER_93_110 VGND VGND VPWR VPWR sky130_fd_sc_hd__fill_2
XFILLER_78_195 VGND VGND VPWR VPWR sky130_fd_sc_hd__fill_1
XTAP_TAPCELL_ROW_105_2015 VGND VPWR sky130_fd_sc_hd__tapvpwrvgnd_1
XTAP_TAPCELL_ROW_105_2004 VGND VPWR sky130_fd_sc_hd__tapvpwrvgnd_1
X_05790_ _02113_ _02203_ VGND VGND VPWR VPWR _02356_ sky130_fd_sc_hd__or2_1
XFILLER_94_666 VGND VGND VPWR VPWR sky130_fd_sc_hd__decap_3
XFILLER_66_346 VGND VGND VPWR VPWR sky130_fd_sc_hd__decap_3
XFILLER_93_198 VGND VGND VPWR VPWR sky130_fd_sc_hd__decap_8
XFILLER_93_165 VGND VGND VPWR VPWR sky130_fd_sc_hd__decap_3
XFILLER_82_839 VPWR VGND VPWR VGND sky130_ef_sc_hd__decap_12
XFILLER_74_390 VPWR VGND VPWR VGND sky130_ef_sc_hd__decap_12
XFILLER_62_541 VGND VGND VPWR VPWR sky130_fd_sc_hd__fill_2
XTAP_TAPCELL_ROW_85_1689 VGND VPWR sky130_fd_sc_hd__tapvpwrvgnd_1
XFILLER_62_585 VGND VGND VPWR VPWR sky130_fd_sc_hd__decap_3
X_07460_ cpuregs\[15\]\[11\] _02630_ net246 VGND VGND VPWR VPWR _00399_ sky130_fd_sc_hd__mux2_1
XFILLER_34_265 VGND VGND VPWR VPWR sky130_fd_sc_hd__decap_8
X_06411_ net258 _02842_ _02844_ VGND VGND VPWR VPWR _02845_ sky130_fd_sc_hd__a21o_1
X_07391_ cpuregs\[14\]\[9\] _02621_ net247 VGND VGND VPWR VPWR _00333_ sky130_fd_sc_hd__mux2_1
X_09130_ _01556_ mem_rdata_q\[13\] mem_rdata_q\[12\] VGND VGND VPWR VPWR _04766_ sky130_fd_sc_hd__and3_1
Xclkbuf_leaf_14_clk clknet_4_3_0_clk VGND VGND VPWR VPWR clknet_leaf_14_clk sky130_fd_sc_hd__clkbuf_8
X_06342_ cpuregs\[8\]\[2\] cpuregs\[9\]\[2\] cpuregs\[10\]\[2\] cpuregs\[11\]\[2\]
+ net264 net262 VGND VGND VPWR VPWR _02778_ sky130_fd_sc_hd__mux4_1
Xrebuffer208 latched_stalu VGND VGND VPWR VPWR net594 sky130_fd_sc_hd__buf_2
X_09061_ cpu_state\[3\] _02236_ _01644_ VGND VGND VPWR VPWR _04731_ sky130_fd_sc_hd__a21o_1
Xrebuffer219 net604 VGND VGND VPWR VPWR net605 sky130_fd_sc_hd__dlygate4sd1_1
XFILLER_147_167 VGND VGND VPWR VPWR sky130_fd_sc_hd__fill_1
X_06273_ _02710_ _02711_ _02583_ VGND VGND VPWR VPWR _02712_ sky130_fd_sc_hd__mux2_8
X_08012_ _03831_ _03832_ VGND VGND VPWR VPWR _03833_ sky130_fd_sc_hd__nand2_1
XPHY_EDGE_ROW_7_Left_161 VGND VGND VPWR VPWR sky130_fd_sc_hd__decap_3
X_05224_ count_cycle\[12\] _01588_ net256 _01826_ VGND VGND VPWR VPWR _01827_ sky130_fd_sc_hd__o211a_1
XTAP_TAPCELL_ROW_116_2188 VGND VPWR sky130_fd_sc_hd__tapvpwrvgnd_1
X_05155_ count_cycle\[7\] _01588_ net256 _01762_ VGND VGND VPWR VPWR _01763_ sky130_fd_sc_hd__o211a_1
X_09963_ clknet_leaf_62_clk _00093_ VGND VGND VPWR VPWR net187 sky130_fd_sc_hd__dfxtp_4
X_05086_ count_instr\[34\] instr_rdinstrh instr_rdcycleh count_cycle\[34\] VGND VGND
+ VPWR VPWR _01699_ sky130_fd_sc_hd__a22o_1
XPHY_EDGE_ROW_4_Right_4 VGND VGND VPWR VPWR sky130_fd_sc_hd__decap_3
XFILLER_131_557 VGND VGND VPWR VPWR sky130_fd_sc_hd__decap_3
X_08914_ net218 _01585_ _04591_ _04592_ VGND VGND VPWR VPWR _00829_ sky130_fd_sc_hd__o22a_1
X_09894_ cpuregs\[0\]\[24\] VGND VGND VPWR VPWR _01502_ sky130_fd_sc_hd__clkbuf_1
XFILLER_134_27 VGND VGND VPWR VPWR sky130_fd_sc_hd__fill_1
X_08845_ cpuregs\[28\]\[20\] cpuregs\[29\]\[20\] cpuregs\[30\]\[20\] cpuregs\[31\]\[20\]
+ net280 net274 VGND VGND VPWR VPWR _04527_ sky130_fd_sc_hd__mux4_1
XFILLER_85_644 VGND VGND VPWR VPWR sky130_fd_sc_hd__fill_1
X_08776_ cpuregs\[8\]\[16\] cpuregs\[9\]\[16\] cpuregs\[10\]\[16\] cpuregs\[11\]\[16\]
+ net276 net272 VGND VGND VPWR VPWR _04462_ sky130_fd_sc_hd__mux4_1
XFILLER_57_368 VPWR VGND VPWR VGND sky130_ef_sc_hd__decap_12
XFILLER_57_346 VGND VGND VPWR VPWR sky130_fd_sc_hd__decap_4
XFILLER_150_15 VPWR VGND VPWR VGND sky130_ef_sc_hd__decap_12
X_07727_ count_instr\[27\] _03624_ _03626_ VGND VGND VPWR VPWR _00608_ sky130_fd_sc_hd__o21a_1
X_05988_ net178 _02497_ _01582_ VGND VGND VPWR VPWR net72 sky130_fd_sc_hd__mux2_1
XTAP_TAPCELL_ROW_0_320 VGND VPWR sky130_fd_sc_hd__tapvpwrvgnd_1
XFILLER_65_390 VGND VGND VPWR VPWR sky130_fd_sc_hd__fill_2
X_04939_ net126 VGND VGND VPWR VPWR _01572_ sky130_fd_sc_hd__inv_2
XTAP_TAPCELL_ROW_0_331 VGND VPWR sky130_fd_sc_hd__tapvpwrvgnd_1
XFILLER_26_755 VGND VGND VPWR VPWR sky130_fd_sc_hd__fill_1
XFILLER_25_243 VGND VGND VPWR VPWR sky130_fd_sc_hd__fill_1
X_07658_ _03581_ _03582_ VGND VGND VPWR VPWR _00583_ sky130_fd_sc_hd__nor2_1
XFILLER_80_393 VGND VGND VPWR VPWR sky130_fd_sc_hd__fill_1
X_06609_ _03006_ _03009_ VGND VGND VPWR VPWR _03036_ sky130_fd_sc_hd__nor2_1
XFILLER_53_596 VGND VGND VPWR VPWR sky130_fd_sc_hd__fill_2
XFILLER_25_287 VGND VGND VPWR VPWR sky130_fd_sc_hd__fill_1
Xclkbuf_4_8_0_clk clknet_0_clk VGND VGND VPWR VPWR clknet_4_8_0_clk sky130_fd_sc_hd__clkbuf_8
X_07589_ cpuregs\[20\]\[6\] _02607_ net245 VGND VGND VPWR VPWR _00522_ sky130_fd_sc_hd__mux2_1
XFILLER_138_101 VPWR VGND VPWR VGND sky130_ef_sc_hd__decap_12
XTAP_TAPCELL_ROW_136_2509 VGND VPWR sky130_fd_sc_hd__tapvpwrvgnd_1
X_09328_ decoded_imm\[31\] _04746_ VGND VGND VPWR VPWR _04826_ sky130_fd_sc_hd__or2_1
XTAP_TAPCELL_ROW_153_2801 VGND VPWR sky130_fd_sc_hd__tapvpwrvgnd_1
XFILLER_139_657 VGND VGND VPWR VPWR sky130_fd_sc_hd__decap_4
XFILLER_126_307 VGND VGND VPWR VPWR sky130_fd_sc_hd__fill_1
XFILLER_21_493 VGND VGND VPWR VPWR sky130_fd_sc_hd__decap_8
X_09259_ _01583_ _01608_ _01609_ _04801_ VGND VGND VPWR VPWR _04802_ sky130_fd_sc_hd__o31a_1
XFILLER_153_137 VGND VGND VPWR VPWR sky130_fd_sc_hd__decap_3
XFILLER_111_3 VGND VGND VPWR VPWR sky130_fd_sc_hd__decap_3
XFILLER_5_615 VGND VGND VPWR VPWR sky130_fd_sc_hd__fill_1
XFILLER_135_841 VPWR VGND VPWR VGND sky130_ef_sc_hd__decap_12
X_11221_ clknet_leaf_27_clk _01268_ VGND VGND VPWR VPWR cpuregs\[3\]\[14\] sky130_fd_sc_hd__dfxtp_1
XFILLER_150_811 VGND VGND VPWR VPWR sky130_fd_sc_hd__fill_1
XFILLER_122_513 VGND VGND VPWR VPWR sky130_fd_sc_hd__decap_3
XFILLER_108_61 VPWR VGND VPWR VGND sky130_ef_sc_hd__decap_12
XTAP_TAPCELL_ROW_56_1235 VGND VPWR sky130_fd_sc_hd__tapvpwrvgnd_1
XTAP_TAPCELL_ROW_56_1224 VGND VPWR sky130_fd_sc_hd__tapvpwrvgnd_1
XFILLER_4_29 VPWR VGND VPWR VGND sky130_ef_sc_hd__decap_12
X_11152_ clknet_leaf_0_clk _01199_ VGND VGND VPWR VPWR cpuregs\[23\]\[9\] sky130_fd_sc_hd__dfxtp_1
XFILLER_108_94 VPWR VGND VPWR VGND sky130_ef_sc_hd__decap_12
XTAP_TAPCELL_ROW_8_464 VGND VPWR sky130_fd_sc_hd__tapvpwrvgnd_1
XTAP_TAPCELL_ROW_8_453 VGND VPWR sky130_fd_sc_hd__tapvpwrvgnd_1
X_10103_ clknet_leaf_141_clk _00233_ VGND VGND VPWR VPWR cpuregs\[28\]\[5\] sky130_fd_sc_hd__dfxtp_1
XFILLER_1_821 VPWR VGND VPWR VGND sky130_ef_sc_hd__decap_12
XFILLER_95_408 VGND VGND VPWR VPWR sky130_fd_sc_hd__decap_3
X_11083_ clknet_leaf_25_clk _01140_ VGND VGND VPWR VPWR cpuregs\[24\]\[14\] sky130_fd_sc_hd__dfxtp_1
XFILLER_49_803 VGND VGND VPWR VPWR sky130_fd_sc_hd__decap_6
XFILLER_1_865 VPWR VGND VPWR VGND sky130_ef_sc_hd__decap_12
X_10034_ clknet_leaf_126_clk _00164_ VGND VGND VPWR VPWR cpuregs\[13\]\[0\] sky130_fd_sc_hd__dfxtp_1
XFILLER_124_82 VGND VGND VPWR VPWR sky130_fd_sc_hd__fill_2
XFILLER_84_64 VPWR VGND VPWR VGND sky130_ef_sc_hd__decap_12
XFILLER_76_688 VPWR VGND VPWR VGND sky130_ef_sc_hd__decap_12
XFILLER_63_349 VGND VGND VPWR VPWR sky130_fd_sc_hd__decap_3
XFILLER_44_530 VGND VGND VPWR VPWR sky130_fd_sc_hd__fill_2
XTAP_TAPCELL_ROW_27_761 VGND VPWR sky130_fd_sc_hd__tapvpwrvgnd_1
X_10936_ clknet_leaf_128_clk _00998_ VGND VGND VPWR VPWR reg_sh\[1\] sky130_fd_sc_hd__dfxtp_1
XTAP_TAPCELL_ROW_67_1397 VGND VPWR sky130_fd_sc_hd__tapvpwrvgnd_1
X_10867_ clknet_leaf_147_clk _00929_ VGND VGND VPWR VPWR cpuregs\[1\]\[11\] sky130_fd_sc_hd__dfxtp_1
XFILLER_44_585 VGND VGND VPWR VPWR sky130_fd_sc_hd__decap_3
XFILLER_129_134 VGND VGND VPWR VPWR sky130_fd_sc_hd__decap_4
X_10798_ clknet_leaf_103_clk _00863_ VGND VGND VPWR VPWR instr_sltiu sky130_fd_sc_hd__dfxtp_1
XFILLER_31_279 VGND VGND VPWR VPWR sky130_fd_sc_hd__fill_1
X_11419_ clknet_leaf_22_clk _01463_ VGND VGND VPWR VPWR cpuregs\[8\]\[17\] sky130_fd_sc_hd__dfxtp_1
XFILLER_141_833 VGND VGND VPWR VPWR sky130_fd_sc_hd__decap_6
XFILLER_99_736 VGND VGND VPWR VPWR sky130_fd_sc_hd__decap_4
XFILLER_99_769 VPWR VGND VPWR VGND sky130_ef_sc_hd__decap_12
XFILLER_87_909 VGND VGND VPWR VPWR sky130_fd_sc_hd__decap_3
XFILLER_4_681 VPWR VGND VPWR VGND sky130_ef_sc_hd__decap_12
XFILLER_141_877 VPWR VGND VPWR VGND sky130_ef_sc_hd__decap_12
XFILLER_140_365 VGND VGND VPWR VPWR sky130_fd_sc_hd__decap_8
X_06960_ decoded_imm\[24\] net187 VGND VGND VPWR VPWR _03374_ sky130_fd_sc_hd__xnor2_1
XFILLER_86_419 VGND VGND VPWR VPWR sky130_fd_sc_hd__fill_1
XFILLER_67_600 VGND VGND VPWR VPWR sky130_fd_sc_hd__fill_1
Xclkbuf_leaf_3_clk clknet_4_1_0_clk VGND VGND VPWR VPWR clknet_leaf_3_clk sky130_fd_sc_hd__clkbuf_8
X_06891_ cpuregs\[16\]\[21\] cpuregs\[17\]\[21\] cpuregs\[18\]\[21\] cpuregs\[19\]\[21\]
+ _00012_ _00013_ VGND VGND VPWR VPWR _03308_ sky130_fd_sc_hd__mux4_1
X_05911_ _02069_ _02237_ VGND VGND VPWR VPWR _02464_ sky130_fd_sc_hd__and2b_1
XFILLER_79_493 VGND VGND VPWR VPWR sky130_fd_sc_hd__decap_6
XFILLER_67_644 VGND VGND VPWR VPWR sky130_fd_sc_hd__fill_2
X_05842_ _02087_ _02237_ VGND VGND VPWR VPWR _02403_ sky130_fd_sc_hd__and2b_1
XFILLER_104_19 VGND VGND VPWR VPWR sky130_fd_sc_hd__decap_8
XFILLER_94_452 VGND VGND VPWR VPWR sky130_fd_sc_hd__decap_4
XTAP_TAPCELL_ROW_87_1718 VGND VPWR sky130_fd_sc_hd__tapvpwrvgnd_1
XFILLER_66_121 VGND VGND VPWR VPWR sky130_fd_sc_hd__decap_4
X_08630_ cpuregs\[12\]\[8\] cpuregs\[13\]\[8\] cpuregs\[14\]\[8\] cpuregs\[15\]\[8\]
+ net278 net273 VGND VGND VPWR VPWR _04324_ sky130_fd_sc_hd__mux4_1
XTAP_TAPCELL_ROW_87_1729 VGND VPWR sky130_fd_sc_hd__tapvpwrvgnd_1
XFILLER_82_636 VGND VGND VPWR VPWR sky130_fd_sc_hd__fill_1
XFILLER_81_113 VGND VGND VPWR VPWR sky130_fd_sc_hd__fill_2
XFILLER_81_124 VGND VGND VPWR VPWR sky130_fd_sc_hd__decap_8
X_05773_ _02145_ _02335_ _02144_ VGND VGND VPWR VPWR _02341_ sky130_fd_sc_hd__a21o_1
X_08561_ net122 _01586_ _04258_ _04259_ VGND VGND VPWR VPWR _00809_ sky130_fd_sc_hd__a22o_1
XFILLER_120_29 VPWR VGND VPWR VGND sky130_ef_sc_hd__decap_12
X_08492_ net76 net45 _04208_ VGND VGND VPWR VPWR _00790_ sky130_fd_sc_hd__mux2_1
X_07512_ cpuregs\[26\]\[30\] _02709_ _03568_ VGND VGND VPWR VPWR _00450_ sky130_fd_sc_hd__mux2_1
X_07443_ cpuregs\[27\]\[27\] _02696_ _03566_ VGND VGND VPWR VPWR _00383_ sky130_fd_sc_hd__mux2_1
X_07374_ _02688_ cpuregs\[9\]\[25\] _03563_ VGND VGND VPWR VPWR _00317_ sky130_fd_sc_hd__mux2_1
XTAP_TAPCELL_ROW_118_2217 VGND VPWR sky130_fd_sc_hd__tapvpwrvgnd_1
X_09113_ _04758_ VGND VGND VPWR VPWR _04759_ sky130_fd_sc_hd__inv_2
XFILLER_10_419 VGND VGND VPWR VPWR sky130_fd_sc_hd__fill_1
XFILLER_13_27 VPWR VGND VPWR VGND sky130_ef_sc_hd__decap_12
XFILLER_22_279 VGND VGND VPWR VPWR sky130_fd_sc_hd__fill_1
XFILLER_129_27 VPWR VGND VPWR VGND sky130_ef_sc_hd__decap_12
XFILLER_108_307 VGND VGND VPWR VPWR sky130_fd_sc_hd__fill_1
X_06325_ _02760_ _02761_ _00015_ VGND VGND VPWR VPWR _02762_ sky130_fd_sc_hd__mux2_1
X_06256_ reg_pc\[28\] _02694_ VGND VGND VPWR VPWR _02698_ sky130_fd_sc_hd__xor2_1
X_09044_ net270 _04714_ VGND VGND VPWR VPWR _04715_ sky130_fd_sc_hd__or2_1
XTAP_TAPCELL_ROW_131_2428 VGND VPWR sky130_fd_sc_hd__tapvpwrvgnd_1
X_05207_ reg_pc\[12\] decoded_imm\[12\] VGND VGND VPWR VPWR _01810_ sky130_fd_sc_hd__or2_1
XFILLER_145_15 VPWR VGND VPWR VGND sky130_ef_sc_hd__decap_12
XFILLER_89_213 VGND VGND VPWR VPWR sky130_fd_sc_hd__decap_8
X_06187_ reg_out\[15\] alu_out_q\[15\] net594 VGND VGND VPWR VPWR _02642_ sky130_fd_sc_hd__mux2_1
XFILLER_2_607 VGND VGND VPWR VPWR sky130_fd_sc_hd__decap_8
X_05138_ net6 net24 net606 VGND VGND VPWR VPWR _01747_ sky130_fd_sc_hd__mux2_1
XFILLER_104_579 VGND VGND VPWR VPWR sky130_fd_sc_hd__decap_8
X_05069_ net9 _01669_ net130 net12 _01682_ VGND VGND VPWR VPWR _01683_ sky130_fd_sc_hd__a221o_1
XTAP_TAPCELL_ROW_5_412 VGND VPWR sky130_fd_sc_hd__tapvpwrvgnd_1
X_09946_ clknet_leaf_138_clk _00076_ VGND VGND VPWR VPWR net200 sky130_fd_sc_hd__dfxtp_4
XFILLER_100_730 VPWR VGND VPWR VGND sky130_ef_sc_hd__decap_12
XFILLER_58_611 VGND VGND VPWR VPWR sky130_fd_sc_hd__fill_1
XTAP_TAPCELL_ROW_51_1143 VGND VPWR sky130_fd_sc_hd__tapvpwrvgnd_1
XTAP_TAPCELL_ROW_146_2671 VGND VPWR sky130_fd_sc_hd__tapvpwrvgnd_1
XTAP_TAPCELL_ROW_146_2660 VGND VPWR sky130_fd_sc_hd__tapvpwrvgnd_1
XFILLER_73_603 VGND VGND VPWR VPWR sky130_fd_sc_hd__fill_1
XTAP_TAPCELL_ROW_51_1154 VGND VPWR sky130_fd_sc_hd__tapvpwrvgnd_1
X_09877_ cpuregs\[0\]\[7\] VGND VGND VPWR VPWR _01485_ sky130_fd_sc_hd__clkbuf_1
XFILLER_38_79 VGND VGND VPWR VPWR sky130_fd_sc_hd__decap_4
X_08828_ cpuregs\[28\]\[19\] cpuregs\[29\]\[19\] cpuregs\[30\]\[19\] cpuregs\[31\]\[19\]
+ net280 net274 VGND VGND VPWR VPWR _04511_ sky130_fd_sc_hd__mux4_1
XPHY_EDGE_ROW_79_Right_79 VGND VGND VPWR VPWR sky130_fd_sc_hd__decap_3
XFILLER_57_165 VGND VGND VPWR VPWR sky130_fd_sc_hd__decap_3
X_08759_ cpuregs\[0\]\[15\] cpuregs\[1\]\[15\] cpuregs\[2\]\[15\] cpuregs\[3\]\[15\]
+ net277 net272 VGND VGND VPWR VPWR _04446_ sky130_fd_sc_hd__mux4_1
XFILLER_73_647 VGND VGND VPWR VPWR sky130_fd_sc_hd__fill_1
XFILLER_45_349 VGND VGND VPWR VPWR sky130_fd_sc_hd__decap_4
XFILLER_41_500 VGND VGND VPWR VPWR sky130_fd_sc_hd__decap_4
XFILLER_81_691 VPWR VGND VPWR VGND sky130_ef_sc_hd__decap_12
X_10721_ clknet_leaf_17_clk _00818_ VGND VGND VPWR VPWR net206 sky130_fd_sc_hd__dfxtp_2
XTAP_TAPCELL_ROW_24_720 VGND VPWR sky130_fd_sc_hd__tapvpwrvgnd_1
XFILLER_26_585 VGND VGND VPWR VPWR sky130_fd_sc_hd__decap_3
X_10652_ clknet_leaf_131_clk _04879_ VGND VGND VPWR VPWR reg_out\[10\] sky130_fd_sc_hd__dfxtp_1
X_10583_ clknet_leaf_109_clk _00713_ VGND VGND VPWR VPWR count_cycle\[6\] sky130_fd_sc_hd__dfxtp_1
XPHY_EDGE_ROW_88_Right_88 VGND VGND VPWR VPWR sky130_fd_sc_hd__decap_3
XFILLER_135_682 VGND VGND VPWR VPWR sky130_fd_sc_hd__fill_1
XFILLER_135_671 VGND VGND VPWR VPWR sky130_fd_sc_hd__fill_1
X_11204_ clknet_leaf_23_clk _01251_ VGND VGND VPWR VPWR cpuregs\[29\]\[29\] sky130_fd_sc_hd__dfxtp_1
XFILLER_123_833 VGND VGND VPWR VPWR sky130_fd_sc_hd__decap_6
XFILLER_122_321 VPWR VGND VPWR VGND sky130_ef_sc_hd__decap_12
XFILLER_69_909 VGND VGND VPWR VPWR sky130_fd_sc_hd__decap_3
X_11135_ clknet_leaf_66_clk _01182_ VGND VGND VPWR VPWR cpuregs\[31\]\[24\] sky130_fd_sc_hd__dfxtp_1
XFILLER_123_877 VGND VGND VPWR VPWR sky130_fd_sc_hd__fill_1
XPHY_EDGE_ROW_79_Left_233 VGND VGND VPWR VPWR sky130_fd_sc_hd__decap_3
X_11066_ clknet_leaf_97_clk _01123_ VGND VGND VPWR VPWR mem_rdata_q\[29\] sky130_fd_sc_hd__dfxtp_2
XFILLER_49_633 VPWR VGND VPWR VGND sky130_ef_sc_hd__decap_12
XFILLER_1_673 VPWR VGND VPWR VGND sky130_ef_sc_hd__decap_12
XPHY_EDGE_ROW_97_Right_97 VGND VGND VPWR VPWR sky130_fd_sc_hd__decap_3
XFILLER_88_290 VGND VGND VPWR VPWR sky130_fd_sc_hd__fill_1
X_10017_ clknet_leaf_15_clk _00147_ VGND VGND VPWR VPWR cpuregs\[30\]\[15\] sky130_fd_sc_hd__dfxtp_1
XFILLER_37_806 VPWR VGND VPWR VGND sky130_ef_sc_hd__decap_12
XTAP_TAPCELL_ROW_69_1437 VGND VPWR sky130_fd_sc_hd__tapvpwrvgnd_1
XFILLER_64_636 VGND VGND VPWR VPWR sky130_fd_sc_hd__decap_8
XFILLER_63_135 VPWR VGND VPWR VGND sky130_ef_sc_hd__decap_12
XFILLER_63_113 VGND VGND VPWR VPWR sky130_fd_sc_hd__fill_2
XFILLER_36_349 VGND VGND VPWR VPWR sky130_fd_sc_hd__decap_4
XFILLER_45_883 VPWR VGND VPWR VGND sky130_ef_sc_hd__decap_12
XPHY_EDGE_ROW_88_Left_242 VGND VGND VPWR VPWR sky130_fd_sc_hd__decap_3
XTAP_TAPCELL_ROW_82_1648 VGND VPWR sky130_fd_sc_hd__tapvpwrvgnd_1
XTAP_TAPCELL_ROW_82_1637 VGND VPWR sky130_fd_sc_hd__tapvpwrvgnd_1
XFILLER_44_371 VPWR VGND VPWR VGND sky130_ef_sc_hd__decap_12
X_10919_ clknet_leaf_30_clk _00981_ VGND VGND VPWR VPWR net152 sky130_fd_sc_hd__dfxtp_1
XFILLER_118_605 VGND VGND VPWR VPWR sky130_fd_sc_hd__fill_2
XFILLER_74_3 VGND VGND VPWR VPWR sky130_fd_sc_hd__decap_3
X_07090_ reg_pc\[28\] _02751_ _03499_ _02715_ VGND VGND VPWR VPWR _03500_ sky130_fd_sc_hd__a211o_1
X_06110_ net604 net600 _01628_ VGND VGND VPWR VPWR _02580_ sky130_fd_sc_hd__o21a_4
XFILLER_145_446 VGND VGND VPWR VPWR sky130_fd_sc_hd__fill_2
X_06041_ _01621_ _01635_ _02236_ _02514_ VGND VGND VPWR VPWR _02515_ sky130_fd_sc_hd__a31o_1
XFILLER_145_479 VGND VGND VPWR VPWR sky130_fd_sc_hd__fill_1
XFILLER_114_811 VGND VGND VPWR VPWR sky130_fd_sc_hd__fill_1
XTAP_TAPCELL_ROW_113_2147 VGND VPWR sky130_fd_sc_hd__tapvpwrvgnd_1
XTAP_TAPCELL_ROW_113_2136 VGND VPWR sky130_fd_sc_hd__tapvpwrvgnd_1
XTAP_TAPCELL_ROW_97_1891 VGND VPWR sky130_fd_sc_hd__tapvpwrvgnd_1
XTAP_TAPCELL_ROW_97_1880 VGND VPWR sky130_fd_sc_hd__tapvpwrvgnd_1
XPHY_EDGE_ROW_97_Left_251 VGND VGND VPWR VPWR sky130_fd_sc_hd__decap_3
XTAP_TAPCELL_ROW_10_491 VGND VPWR sky130_fd_sc_hd__tapvpwrvgnd_1
XFILLER_125_181 VGND VGND VPWR VPWR sky130_fd_sc_hd__fill_1
XFILLER_141_663 VGND VGND VPWR VPWR sky130_fd_sc_hd__decap_8
XFILLER_113_354 VGND VGND VPWR VPWR sky130_fd_sc_hd__fill_2
XFILLER_101_505 VGND VGND VPWR VPWR sky130_fd_sc_hd__decap_4
X_07992_ _01547_ reg_next_pc\[10\] _01645_ _03697_ VGND VGND VPWR VPWR _03815_ sky130_fd_sc_hd__a22o_1
X_09800_ _02612_ cpuregs\[8\]\[7\] _04875_ VGND VGND VPWR VPWR _01453_ sky130_fd_sc_hd__mux2_1
X_06943_ cpuregs\[4\]\[23\] cpuregs\[5\]\[23\] cpuregs\[6\]\[23\] cpuregs\[7\]\[23\]
+ net267 net260 VGND VGND VPWR VPWR _03358_ sky130_fd_sc_hd__mux4_1
XFILLER_113_387 VGND VGND VPWR VPWR sky130_fd_sc_hd__fill_1
XFILLER_101_516 VPWR VGND VPWR VGND sky130_ef_sc_hd__decap_12
X_09731_ _02598_ cpuregs\[6\]\[4\] _04873_ VGND VGND VPWR VPWR _01386_ sky130_fd_sc_hd__mux2_1
XFILLER_140_195 VGND VGND VPWR VPWR sky130_fd_sc_hd__fill_1
XFILLER_95_750 VGND VGND VPWR VPWR sky130_fd_sc_hd__decap_3
XFILLER_86_249 VGND VGND VPWR VPWR sky130_fd_sc_hd__decap_3
X_06874_ _03283_ _03290_ _03291_ _01581_ _01580_ VGND VGND VPWR VPWR _03292_ sky130_fd_sc_hd__a221o_1
X_09662_ cpuregs\[4\]\[1\] _02588_ _04871_ VGND VGND VPWR VPWR _01319_ sky130_fd_sc_hd__mux2_1
XFILLER_131_39 VPWR VGND VPWR VGND sky130_ef_sc_hd__decap_12
X_05825_ net255 _02384_ _02385_ _02387_ VGND VGND VPWR VPWR alu_out\[20\] sky130_fd_sc_hd__a31o_1
XFILLER_55_647 VGND VGND VPWR VPWR sky130_fd_sc_hd__decap_4
X_08613_ cpuregs\[8\]\[7\] cpuregs\[9\]\[7\] cpuregs\[10\]\[7\] cpuregs\[11\]\[7\]
+ net278 net273 VGND VGND VPWR VPWR _04308_ sky130_fd_sc_hd__mux4_1
X_09593_ _02581_ _03549_ VGND VGND VPWR VPWR _04868_ sky130_fd_sc_hd__or2_4
XFILLER_82_477 VGND VGND VPWR VPWR sky130_fd_sc_hd__decap_3
X_05756_ _02197_ _02325_ instr_sub VGND VGND VPWR VPWR _02326_ sky130_fd_sc_hd__o21ai_1
X_08544_ _00010_ _04240_ _04244_ VGND VGND VPWR VPWR _04245_ sky130_fd_sc_hd__a21oi_1
XFILLER_36_861 VGND VGND VPWR VPWR sky130_fd_sc_hd__decap_6
XTAP_TAPCELL_ROW_141_2590 VGND VPWR sky130_fd_sc_hd__tapvpwrvgnd_1
XFILLER_24_15 VPWR VGND VPWR VGND sky130_ef_sc_hd__decap_12
XFILLER_35_382 VGND VGND VPWR VPWR sky130_fd_sc_hd__decap_8
XFILLER_51_853 VGND VGND VPWR VPWR sky130_fd_sc_hd__decap_6
X_05687_ _02141_ _02264_ _02265_ VGND VGND VPWR VPWR _02266_ sky130_fd_sc_hd__o21a_1
X_08475_ net89 net58 _04208_ VGND VGND VPWR VPWR _00773_ sky130_fd_sc_hd__mux2_1
XFILLER_35_393 VGND VGND VPWR VPWR sky130_fd_sc_hd__decap_8
X_07426_ cpuregs\[27\]\[10\] _02624_ _03566_ VGND VGND VPWR VPWR _00366_ sky130_fd_sc_hd__mux2_1
XFILLER_51_897 VGND VGND VPWR VPWR sky130_fd_sc_hd__fill_1
XFILLER_50_363 VGND VGND VPWR VPWR sky130_fd_sc_hd__fill_1
XFILLER_149_774 VGND VGND VPWR VPWR sky130_fd_sc_hd__decap_8
X_07357_ _02616_ cpuregs\[9\]\[8\] _03563_ VGND VGND VPWR VPWR _00300_ sky130_fd_sc_hd__mux2_1
XFILLER_10_238 VPWR VGND VPWR VGND sky130_ef_sc_hd__decap_12
XFILLER_149_785 VPWR VGND VPWR VGND sky130_ef_sc_hd__decap_12
XFILLER_6_209 VPWR VGND VPWR VGND sky130_ef_sc_hd__decap_12
X_06308_ net606 _01641_ _02744_ net197 VGND VGND VPWR VPWR _02746_ sky130_fd_sc_hd__a22o_1
X_09027_ cpuregs\[8\]\[30\] cpuregs\[9\]\[30\] cpuregs\[10\]\[30\] cpuregs\[11\]\[30\]
+ net275 net271 VGND VGND VPWR VPWR _04699_ sky130_fd_sc_hd__mux4_1
X_07288_ cpuregs\[28\]\[6\] _02607_ net249 VGND VGND VPWR VPWR _00234_ sky130_fd_sc_hd__mux2_1
XFILLER_151_405 VGND VGND VPWR VPWR sky130_fd_sc_hd__decap_8
XFILLER_124_619 VGND VGND VPWR VPWR sky130_fd_sc_hd__fill_1
X_06239_ reg_out\[25\] alu_out_q\[25\] net587 VGND VGND VPWR VPWR _02684_ sky130_fd_sc_hd__mux2_1
XFILLER_117_671 VGND VGND VPWR VPWR sky130_fd_sc_hd__fill_1
XFILLER_104_321 VGND VGND VPWR VPWR sky130_fd_sc_hd__decap_8
XFILLER_2_437 VGND VGND VPWR VPWR sky130_fd_sc_hd__fill_1
XTAP_TAPCELL_ROW_148_2700 VGND VPWR sky130_fd_sc_hd__tapvpwrvgnd_1
XFILLER_116_192 VGND VGND VPWR VPWR sky130_fd_sc_hd__decap_4
XFILLER_104_365 VGND VGND VPWR VPWR sky130_fd_sc_hd__fill_1
XFILLER_78_717 VGND VGND VPWR VPWR sky130_fd_sc_hd__fill_2
XFILLER_120_825 VPWR VGND VPWR VGND sky130_ef_sc_hd__decap_12
XFILLER_77_216 VGND VGND VPWR VPWR sky130_fd_sc_hd__decap_8
XPHY_EDGE_ROW_130_Right_130 VGND VGND VPWR VPWR sky130_fd_sc_hd__decap_3
X_09929_ clknet_leaf_35_clk _00064_ VGND VGND VPWR VPWR cpuregs\[11\]\[27\] sky130_fd_sc_hd__dfxtp_1
XFILLER_120_869 VPWR VGND VPWR VGND sky130_ef_sc_hd__decap_12
XFILLER_100_560 VGND VGND VPWR VPWR sky130_fd_sc_hd__decap_8
XFILLER_86_794 VGND VGND VPWR VPWR sky130_fd_sc_hd__decap_3
XFILLER_73_400 VGND VGND VPWR VPWR sky130_fd_sc_hd__decap_4
XFILLER_58_485 VPWR VGND VPWR VGND sky130_ef_sc_hd__decap_12
XFILLER_19_839 VGND VGND VPWR VPWR sky130_fd_sc_hd__fill_1
XTAP_TAPCELL_ROW_29_801 VGND VPWR sky130_fd_sc_hd__tapvpwrvgnd_1
XFILLER_100_582 VGND VGND VPWR VPWR sky130_fd_sc_hd__decap_6
XFILLER_85_293 VGND VGND VPWR VPWR sky130_fd_sc_hd__decap_8
XFILLER_73_444 VGND VGND VPWR VPWR sky130_fd_sc_hd__decap_4
XFILLER_65_55 VGND VGND VPWR VPWR sky130_fd_sc_hd__fill_1
XFILLER_45_113 VPWR VGND VPWR VGND sky130_ef_sc_hd__decap_12
XFILLER_73_466 VGND VGND VPWR VPWR sky130_fd_sc_hd__fill_1
XFILLER_65_77 VGND VGND VPWR VPWR sky130_fd_sc_hd__fill_2
XFILLER_73_499 VGND VGND VPWR VPWR sky130_fd_sc_hd__fill_2
XFILLER_14_511 VGND VGND VPWR VPWR sky130_fd_sc_hd__fill_1
XFILLER_81_54 VGND VGND VPWR VPWR sky130_fd_sc_hd__fill_2
XTAP_TAPCELL_ROW_64_1356 VGND VPWR sky130_fd_sc_hd__tapvpwrvgnd_1
X_10704_ clknet_leaf_101_clk _00802_ VGND VGND VPWR VPWR mem_do_prefetch sky130_fd_sc_hd__dfxtp_2
X_10635_ clknet_leaf_82_clk _00765_ VGND VGND VPWR VPWR count_cycle\[58\] sky130_fd_sc_hd__dfxtp_1
XFILLER_127_402 VGND VGND VPWR VPWR sky130_fd_sc_hd__decap_4
Xclkload109 clknet_leaf_109_clk VGND VGND VPWR VPWR clkload109/Y sky130_fd_sc_hd__inv_8
X_10566_ clknet_leaf_74_clk _00696_ VGND VGND VPWR VPWR reg_next_pc\[21\] sky130_fd_sc_hd__dfxtp_1
XFILLER_6_754 VGND VGND VPWR VPWR sky130_fd_sc_hd__fill_2
X_10497_ clknet_leaf_86_clk _00627_ VGND VGND VPWR VPWR count_instr\[46\] sky130_fd_sc_hd__dfxtp_1
XFILLER_122_162 VGND VGND VPWR VPWR sky130_fd_sc_hd__fill_2
X_11118_ clknet_leaf_143_clk _01165_ VGND VGND VPWR VPWR cpuregs\[31\]\[7\] sky130_fd_sc_hd__dfxtp_1
XFILLER_68_249 VGND VGND VPWR VPWR sky130_fd_sc_hd__decap_3
Xinput7 mem_rdata[15] VGND VGND VPWR VPWR net7 sky130_fd_sc_hd__buf_1
X_11049_ clknet_leaf_103_clk _01106_ VGND VGND VPWR VPWR mem_rdata_q\[12\] sky130_fd_sc_hd__dfxtp_2
XFILLER_49_485 VGND VGND VPWR VPWR sky130_fd_sc_hd__fill_1
XFILLER_37_603 VGND VGND VPWR VPWR sky130_fd_sc_hd__fill_1
XFILLER_64_433 VPWR VGND VPWR VGND sky130_ef_sc_hd__decap_12
X_05610_ _02124_ _02192_ VGND VGND VPWR VPWR _02193_ sky130_fd_sc_hd__nand2_1
XFILLER_18_861 VGND VGND VPWR VPWR sky130_fd_sc_hd__decap_6
XFILLER_25_809 VPWR VGND VPWR VGND sky130_ef_sc_hd__decap_12
X_06590_ _01579_ _03017_ VGND VGND VPWR VPWR _03018_ sky130_fd_sc_hd__or2_1
XFILLER_52_639 VGND VGND VPWR VPWR sky130_fd_sc_hd__fill_2
X_05541_ _02121_ _02123_ VGND VGND VPWR VPWR _02124_ sky130_fd_sc_hd__or2_2
XFILLER_33_853 VPWR VGND VPWR VGND sky130_ef_sc_hd__decap_12
X_05472_ net189 net221 VGND VGND VPWR VPWR _02055_ sky130_fd_sc_hd__nor2_1
XFILLER_20_503 VGND VGND VPWR VPWR sky130_fd_sc_hd__decap_8
XFILLER_32_374 VGND VGND VPWR VPWR sky130_fd_sc_hd__fill_1
XFILLER_33_897 VGND VGND VPWR VPWR sky130_fd_sc_hd__fill_2
X_08260_ net453 net455 net34 VGND VGND VPWR VPWR _04060_ sky130_fd_sc_hd__o21ai_1
X_08191_ decoded_imm_j\[20\] _03713_ VGND VGND VPWR VPWR _03998_ sky130_fd_sc_hd__nor2_1
X_07211_ cpuregs\[30\]\[29\] _02704_ net252 VGND VGND VPWR VPWR _00161_ sky130_fd_sc_hd__mux2_1
XTAP_TAPCELL_ROW_99_1920 VGND VPWR sky130_fd_sc_hd__tapvpwrvgnd_1
XTAP_TAPCELL_ROW_15_572 VGND VPWR sky130_fd_sc_hd__tapvpwrvgnd_1
XFILLER_20_569 VGND VGND VPWR VPWR sky130_fd_sc_hd__decap_8
X_07142_ latched_rd\[2\] latched_rd\[3\] latched_rd\[4\] VGND VGND VPWR VPWR _03549_
+ sky130_fd_sc_hd__or3_4
XFILLER_146_755 VGND VGND VPWR VPWR sky130_fd_sc_hd__fill_1
XFILLER_146_788 VPWR VGND VPWR VGND sky130_ef_sc_hd__decap_12
X_07073_ net187 _02721_ _02744_ _03482_ VGND VGND VPWR VPWR _03483_ sky130_fd_sc_hd__o211a_1
XFILLER_145_287 VPWR VGND VPWR VGND sky130_ef_sc_hd__decap_12
XFILLER_133_449 VGND VGND VPWR VPWR sky130_fd_sc_hd__decap_6
X_06024_ decoded_imm_j\[1\] _01115_ _02513_ VGND VGND VPWR VPWR _00028_ sky130_fd_sc_hd__mux2_1
XFILLER_114_641 VGND VGND VPWR VPWR sky130_fd_sc_hd__decap_3
XFILLER_99_341 VGND VGND VPWR VPWR sky130_fd_sc_hd__fill_1
XFILLER_113_162 VGND VGND VPWR VPWR sky130_fd_sc_hd__decap_6
XFILLER_59_249 VPWR VGND VPWR VGND sky130_ef_sc_hd__decap_12
X_07975_ _03776_ _03788_ VGND VGND VPWR VPWR _03799_ sky130_fd_sc_hd__or2_1
XFILLER_19_15 VPWR VGND VPWR VGND sky130_ef_sc_hd__decap_12
XFILLER_142_27 VGND VGND VPWR VPWR sky130_fd_sc_hd__fill_1
X_09714_ _02665_ cpuregs\[5\]\[20\] _04872_ VGND VGND VPWR VPWR _01370_ sky130_fd_sc_hd__mux2_1
X_06926_ _00015_ _03338_ _03341_ _02735_ VGND VGND VPWR VPWR _03342_ sky130_fd_sc_hd__o211a_1
XTAP_TAPCELL_ROW_126_2349 VGND VPWR sky130_fd_sc_hd__tapvpwrvgnd_1
X_09645_ _02657_ cpuregs\[22\]\[18\] _04869_ VGND VGND VPWR VPWR _01304_ sky130_fd_sc_hd__mux2_1
X_06857_ _01564_ net254 VGND VGND VPWR VPWR _03275_ sky130_fd_sc_hd__nand2_1
XFILLER_67_293 VPWR VGND VPWR VGND sky130_ef_sc_hd__decap_12
XFILLER_27_113 VPWR VGND VPWR VGND sky130_ef_sc_hd__decap_12
X_05808_ _02105_ _02364_ _02104_ VGND VGND VPWR VPWR _02372_ sky130_fd_sc_hd__o21ai_1
XFILLER_82_241 VGND VGND VPWR VPWR sky130_fd_sc_hd__decap_8
XFILLER_55_466 VGND VGND VPWR VPWR sky130_fd_sc_hd__fill_1
XFILLER_27_157 VGND VGND VPWR VPWR sky130_fd_sc_hd__decap_8
XFILLER_43_617 VGND VGND VPWR VPWR sky130_fd_sc_hd__decap_8
X_06788_ _03204_ _03207_ _03208_ _00016_ _01580_ VGND VGND VPWR VPWR _03209_ sky130_fd_sc_hd__a221o_1
XFILLER_83_797 VGND VGND VPWR VPWR sky130_fd_sc_hd__fill_1
XFILLER_70_436 VPWR VGND VPWR VGND sky130_ef_sc_hd__decap_12
X_09576_ cpuregs\[29\]\[15\] _02646_ net239 VGND VGND VPWR VPWR _01237_ sky130_fd_sc_hd__mux2_1
XFILLER_15_319 VGND VGND VPWR VPWR sky130_fd_sc_hd__fill_1
X_05739_ _02118_ _02237_ _02238_ _02117_ VGND VGND VPWR VPWR _02311_ sky130_fd_sc_hd__a22o_1
X_08527_ _01558_ _04228_ VGND VGND VPWR VPWR _04229_ sky130_fd_sc_hd__or2_1
X_08458_ cpuregs\[20\]\[31\] cpuregs\[21\]\[31\] net264 VGND VGND VPWR VPWR _04195_
+ sky130_fd_sc_hd__mux2_1
XTAP_TAPCELL_ROW_34_870 VGND VPWR sky130_fd_sc_hd__tapvpwrvgnd_1
XTAP_TAPCELL_ROW_46_1064 VGND VPWR sky130_fd_sc_hd__tapvpwrvgnd_1
XTAP_TAPCELL_ROW_46_1075 VGND VPWR sky130_fd_sc_hd__tapvpwrvgnd_1
X_07409_ cpuregs\[14\]\[27\] _02696_ net247 VGND VGND VPWR VPWR _00351_ sky130_fd_sc_hd__mux2_1
XTAP_TAPCELL_ROW_34_881 VGND VPWR sky130_fd_sc_hd__tapvpwrvgnd_1
XFILLER_109_402 VGND VGND VPWR VPWR sky130_fd_sc_hd__fill_1
X_08389_ count_cycle\[47\] _04139_ count_cycle\[48\] VGND VGND VPWR VPWR _04142_ sky130_fd_sc_hd__a21o_1
XFILLER_51_57 VPWR VGND VPWR VGND sky130_ef_sc_hd__decap_12
X_10420_ clknet_leaf_122_clk _00550_ VGND VGND VPWR VPWR cpuregs\[17\]\[2\] sky130_fd_sc_hd__dfxtp_1
XFILLER_109_457 VGND VGND VPWR VPWR sky130_fd_sc_hd__fill_2
X_10351_ clknet_leaf_32_clk _00481_ VGND VGND VPWR VPWR cpuregs\[16\]\[29\] sky130_fd_sc_hd__dfxtp_1
X_10282_ clknet_leaf_67_clk _00412_ VGND VGND VPWR VPWR cpuregs\[15\]\[24\] sky130_fd_sc_hd__dfxtp_1
XFILLER_124_427 VGND VGND VPWR VPWR sky130_fd_sc_hd__fill_1
XFILLER_152_769 VPWR VGND VPWR VGND sky130_ef_sc_hd__decap_12
XFILLER_105_652 VGND VGND VPWR VPWR sky130_fd_sc_hd__fill_1
XFILLER_4_3 VPWR VGND VPWR VGND sky130_ef_sc_hd__decap_12
XFILLER_2_245 VGND VGND VPWR VPWR sky130_fd_sc_hd__decap_6
XFILLER_151_279 VGND VGND VPWR VPWR sky130_fd_sc_hd__fill_1
XFILLER_120_600 VGND VGND VPWR VPWR sky130_fd_sc_hd__decap_6
XFILLER_104_162 VPWR VGND VPWR VGND sky130_ef_sc_hd__decap_12
XFILLER_78_525 VGND VGND VPWR VPWR sky130_fd_sc_hd__fill_1
XFILLER_2_289 VPWR VGND VPWR VGND sky130_ef_sc_hd__decap_12
XFILLER_132_493 VGND VGND VPWR VPWR sky130_fd_sc_hd__decap_6
XFILLER_59_783 VGND VGND VPWR VPWR sky130_fd_sc_hd__fill_1
XFILLER_47_901 VGND VGND VPWR VPWR sky130_fd_sc_hd__fill_1
XFILLER_59_794 VPWR VGND VPWR VGND sky130_ef_sc_hd__decap_12
XFILLER_46_477 VPWR VGND VPWR VGND sky130_ef_sc_hd__decap_12
XFILLER_92_53 VGND VGND VPWR VPWR sky130_fd_sc_hd__decap_8
XFILLER_34_628 VPWR VGND VPWR VGND sky130_ef_sc_hd__decap_12
XFILLER_15_853 VPWR VGND VPWR VGND sky130_ef_sc_hd__decap_12
XFILLER_14_363 VGND VGND VPWR VPWR sky130_fd_sc_hd__fill_1
XFILLER_15_897 VPWR VGND VPWR VGND sky130_ef_sc_hd__decap_12
XTAP_TAPCELL_ROW_12_520 VGND VPWR sky130_fd_sc_hd__tapvpwrvgnd_1
XTAP_TAPCELL_ROW_12_531 VGND VPWR sky130_fd_sc_hd__tapvpwrvgnd_1
XFILLER_30_867 VGND VGND VPWR VPWR sky130_fd_sc_hd__fill_1
XFILLER_128_766 VPWR VGND VPWR VGND sky130_ef_sc_hd__decap_12
X_10618_ clknet_leaf_106_clk _00748_ VGND VGND VPWR VPWR count_cycle\[41\] sky130_fd_sc_hd__dfxtp_1
XFILLER_41_90 VPWR VGND VPWR VGND sky130_ef_sc_hd__decap_12
X_10549_ clknet_leaf_129_clk _00679_ VGND VGND VPWR VPWR reg_next_pc\[4\] sky130_fd_sc_hd__dfxtp_1
XFILLER_115_449 VGND VGND VPWR VPWR sky130_fd_sc_hd__fill_2
XTAP_TAPCELL_ROW_77_1569 VGND VPWR sky130_fd_sc_hd__tapvpwrvgnd_1
XTAP_TAPCELL_ROW_77_1558 VGND VPWR sky130_fd_sc_hd__tapvpwrvgnd_1
XFILLER_6_573 VPWR VGND VPWR VGND sky130_ef_sc_hd__decap_12
XFILLER_130_419 VGND VGND VPWR VPWR sky130_fd_sc_hd__fill_1
XFILLER_37_3 VPWR VGND VPWR VGND sky130_ef_sc_hd__decap_12
XTAP_TAPCELL_ROW_90_1769 VGND VPWR sky130_fd_sc_hd__tapvpwrvgnd_1
XFILLER_69_569 VGND VGND VPWR VPWR sky130_fd_sc_hd__decap_4
XFILLER_69_558 VGND VGND VPWR VPWR sky130_fd_sc_hd__fill_2
X_07760_ count_instr\[39\] _03644_ count_instr\[40\] VGND VGND VPWR VPWR _03647_ sky130_fd_sc_hd__a21o_1
X_04972_ _01588_ _01594_ _01601_ VGND VGND VPWR VPWR _01602_ sky130_fd_sc_hd__or3_1
XTAP_TAPCELL_ROW_108_2057 VGND VPWR sky130_fd_sc_hd__tapvpwrvgnd_1
X_06711_ decoded_imm\[14\] net176 _03110_ VGND VGND VPWR VPWR _03134_ sky130_fd_sc_hd__a21o_1
XFILLER_37_422 VGND VGND VPWR VPWR sky130_fd_sc_hd__fill_1
X_07691_ count_instr\[14\] net414 count_instr\[15\] VGND VGND VPWR VPWR _03603_ sky130_fd_sc_hd__a21o_1
XFILLER_80_701 VGND VGND VPWR VPWR sky130_fd_sc_hd__decap_8
XFILLER_53_904 VGND VGND VPWR VPWR sky130_fd_sc_hd__decap_8
X_09430_ _02588_ cpuregs\[19\]\[1\] _04863_ VGND VGND VPWR VPWR _01063_ sky130_fd_sc_hd__mux2_1
X_06642_ cpuregs\[12\]\[12\] cpuregs\[13\]\[12\] cpuregs\[14\]\[12\] cpuregs\[15\]\[12\]
+ net263 net259 VGND VGND VPWR VPWR _03068_ sky130_fd_sc_hd__mux4_1
XTAP_TAPCELL_ROW_121_2268 VGND VPWR sky130_fd_sc_hd__tapvpwrvgnd_1
X_09361_ decoded_imm\[15\] _04746_ _04824_ _04842_ VGND VGND VPWR VPWR _01015_ sky130_fd_sc_hd__o22a_1
X_06573_ reg_pc\[9\] _02751_ _03001_ _02715_ VGND VGND VPWR VPWR _03002_ sky130_fd_sc_hd__a211o_1
X_05524_ net179 net211 VGND VGND VPWR VPWR _02107_ sky130_fd_sc_hd__nor2_1
X_08312_ _04092_ _04093_ VGND VGND VPWR VPWR _00726_ sky130_fd_sc_hd__nor2_1
X_09292_ net149 net111 _04206_ VGND VGND VPWR VPWR _00978_ sky130_fd_sc_hd__mux2_1
XANTENNA_23 net184 VGND VGND VPWR VPWR sky130_fd_sc_hd__diode_2
X_08243_ _04043_ _04045_ VGND VGND VPWR VPWR _04046_ sky130_fd_sc_hd__and2_1
XANTENNA_12 _04869_ VGND VGND VPWR VPWR sky130_fd_sc_hd__diode_2
X_05455_ _02027_ _02030_ _02038_ VGND VGND VPWR VPWR _02039_ sky130_fd_sc_hd__a21oi_1
XANTENNA_34 _03054_ VGND VGND VPWR VPWR sky130_fd_sc_hd__diode_2
XFILLER_21_889 VGND VGND VPWR VPWR sky130_fd_sc_hd__decap_6
XPHY_EDGE_ROW_25_Left_179 VGND VGND VPWR VPWR sky130_fd_sc_hd__decap_3
X_08174_ _03981_ _03982_ net34 VGND VGND VPWR VPWR _00699_ sky130_fd_sc_hd__o21a_1
X_05386_ count_instr\[57\] instr_rdinstrh _01587_ _01975_ VGND VGND VPWR VPWR _01976_
+ sky130_fd_sc_hd__a211o_1
XFILLER_20_377 VPWR VGND VPWR VGND sky130_ef_sc_hd__decap_12
XFILLER_21_27 VPWR VGND VPWR VGND sky130_ef_sc_hd__decap_12
XFILLER_137_27 VPWR VGND VPWR VGND sky130_ef_sc_hd__decap_12
XFILLER_119_777 VGND VGND VPWR VPWR sky130_fd_sc_hd__decap_6
X_07125_ cpuregs\[20\]\[30\] cpuregs\[21\]\[30\] cpuregs\[22\]\[30\] cpuregs\[23\]\[30\]
+ net266 net261 VGND VGND VPWR VPWR _03533_ sky130_fd_sc_hd__mux4_1
X_07056_ cpuregs\[0\]\[27\] cpuregs\[1\]\[27\] cpuregs\[2\]\[27\] cpuregs\[3\]\[27\]
+ net266 net261 VGND VGND VPWR VPWR _03467_ sky130_fd_sc_hd__mux4_1
XFILLER_134_769 VPWR VGND VPWR VGND sky130_ef_sc_hd__decap_12
X_06007_ reg_out\[26\] reg_next_pc\[26\] net596 VGND VGND VPWR VPWR _02507_ sky130_fd_sc_hd__mux2_1
Xoutput152 net152 VGND VGND VPWR VPWR mem_wdata[25] sky130_fd_sc_hd__buf_2
Xoutput141 net141 VGND VGND VPWR VPWR mem_wdata[15] sky130_fd_sc_hd__buf_2
Xoutput130 net130 VGND VGND VPWR VPWR mem_la_wstrb[0] sky130_fd_sc_hd__buf_2
Xoutput185 net185 VGND VGND VPWR VPWR pcpi_rs1[22] sky130_fd_sc_hd__buf_2
XFILLER_153_15 VPWR VGND VPWR VGND sky130_ef_sc_hd__decap_12
XFILLER_133_279 VGND VGND VPWR VPWR sky130_fd_sc_hd__fill_1
Xoutput163 net163 VGND VGND VPWR VPWR mem_wdata[6] sky130_fd_sc_hd__buf_2
Xoutput174 net174 VGND VGND VPWR VPWR pcpi_rs1[12] sky130_fd_sc_hd__buf_2
XFILLER_87_322 VPWR VGND VPWR VGND sky130_ef_sc_hd__decap_12
Xoutput196 net196 VGND VGND VPWR VPWR pcpi_rs1[3] sky130_fd_sc_hd__buf_2
XFILLER_88_889 VGND VGND VPWR VPWR sky130_fd_sc_hd__decap_3
XPHY_EDGE_ROW_34_Left_188 VGND VGND VPWR VPWR sky130_fd_sc_hd__decap_3
X_07958_ _01547_ reg_next_pc\[7\] _01645_ _03694_ VGND VGND VPWR VPWR _03784_ sky130_fd_sc_hd__a22o_1
X_06909_ _01622_ _03323_ _03324_ VGND VGND VPWR VPWR _03325_ sky130_fd_sc_hd__and3_1
XFILLER_83_561 VGND VGND VPWR VPWR sky130_fd_sc_hd__decap_4
XTAP_TAPCELL_ROW_48_1104 VGND VPWR sky130_fd_sc_hd__tapvpwrvgnd_1
XFILLER_16_606 VGND VGND VPWR VPWR sky130_fd_sc_hd__decap_6
XFILLER_28_466 VGND VGND VPWR VPWR sky130_fd_sc_hd__fill_1
XTAP_TAPCELL_ROW_39_951 VGND VPWR sky130_fd_sc_hd__tapvpwrvgnd_1
XTAP_TAPCELL_ROW_39_962 VGND VPWR sky130_fd_sc_hd__tapvpwrvgnd_1
X_07889_ decoded_imm_j\[1\] _03687_ VGND VGND VPWR VPWR _03721_ sky130_fd_sc_hd__and2_1
X_09628_ _02588_ cpuregs\[22\]\[1\] _04869_ VGND VGND VPWR VPWR _01287_ sky130_fd_sc_hd__mux2_1
XFILLER_28_477 VGND VGND VPWR VPWR sky130_fd_sc_hd__decap_6
XFILLER_102_41 VPWR VGND VPWR VGND sky130_ef_sc_hd__decap_12
X_09559_ cpuregs\[23\]\[31\] _02712_ _04866_ VGND VGND VPWR VPWR _01221_ sky130_fd_sc_hd__mux2_1
XFILLER_102_85 VPWR VGND VPWR VGND sky130_ef_sc_hd__decap_12
XTAP_TAPCELL_ROW_61_1315 VGND VPWR sky130_fd_sc_hd__tapvpwrvgnd_1
XTAP_TAPCELL_ROW_61_1304 VGND VPWR sky130_fd_sc_hd__tapvpwrvgnd_1
XFILLER_24_661 VGND VGND VPWR VPWR sky130_fd_sc_hd__decap_8
XFILLER_141_3 VPWR VGND VPWR VGND sky130_ef_sc_hd__decap_12
XPHY_EDGE_ROW_43_Left_197 VGND VGND VPWR VPWR sky130_fd_sc_hd__decap_3
XFILLER_12_867 VGND VGND VPWR VPWR sky130_fd_sc_hd__fill_1
XFILLER_109_221 VGND VGND VPWR VPWR sky130_fd_sc_hd__decap_3
X_11452_ clknet_leaf_23_clk _01496_ VGND VGND VPWR VPWR cpuregs\[0\]\[18\] sky130_fd_sc_hd__dfxtp_1
XFILLER_8_849 VPWR VGND VPWR VGND sky130_ef_sc_hd__decap_12
Xwire246 _03567_ VGND VGND VPWR VPWR net246 sky130_fd_sc_hd__buf_12
X_10403_ clknet_leaf_22_clk _00533_ VGND VGND VPWR VPWR cpuregs\[20\]\[17\] sky130_fd_sc_hd__dfxtp_1
X_11383_ clknet_leaf_8_clk _01427_ VGND VGND VPWR VPWR cpuregs\[7\]\[13\] sky130_fd_sc_hd__dfxtp_1
XFILLER_109_287 VGND VGND VPWR VPWR sky130_fd_sc_hd__fill_1
X_10334_ clknet_leaf_9_clk _00464_ VGND VGND VPWR VPWR cpuregs\[16\]\[12\] sky130_fd_sc_hd__dfxtp_1
XFILLER_124_246 VGND VGND VPWR VPWR sky130_fd_sc_hd__decap_6
XTAP_TAPCELL_ROW_59_1277 VGND VPWR sky130_fd_sc_hd__tapvpwrvgnd_1
XFILLER_11_93 VPWR VGND VPWR VGND sky130_ef_sc_hd__decap_12
XFILLER_133_780 VGND VGND VPWR VPWR sky130_fd_sc_hd__decap_4
XFILLER_112_419 VGND VGND VPWR VPWR sky130_fd_sc_hd__fill_1
XFILLER_105_460 VGND VGND VPWR VPWR sky130_fd_sc_hd__fill_2
X_10265_ clknet_leaf_146_clk _00395_ VGND VGND VPWR VPWR cpuregs\[15\]\[7\] sky130_fd_sc_hd__dfxtp_1
XTAP_TAPCELL_ROW_72_1477 VGND VPWR sky130_fd_sc_hd__tapvpwrvgnd_1
X_10196_ clknet_leaf_119_clk _00326_ VGND VGND VPWR VPWR cpuregs\[14\]\[2\] sky130_fd_sc_hd__dfxtp_1
XFILLER_78_377 VGND VGND VPWR VPWR sky130_fd_sc_hd__fill_2
XTAP_TAPCELL_ROW_72_1488 VGND VPWR sky130_fd_sc_hd__tapvpwrvgnd_1
XFILLER_143_81 VGND VGND VPWR VPWR sky130_fd_sc_hd__decap_8
XFILLER_93_314 VGND VGND VPWR VPWR sky130_fd_sc_hd__fill_1
XFILLER_59_591 VPWR VGND VPWR VGND sky130_ef_sc_hd__decap_12
XFILLER_19_422 VGND VGND VPWR VPWR sky130_fd_sc_hd__decap_8
XFILLER_46_241 VGND VGND VPWR VPWR sky130_fd_sc_hd__fill_1
XTAP_TAPCELL_ROW_17_601 VGND VPWR sky130_fd_sc_hd__tapvpwrvgnd_1
XFILLER_19_499 VGND VGND VPWR VPWR sky130_fd_sc_hd__decap_4
XFILLER_34_414 VGND VGND VPWR VPWR sky130_fd_sc_hd__decap_6
XFILLER_147_316 VGND VGND VPWR VPWR sky130_fd_sc_hd__decap_4
X_05240_ reg_pc\[14\] decoded_imm\[14\] VGND VGND VPWR VPWR _01841_ sky130_fd_sc_hd__nand2_1
Xinput21 mem_rdata[28] VGND VGND VPWR VPWR net21 sky130_fd_sc_hd__buf_2
Xinput10 mem_rdata[18] VGND VGND VPWR VPWR net10 sky130_fd_sc_hd__clkbuf_2
XFILLER_128_541 VGND VGND VPWR VPWR sky130_fd_sc_hd__decap_3
X_05171_ cpu_state\[4\] net201 _01774_ cpu_state\[6\] _01777_ VGND VGND VPWR VPWR
+ _01778_ sky130_fd_sc_hd__a221o_1
Xinput32 mem_rdata[9] VGND VGND VPWR VPWR net32 sky130_fd_sc_hd__dlymetal6s2s_1
XFILLER_116_725 VGND VGND VPWR VPWR sky130_fd_sc_hd__decap_3
XTAP_TAPCELL_ROW_92_1809 VGND VPWR sky130_fd_sc_hd__tapvpwrvgnd_1
XFILLER_89_609 VGND VGND VPWR VPWR sky130_fd_sc_hd__decap_6
XFILLER_6_381 VPWR VGND VPWR VGND sky130_ef_sc_hd__decap_12
X_08930_ net269 _04606_ _01559_ VGND VGND VPWR VPWR _04608_ sky130_fd_sc_hd__a21o_1
X_08861_ cpuregs\[20\]\[21\] cpuregs\[21\]\[21\] cpuregs\[22\]\[21\] cpuregs\[23\]\[21\]
+ _00007_ net274 VGND VGND VPWR VPWR _04542_ sky130_fd_sc_hd__mux4_1
XFILLER_124_791 VPWR VGND VPWR VGND sky130_ef_sc_hd__decap_12
X_07812_ count_instr\[59\] _03678_ net34 VGND VGND VPWR VPWR _03680_ sky130_fd_sc_hd__o21ai_1
XFILLER_96_141 VPWR VGND VPWR VGND sky130_ef_sc_hd__decap_12
XFILLER_111_485 VPWR VGND VPWR VGND sky130_ef_sc_hd__decap_12
XFILLER_111_474 VGND VGND VPWR VPWR sky130_fd_sc_hd__fill_2
X_08792_ cpuregs\[8\]\[17\] cpuregs\[9\]\[17\] cpuregs\[10\]\[17\] cpuregs\[11\]\[17\]
+ net277 net272 VGND VGND VPWR VPWR _04477_ sky130_fd_sc_hd__mux4_1
X_07743_ count_instr\[33\] _03634_ _03636_ VGND VGND VPWR VPWR _00614_ sky130_fd_sc_hd__o21a_1
X_04955_ net34 cpu_state\[2\] VGND VGND VPWR VPWR _01586_ sky130_fd_sc_hd__nand2_8
XFILLER_65_561 VGND VGND VPWR VPWR sky130_fd_sc_hd__decap_6
X_07674_ count_instr\[8\] net420 _03592_ VGND VGND VPWR VPWR _00589_ sky130_fd_sc_hd__o21a_1
XTAP_TAPCELL_ROW_36_910 VGND VPWR sky130_fd_sc_hd__tapvpwrvgnd_1
X_09413_ _02654_ cpuregs\[18\]\[17\] _04862_ VGND VGND VPWR VPWR _01047_ sky130_fd_sc_hd__mux2_1
XFILLER_80_553 VGND VGND VPWR VPWR sky130_fd_sc_hd__decap_3
XFILLER_53_756 VGND VGND VPWR VPWR sky130_fd_sc_hd__fill_1
XFILLER_16_27 VGND VGND VPWR VPWR sky130_fd_sc_hd__fill_1
X_06625_ _03043_ _03044_ _01579_ VGND VGND VPWR VPWR _03052_ sky130_fd_sc_hd__mux2_1
XFILLER_25_447 VGND VGND VPWR VPWR sky130_fd_sc_hd__fill_1
XFILLER_80_564 VGND VGND VPWR VPWR sky130_fd_sc_hd__decap_4
XTAP_TAPCELL_ROW_101_1949 VGND VPWR sky130_fd_sc_hd__tapvpwrvgnd_1
X_09344_ mem_rdata_q\[23\] _01589_ VGND VGND VPWR VPWR _04834_ sky130_fd_sc_hd__and2_1
X_06556_ net175 _02720_ VGND VGND VPWR VPWR _02985_ sky130_fd_sc_hd__or2_1
XFILLER_40_439 VGND VGND VPWR VPWR sky130_fd_sc_hd__fill_1
XTAP_TAPCELL_ROW_43_1012 VGND VPWR sky130_fd_sc_hd__tapvpwrvgnd_1
XTAP_TAPCELL_ROW_43_1023 VGND VPWR sky130_fd_sc_hd__tapvpwrvgnd_1
XFILLER_139_839 VGND VGND VPWR VPWR sky130_fd_sc_hd__fill_1
XTAP_TAPCELL_ROW_138_2540 VGND VPWR sky130_fd_sc_hd__tapvpwrvgnd_1
X_05507_ net183 net215 VGND VGND VPWR VPWR _02090_ sky130_fd_sc_hd__and2_1
X_09275_ net162 net124 _04206_ VGND VGND VPWR VPWR _00961_ sky130_fd_sc_hd__mux2_1
XFILLER_32_15 VPWR VGND VPWR VGND sky130_ef_sc_hd__decap_12
X_06487_ _02915_ _02916_ _01579_ VGND VGND VPWR VPWR _02919_ sky130_fd_sc_hd__mux2_1
XFILLER_148_15 VPWR VGND VPWR VGND sky130_ef_sc_hd__decap_12
X_08226_ _03717_ _04024_ VGND VGND VPWR VPWR _04030_ sky130_fd_sc_hd__or2_1
X_05438_ count_cycle\[29\] _01588_ _01674_ _02023_ VGND VGND VPWR VPWR _02024_ sky130_fd_sc_hd__o211a_1
X_08157_ _03708_ _03709_ decoded_imm_j\[20\] VGND VGND VPWR VPWR _03967_ sky130_fd_sc_hd__o21a_1
XTAP_TAPCELL_ROW_151_2751 VGND VPWR sky130_fd_sc_hd__tapvpwrvgnd_1
XTAP_TAPCELL_ROW_151_2740 VGND VPWR sky130_fd_sc_hd__tapvpwrvgnd_1
X_07108_ cpuregs\[8\]\[29\] cpuregs\[9\]\[29\] cpuregs\[10\]\[29\] cpuregs\[11\]\[29\]
+ net266 net261 VGND VGND VPWR VPWR _03517_ sky130_fd_sc_hd__mux4_1
X_05369_ _01958_ _01959_ VGND VGND VPWR VPWR _01960_ sky130_fd_sc_hd__nand2_1
XFILLER_106_235 VPWR VGND VPWR VGND sky130_ef_sc_hd__decap_12
X_08088_ _01551_ _03900_ _03901_ _03902_ _03903_ VGND VGND VPWR VPWR _03904_ sky130_fd_sc_hd__o32a_1
X_07039_ decoded_imm\[27\] net190 VGND VGND VPWR VPWR _03450_ sky130_fd_sc_hd__nand2_1
XFILLER_0_502 VGND VGND VPWR VPWR sky130_fd_sc_hd__fill_2
XFILLER_114_290 VGND VGND VPWR VPWR sky130_fd_sc_hd__fill_2
X_10050_ clknet_leaf_19_clk _00180_ VGND VGND VPWR VPWR cpuregs\[13\]\[16\] sky130_fd_sc_hd__dfxtp_1
XFILLER_102_441 VGND VGND VPWR VPWR sky130_fd_sc_hd__fill_2
XFILLER_88_664 VPWR VGND VPWR VGND sky130_ef_sc_hd__decap_12
XTAP_TAPCELL_ROW_54_1196 VGND VPWR sky130_fd_sc_hd__tapvpwrvgnd_1
XFILLER_48_539 VGND VGND VPWR VPWR sky130_fd_sc_hd__fill_1
XFILLER_48_528 VGND VGND VPWR VPWR sky130_fd_sc_hd__decap_4
XFILLER_75_369 VGND VGND VPWR VPWR sky130_fd_sc_hd__fill_1
XFILLER_63_509 VPWR VGND VPWR VGND sky130_ef_sc_hd__decap_12
XFILLER_90_339 VGND VGND VPWR VPWR sky130_fd_sc_hd__fill_1
XFILLER_90_317 VGND VGND VPWR VPWR sky130_fd_sc_hd__fill_1
X_10952_ clknet_leaf_88_clk _01014_ VGND VGND VPWR VPWR decoded_imm\[16\] sky130_fd_sc_hd__dfxtp_2
XFILLER_73_11 VGND VGND VPWR VPWR sky130_fd_sc_hd__decap_6
XTAP_TAPCELL_ROW_3_384 VGND VPWR sky130_fd_sc_hd__tapvpwrvgnd_1
XTAP_TAPCELL_ROW_3_373 VGND VPWR sky130_fd_sc_hd__tapvpwrvgnd_1
XFILLER_83_391 VGND VGND VPWR VPWR sky130_fd_sc_hd__fill_1
X_10883_ clknet_leaf_36_clk _00945_ VGND VGND VPWR VPWR cpuregs\[1\]\[27\] sky130_fd_sc_hd__dfxtp_1
XFILLER_71_564 VPWR VGND VPWR VGND sky130_ef_sc_hd__decap_12
XFILLER_71_553 VGND VGND VPWR VPWR sky130_fd_sc_hd__fill_1
XPHY_EDGE_ROW_51_Left_205 VGND VGND VPWR VPWR sky130_fd_sc_hd__decap_3
XFILLER_145_809 VPWR VGND VPWR VGND sky130_ef_sc_hd__decap_12
XFILLER_12_697 VGND VGND VPWR VPWR sky130_fd_sc_hd__decap_3
XFILLER_138_861 VGND VGND VPWR VPWR sky130_fd_sc_hd__decap_6
XTAP_TAPCELL_ROW_22_681 VGND VPWR sky130_fd_sc_hd__tapvpwrvgnd_1
X_11435_ clknet_leaf_115_clk _01479_ VGND VGND VPWR VPWR cpuregs\[0\]\[1\] sky130_fd_sc_hd__dfxtp_1
XFILLER_7_167 VGND VGND VPWR VPWR sky130_fd_sc_hd__fill_1
XFILLER_153_853 VGND VGND VPWR VPWR sky130_fd_sc_hd__decap_4
X_11366_ clknet_leaf_38_clk _01410_ VGND VGND VPWR VPWR cpuregs\[6\]\[28\] sky130_fd_sc_hd__dfxtp_1
XFILLER_98_41 VGND VGND VPWR VPWR sky130_fd_sc_hd__fill_1
XTAP_TAPCELL_ROW_74_1517 VGND VPWR sky130_fd_sc_hd__tapvpwrvgnd_1
XPHY_EDGE_ROW_60_Left_214 VGND VGND VPWR VPWR sky130_fd_sc_hd__decap_3
XFILLER_153_897 VGND VGND VPWR VPWR sky130_fd_sc_hd__fill_2
X_11297_ clknet_leaf_44_clk _01344_ VGND VGND VPWR VPWR cpuregs\[4\]\[26\] sky130_fd_sc_hd__dfxtp_1
X_10317_ clknet_leaf_34_clk _00447_ VGND VGND VPWR VPWR cpuregs\[26\]\[27\] sky130_fd_sc_hd__dfxtp_1
XFILLER_98_85 VGND VGND VPWR VPWR sky130_fd_sc_hd__decap_4
X_10248_ clknet_leaf_49_clk _00378_ VGND VGND VPWR VPWR cpuregs\[27\]\[22\] sky130_fd_sc_hd__dfxtp_1
XFILLER_106_791 VGND VGND VPWR VPWR sky130_fd_sc_hd__decap_3
XFILLER_3_373 VPWR VGND VPWR VGND sky130_ef_sc_hd__decap_12
XFILLER_105_290 VGND VGND VPWR VPWR sky130_fd_sc_hd__fill_1
XFILLER_78_141 VPWR VGND VPWR VGND sky130_ef_sc_hd__decap_12
XFILLER_39_517 VPWR VGND VPWR VGND sky130_ef_sc_hd__decap_12
XFILLER_121_783 VGND VGND VPWR VPWR sky130_fd_sc_hd__fill_1
XFILLER_94_645 VGND VGND VPWR VPWR sky130_fd_sc_hd__fill_1
X_10179_ clknet_leaf_25_clk _00309_ VGND VGND VPWR VPWR cpuregs\[9\]\[17\] sky130_fd_sc_hd__dfxtp_1
XFILLER_78_185 VGND VGND VPWR VPWR sky130_fd_sc_hd__fill_1
XTAP_TAPCELL_ROW_105_2005 VGND VPWR sky130_fd_sc_hd__tapvpwrvgnd_1
XTAP_TAPCELL_ROW_89_1760 VGND VPWR sky130_fd_sc_hd__tapvpwrvgnd_1
XFILLER_66_358 VGND VGND VPWR VPWR sky130_fd_sc_hd__decap_6
XTAP_TAPCELL_ROW_105_2016 VGND VPWR sky130_fd_sc_hd__tapvpwrvgnd_1
XFILLER_81_328 VGND VGND VPWR VPWR sky130_fd_sc_hd__fill_1
XFILLER_47_561 VGND VGND VPWR VPWR sky130_fd_sc_hd__decap_3
XFILLER_47_583 VPWR VGND VPWR VGND sky130_ef_sc_hd__decap_12
XFILLER_62_531 VGND VGND VPWR VPWR sky130_fd_sc_hd__fill_1
XFILLER_19_296 VPWR VGND VPWR VGND sky130_ef_sc_hd__decap_12
X_06410_ _01579_ _02843_ _01580_ VGND VGND VPWR VPWR _02844_ sky130_fd_sc_hd__a21o_1
X_07390_ cpuregs\[14\]\[8\] _02616_ net247 VGND VGND VPWR VPWR _00332_ sky130_fd_sc_hd__mux2_1
X_06341_ cpuregs\[12\]\[2\] cpuregs\[13\]\[2\] cpuregs\[14\]\[2\] cpuregs\[15\]\[2\]
+ net268 net262 VGND VGND VPWR VPWR _02777_ sky130_fd_sc_hd__mux4_1
XFILLER_147_113 VPWR VGND VPWR VGND sky130_ef_sc_hd__decap_12
Xrebuffer209 net594 VGND VGND VPWR VPWR net595 sky130_fd_sc_hd__dlygate4sd1_1
X_06272_ reg_out\[31\] alu_out_q\[31\] net587 VGND VGND VPWR VPWR _02711_ sky130_fd_sc_hd__mux2_1
X_09060_ net227 _01585_ _04729_ _04730_ VGND VGND VPWR VPWR _00837_ sky130_fd_sc_hd__o22a_1
X_05223_ count_instr\[44\] instr_rdinstrh net257 _01825_ VGND VGND VPWR VPWR _01826_
+ sky130_fd_sc_hd__a211o_1
X_08011_ _03817_ _03823_ _03830_ instr_jal VGND VGND VPWR VPWR _03832_ sky130_fd_sc_hd__o31a_1
XFILLER_8_83 VGND VGND VPWR VPWR sky130_fd_sc_hd__fill_1
XTAP_TAPCELL_ROW_41_990 VGND VPWR sky130_fd_sc_hd__tapvpwrvgnd_1
XFILLER_118_29 VPWR VGND VPWR VGND sky130_ef_sc_hd__decap_12
XTAP_TAPCELL_ROW_116_2189 VGND VPWR sky130_fd_sc_hd__tapvpwrvgnd_1
X_05154_ count_instr\[7\] instr_rdinstr net257 _01761_ VGND VGND VPWR VPWR _01762_
+ sky130_fd_sc_hd__a211o_1
XFILLER_131_514 VGND VGND VPWR VPWR sky130_fd_sc_hd__decap_8
X_09962_ clknet_leaf_62_clk _00092_ VGND VGND VPWR VPWR net186 sky130_fd_sc_hd__dfxtp_4
XFILLER_104_717 VGND VGND VPWR VPWR sky130_fd_sc_hd__decap_8
X_05085_ _01697_ VGND VGND VPWR VPWR _01698_ sky130_fd_sc_hd__inv_2
XFILLER_143_385 VGND VGND VPWR VPWR sky130_fd_sc_hd__decap_6
X_08913_ decoded_imm\[23\] _01654_ _01586_ VGND VGND VPWR VPWR _04592_ sky130_fd_sc_hd__a21o_1
X_09893_ cpuregs\[0\]\[23\] VGND VGND VPWR VPWR _01501_ sky130_fd_sc_hd__clkbuf_1
XFILLER_100_901 VGND VGND VPWR VPWR sky130_fd_sc_hd__decap_3
X_08844_ net270 _04525_ VGND VGND VPWR VPWR _04526_ sky130_fd_sc_hd__or2_1
XFILLER_112_783 VGND VGND VPWR VPWR sky130_fd_sc_hd__fill_2
XFILLER_57_325 VGND VGND VPWR VPWR sky130_fd_sc_hd__decap_8
X_05987_ reg_out\[16\] reg_next_pc\[16\] net596 VGND VGND VPWR VPWR _02497_ sky130_fd_sc_hd__mux2_1
X_08775_ cpuregs\[24\]\[16\] cpuregs\[25\]\[16\] cpuregs\[26\]\[16\] cpuregs\[27\]\[16\]
+ net276 net272 VGND VGND VPWR VPWR _04461_ sky130_fd_sc_hd__mux4_1
XFILLER_27_15 VPWR VGND VPWR VGND sky130_ef_sc_hd__decap_12
XFILLER_150_27 VGND VGND VPWR VPWR sky130_fd_sc_hd__fill_1
XPHY_EDGE_ROW_108_Left_262 VGND VGND VPWR VPWR sky130_fd_sc_hd__decap_3
X_07726_ count_instr\[27\] _03624_ _01549_ VGND VGND VPWR VPWR _03626_ sky130_fd_sc_hd__a21oi_1
X_04938_ net119 VGND VGND VPWR VPWR _01571_ sky130_fd_sc_hd__inv_2
XTAP_TAPCELL_ROW_0_310 VGND VPWR sky130_fd_sc_hd__tapvpwrvgnd_1
XTAP_TAPCELL_ROW_0_321 VGND VPWR sky130_fd_sc_hd__tapvpwrvgnd_1
XFILLER_26_701 VGND VGND VPWR VPWR sky130_fd_sc_hd__fill_2
XTAP_TAPCELL_ROW_0_332 VGND VPWR sky130_fd_sc_hd__tapvpwrvgnd_1
XFILLER_80_361 VGND VGND VPWR VPWR sky130_fd_sc_hd__decap_3
X_07657_ count_instr\[2\] net419 net34 VGND VGND VPWR VPWR _03582_ sky130_fd_sc_hd__o21ai_1
X_06608_ _03033_ _03034_ VGND VGND VPWR VPWR _03035_ sky130_fd_sc_hd__or2_1
X_07588_ cpuregs\[20\]\[5\] _02603_ net245 VGND VGND VPWR VPWR _00521_ sky130_fd_sc_hd__mux2_1
XFILLER_40_203 VPWR VGND VPWR VGND sky130_ef_sc_hd__decap_12
XFILLER_41_726 VGND VGND VPWR VPWR sky130_fd_sc_hd__fill_2
XFILLER_41_737 VGND VGND VPWR VPWR sky130_fd_sc_hd__fill_2
XFILLER_41_748 VGND VGND VPWR VPWR sky130_fd_sc_hd__decap_6
X_09327_ instr_jal decoded_imm_j\[20\] _04824_ VGND VGND VPWR VPWR _04825_ sky130_fd_sc_hd__a21o_2
X_06539_ cpuregs\[16\]\[8\] cpuregs\[17\]\[8\] cpuregs\[18\]\[8\] cpuregs\[19\]\[8\]
+ net263 net259 VGND VGND VPWR VPWR _02969_ sky130_fd_sc_hd__mux4_1
XTAP_TAPCELL_ROW_153_2802 VGND VPWR sky130_fd_sc_hd__tapvpwrvgnd_1
XFILLER_138_113 VGND VGND VPWR VPWR sky130_fd_sc_hd__fill_1
XFILLER_138_168 VGND VGND VPWR VPWR sky130_fd_sc_hd__decap_4
XFILLER_127_809 VPWR VGND VPWR VGND sky130_ef_sc_hd__decap_12
XPHY_EDGE_ROW_117_Left_271 VGND VGND VPWR VPWR sky130_fd_sc_hd__decap_3
X_09258_ mem_do_wdata mem_do_rdata _01582_ _01584_ VGND VGND VPWR VPWR _04801_ sky130_fd_sc_hd__or4_1
X_08209_ _03986_ _03997_ _04012_ _04013_ VGND VGND VPWR VPWR _04015_ sky130_fd_sc_hd__or4_1
X_09189_ decoded_imm_j\[10\] _01124_ _02513_ VGND VGND VPWR VPWR _00892_ sky130_fd_sc_hd__mux2_1
XFILLER_135_853 VPWR VGND VPWR VGND sky130_ef_sc_hd__decap_12
XFILLER_107_533 VGND VGND VPWR VPWR sky130_fd_sc_hd__fill_1
X_11220_ clknet_leaf_28_clk _01267_ VGND VGND VPWR VPWR cpuregs\[3\]\[13\] sky130_fd_sc_hd__dfxtp_1
XFILLER_135_897 VPWR VGND VPWR VGND sky130_ef_sc_hd__decap_12
XFILLER_134_352 VPWR VGND VPWR VGND sky130_ef_sc_hd__decap_12
XTAP_TAPCELL_ROW_56_1225 VGND VPWR sky130_fd_sc_hd__tapvpwrvgnd_1
X_11151_ clknet_leaf_1_clk _01198_ VGND VGND VPWR VPWR cpuregs\[23\]\[8\] sky130_fd_sc_hd__dfxtp_1
XFILLER_150_867 VGND VGND VPWR VPWR sky130_fd_sc_hd__fill_1
XFILLER_122_536 VGND VGND VPWR VPWR sky130_fd_sc_hd__decap_8
XFILLER_108_73 VGND VGND VPWR VPWR sky130_fd_sc_hd__decap_8
XTAP_TAPCELL_ROW_8_454 VGND VPWR sky130_fd_sc_hd__tapvpwrvgnd_1
XFILLER_0_321 VGND VGND VPWR VPWR sky130_fd_sc_hd__decap_4
XFILLER_1_833 VGND VGND VPWR VPWR sky130_fd_sc_hd__decap_6
X_10102_ clknet_leaf_126_clk _00232_ VGND VGND VPWR VPWR cpuregs\[28\]\[4\] sky130_fd_sc_hd__dfxtp_1
X_11082_ clknet_leaf_15_clk _01139_ VGND VGND VPWR VPWR cpuregs\[24\]\[13\] sky130_fd_sc_hd__dfxtp_1
XTAP_TAPCELL_ROW_8_465 VGND VPWR sky130_fd_sc_hd__tapvpwrvgnd_1
XFILLER_0_343 VGND VGND VPWR VPWR sky130_fd_sc_hd__decap_3
XFILLER_1_877 VGND VGND VPWR VPWR sky130_fd_sc_hd__decap_8
XFILLER_1_888 VGND VGND VPWR VPWR sky130_fd_sc_hd__decap_8
XPHY_EDGE_ROW_126_Left_280 VGND VGND VPWR VPWR sky130_fd_sc_hd__decap_3
XFILLER_75_111 VGND VGND VPWR VPWR sky130_fd_sc_hd__fill_1
X_10033_ clknet_leaf_16_clk _00163_ VGND VGND VPWR VPWR cpuregs\[30\]\[31\] sky130_fd_sc_hd__dfxtp_1
XFILLER_48_325 VGND VGND VPWR VPWR sky130_fd_sc_hd__fill_2
XFILLER_0_365 VGND VGND VPWR VPWR sky130_fd_sc_hd__fill_2
XFILLER_91_604 VPWR VGND VPWR VGND sky130_ef_sc_hd__decap_12
XFILLER_91_626 VPWR VGND VPWR VGND sky130_ef_sc_hd__decap_12
XFILLER_90_114 VGND VGND VPWR VPWR sky130_fd_sc_hd__fill_2
XFILLER_75_166 VGND VGND VPWR VPWR sky130_fd_sc_hd__fill_2
XFILLER_29_561 VGND VGND VPWR VPWR sky130_fd_sc_hd__decap_4
XFILLER_84_76 VGND VGND VPWR VPWR sky130_fd_sc_hd__decap_8
XFILLER_16_211 VGND VGND VPWR VPWR sky130_fd_sc_hd__decap_8
XFILLER_71_361 VPWR VGND VPWR VGND sky130_ef_sc_hd__decap_12
XFILLER_17_81 VPWR VGND VPWR VGND sky130_ef_sc_hd__decap_12
XTAP_TAPCELL_ROW_27_762 VGND VPWR sky130_fd_sc_hd__tapvpwrvgnd_1
X_10935_ clknet_leaf_128_clk _00997_ VGND VGND VPWR VPWR reg_sh\[0\] sky130_fd_sc_hd__dfxtp_1
XTAP_TAPCELL_ROW_67_1398 VGND VPWR sky130_fd_sc_hd__tapvpwrvgnd_1
X_10866_ clknet_leaf_3_clk _00928_ VGND VGND VPWR VPWR cpuregs\[1\]\[10\] sky130_fd_sc_hd__dfxtp_1
XFILLER_31_225 VPWR VGND VPWR VGND sky130_ef_sc_hd__decap_12
X_10797_ clknet_leaf_98_clk _00862_ VGND VGND VPWR VPWR instr_slti sky130_fd_sc_hd__dfxtp_1
XFILLER_118_809 VGND VGND VPWR VPWR sky130_fd_sc_hd__decap_3
XFILLER_33_80 VGND VGND VPWR VPWR sky130_fd_sc_hd__decap_8
XPHY_EDGE_ROW_144_Right_144 VGND VGND VPWR VPWR sky130_fd_sc_hd__decap_3
X_11418_ clknet_leaf_19_clk _01462_ VGND VGND VPWR VPWR cpuregs\[8\]\[16\] sky130_fd_sc_hd__dfxtp_1
XFILLER_98_214 VGND VGND VPWR VPWR sky130_fd_sc_hd__decap_3
XFILLER_4_693 VGND VGND VPWR VPWR sky130_fd_sc_hd__decap_6
XFILLER_3_181 VPWR VGND VPWR VGND sky130_ef_sc_hd__decap_12
X_11349_ clknet_leaf_149_clk _01393_ VGND VGND VPWR VPWR cpuregs\[6\]\[11\] sky130_fd_sc_hd__dfxtp_1
XFILLER_141_889 VGND VGND VPWR VPWR sky130_fd_sc_hd__decap_6
XFILLER_98_269 VPWR VGND VPWR VGND sky130_ef_sc_hd__decap_12
XFILLER_79_461 VGND VGND VPWR VPWR sky130_fd_sc_hd__decap_8
X_06890_ cpuregs\[20\]\[21\] cpuregs\[21\]\[21\] cpuregs\[22\]\[21\] cpuregs\[23\]\[21\]
+ _00012_ _00013_ VGND VGND VPWR VPWR _03307_ sky130_fd_sc_hd__mux4_1
X_05910_ _02070_ _02461_ _02462_ net255 VGND VGND VPWR VPWR _02463_ sky130_fd_sc_hd__o211a_1
X_05841_ _02089_ _02400_ VGND VGND VPWR VPWR _02402_ sky130_fd_sc_hd__or2_1
XTAP_TAPCELL_ROW_87_1719 VGND VPWR sky130_fd_sc_hd__tapvpwrvgnd_1
X_05772_ _02146_ _02336_ _02199_ VGND VGND VPWR VPWR _02340_ sky130_fd_sc_hd__o21a_1
X_08560_ decoded_imm\[3\] _01653_ _01585_ VGND VGND VPWR VPWR _04259_ sky130_fd_sc_hd__o21a_1
XFILLER_47_391 VGND VGND VPWR VPWR sky130_fd_sc_hd__fill_1
XFILLER_120_19 VGND VGND VPWR VPWR sky130_fd_sc_hd__decap_8
X_07511_ cpuregs\[26\]\[29\] _02704_ _03568_ VGND VGND VPWR VPWR _00449_ sky130_fd_sc_hd__mux2_1
X_08491_ net75 net44 _04208_ VGND VGND VPWR VPWR _00789_ sky130_fd_sc_hd__mux2_1
X_07442_ cpuregs\[27\]\[26\] _02691_ _03566_ VGND VGND VPWR VPWR _00382_ sky130_fd_sc_hd__mux2_1
X_07373_ _02683_ cpuregs\[9\]\[24\] _03563_ VGND VGND VPWR VPWR _00316_ sky130_fd_sc_hd__mux2_1
XFILLER_50_556 VGND VGND VPWR VPWR sky130_fd_sc_hd__fill_1
XTAP_TAPCELL_ROW_118_2218 VGND VPWR sky130_fd_sc_hd__tapvpwrvgnd_1
X_09112_ _01106_ _01108_ _01107_ _04739_ VGND VGND VPWR VPWR _04758_ sky130_fd_sc_hd__or4b_1
XFILLER_13_39 VPWR VGND VPWR VGND sky130_ef_sc_hd__decap_12
X_06324_ _02754_ _02755_ _02757_ _02756_ _01579_ _00016_ VGND VGND VPWR VPWR _02761_
+ sky130_fd_sc_hd__mux4_1
XFILLER_129_39 VPWR VGND VPWR VGND sky130_ef_sc_hd__decap_12
XFILLER_30_280 VGND VGND VPWR VPWR sky130_fd_sc_hd__fill_1
XFILLER_148_477 VGND VGND VPWR VPWR sky130_fd_sc_hd__decap_3
X_06255_ reg_out\[28\] alu_out_q\[28\] net587 VGND VGND VPWR VPWR _02697_ sky130_fd_sc_hd__mux2_1
X_09043_ cpuregs\[16\]\[31\] cpuregs\[17\]\[31\] cpuregs\[18\]\[31\] cpuregs\[19\]\[31\]
+ net277 net272 VGND VGND VPWR VPWR _04714_ sky130_fd_sc_hd__mux4_1
XTAP_TAPCELL_ROW_131_2429 VGND VPWR sky130_fd_sc_hd__tapvpwrvgnd_1
XFILLER_129_691 VGND VGND VPWR VPWR sky130_fd_sc_hd__fill_1
XPHY_EDGE_ROW_111_Right_111 VGND VGND VPWR VPWR sky130_fd_sc_hd__decap_3
X_06186_ _02641_ cpuregs\[11\]\[14\] _02582_ VGND VGND VPWR VPWR _00051_ sky130_fd_sc_hd__mux2_1
X_05206_ net256 _01807_ _01808_ _01809_ VGND VGND VPWR VPWR _04880_ sky130_fd_sc_hd__a31o_1
XFILLER_145_27 VPWR VGND VPWR VGND sky130_ef_sc_hd__decap_12
XFILLER_144_683 VGND VGND VPWR VPWR sky130_fd_sc_hd__fill_1
XFILLER_117_897 VGND VGND VPWR VPWR sky130_fd_sc_hd__decap_3
X_05137_ _01737_ _01744_ _01743_ VGND VGND VPWR VPWR _01746_ sky130_fd_sc_hd__a21bo_1
XFILLER_89_225 VGND VGND VPWR VPWR sky130_fd_sc_hd__decap_3
XFILLER_132_867 VGND VGND VPWR VPWR sky130_fd_sc_hd__fill_1
X_05068_ net171 mem_wordsize\[1\] _01681_ VGND VGND VPWR VPWR _01682_ sky130_fd_sc_hd__and3_1
XTAP_TAPCELL_ROW_5_413 VGND VPWR sky130_fd_sc_hd__tapvpwrvgnd_1
X_09945_ clknet_leaf_134_clk _00075_ VGND VGND VPWR VPWR net199 sky130_fd_sc_hd__dfxtp_4
XFILLER_100_720 VGND VGND VPWR VPWR sky130_fd_sc_hd__decap_3
XFILLER_57_111 VGND VGND VPWR VPWR sky130_fd_sc_hd__fill_1
XTAP_TAPCELL_ROW_51_1144 VGND VPWR sky130_fd_sc_hd__tapvpwrvgnd_1
X_09876_ cpuregs\[0\]\[6\] VGND VGND VPWR VPWR _01484_ sky130_fd_sc_hd__clkbuf_1
XTAP_TAPCELL_ROW_146_2661 VGND VPWR sky130_fd_sc_hd__tapvpwrvgnd_1
X_08827_ cpuregs\[8\]\[19\] cpuregs\[9\]\[19\] cpuregs\[10\]\[19\] cpuregs\[11\]\[19\]
+ net280 net274 VGND VGND VPWR VPWR _04510_ sky130_fd_sc_hd__mux4_1
XFILLER_100_742 VPWR VGND VPWR VGND sky130_ef_sc_hd__decap_12
XFILLER_58_667 VGND VGND VPWR VPWR sky130_fd_sc_hd__decap_6
XFILLER_58_645 VPWR VGND VPWR VGND sky130_ef_sc_hd__decap_12
XTAP_TAPCELL_ROW_51_1155 VGND VPWR sky130_fd_sc_hd__tapvpwrvgnd_1
XTAP_TAPCELL_ROW_146_2672 VGND VPWR sky130_fd_sc_hd__tapvpwrvgnd_1
XFILLER_18_509 VGND VGND VPWR VPWR sky130_fd_sc_hd__fill_2
XFILLER_39_881 VGND VGND VPWR VPWR sky130_fd_sc_hd__fill_2
X_08758_ cpuregs\[4\]\[15\] cpuregs\[5\]\[15\] cpuregs\[6\]\[15\] cpuregs\[7\]\[15\]
+ net277 net272 VGND VGND VPWR VPWR _04445_ sky130_fd_sc_hd__mux4_1
X_07709_ _03610_ _03614_ VGND VGND VPWR VPWR _03615_ sky130_fd_sc_hd__and2_1
XFILLER_54_46 VGND VGND VPWR VPWR sky130_fd_sc_hd__fill_1
X_08689_ _04371_ _04372_ _04376_ _04377_ _01558_ _01559_ VGND VGND VPWR VPWR _04380_
+ sky130_fd_sc_hd__mux4_1
XFILLER_13_225 VGND VGND VPWR VPWR sky130_fd_sc_hd__decap_3
XTAP_TAPCELL_ROW_24_710 VGND VPWR sky130_fd_sc_hd__tapvpwrvgnd_1
XTAP_TAPCELL_ROW_24_721 VGND VPWR sky130_fd_sc_hd__tapvpwrvgnd_1
X_10720_ clknet_leaf_134_clk _00817_ VGND VGND VPWR VPWR net205 sky130_fd_sc_hd__dfxtp_4
XFILLER_80_191 VGND VGND VPWR VPWR sky130_fd_sc_hd__decap_4
XFILLER_139_411 VGND VGND VPWR VPWR sky130_fd_sc_hd__decap_8
XFILLER_110_85 VGND VGND VPWR VPWR sky130_fd_sc_hd__decap_8
X_10651_ clknet_leaf_131_clk _04909_ VGND VGND VPWR VPWR reg_out\[9\] sky130_fd_sc_hd__dfxtp_1
XFILLER_41_589 VGND VGND VPWR VPWR sky130_fd_sc_hd__fill_1
X_10582_ clknet_leaf_109_clk _00712_ VGND VGND VPWR VPWR count_cycle\[5\] sky130_fd_sc_hd__dfxtp_1
XFILLER_127_617 VPWR VGND VPWR VGND sky130_ef_sc_hd__decap_12
XFILLER_108_820 VGND VGND VPWR VPWR sky130_fd_sc_hd__decap_8
XFILLER_5_435 VPWR VGND VPWR VGND sky130_ef_sc_hd__decap_12
X_11203_ clknet_leaf_40_clk _01250_ VGND VGND VPWR VPWR cpuregs\[29\]\[28\] sky130_fd_sc_hd__dfxtp_1
XFILLER_122_333 VGND VGND VPWR VPWR sky130_fd_sc_hd__decap_6
X_11134_ clknet_leaf_52_clk _01181_ VGND VGND VPWR VPWR cpuregs\[31\]\[23\] sky130_fd_sc_hd__dfxtp_1
XFILLER_110_528 VGND VGND VPWR VPWR sky130_fd_sc_hd__decap_4
X_11065_ clknet_leaf_99_clk _01122_ VGND VGND VPWR VPWR mem_rdata_q\[28\] sky130_fd_sc_hd__dfxtp_1
XFILLER_1_685 VPWR VGND VPWR VGND sky130_ef_sc_hd__decap_12
X_10016_ clknet_leaf_27_clk _00146_ VGND VGND VPWR VPWR cpuregs\[30\]\[14\] sky130_fd_sc_hd__dfxtp_1
XFILLER_76_442 VGND VGND VPWR VPWR sky130_fd_sc_hd__fill_2
XFILLER_49_645 VGND VGND VPWR VPWR sky130_fd_sc_hd__fill_2
XFILLER_48_122 VGND VGND VPWR VPWR sky130_fd_sc_hd__fill_2
XFILLER_36_306 VGND VGND VPWR VPWR sky130_fd_sc_hd__fill_2
XFILLER_37_818 VPWR VGND VPWR VGND sky130_ef_sc_hd__decap_12
XTAP_TAPCELL_ROW_69_1438 VGND VPWR sky130_fd_sc_hd__tapvpwrvgnd_1
XFILLER_151_81 VPWR VGND VPWR VGND sky130_ef_sc_hd__decap_12
XFILLER_63_147 VPWR VGND VPWR VGND sky130_ef_sc_hd__decap_12
X_10918_ clknet_leaf_46_clk _00980_ VGND VGND VPWR VPWR net151 sky130_fd_sc_hd__dfxtp_1
XTAP_TAPCELL_ROW_82_1649 VGND VPWR sky130_fd_sc_hd__tapvpwrvgnd_1
XTAP_TAPCELL_ROW_82_1638 VGND VPWR sky130_fd_sc_hd__tapvpwrvgnd_1
XFILLER_32_501 VGND VGND VPWR VPWR sky130_fd_sc_hd__fill_2
XFILLER_44_383 VGND VGND VPWR VPWR sky130_fd_sc_hd__decap_3
XFILLER_45_895 VGND VGND VPWR VPWR sky130_fd_sc_hd__fill_1
XFILLER_60_854 VGND VGND VPWR VPWR sky130_fd_sc_hd__decap_4
XFILLER_32_556 VGND VGND VPWR VPWR sky130_fd_sc_hd__fill_1
X_10849_ clknet_leaf_100_clk _00913_ VGND VGND VPWR VPWR is_slli_srli_srai sky130_fd_sc_hd__dfxtp_2
XFILLER_9_785 VPWR VGND VPWR VGND sky130_ef_sc_hd__decap_12
X_06040_ decoded_imm_j\[19\] _01113_ _02513_ VGND VGND VPWR VPWR _00036_ sky130_fd_sc_hd__mux2_1
XFILLER_67_3 VGND VGND VPWR VPWR sky130_fd_sc_hd__decap_3
XTAP_TAPCELL_ROW_113_2137 VGND VPWR sky130_fd_sc_hd__tapvpwrvgnd_1
XTAP_TAPCELL_ROW_97_1881 VGND VPWR sky130_fd_sc_hd__tapvpwrvgnd_1
XTAP_TAPCELL_ROW_10_492 VGND VPWR sky130_fd_sc_hd__tapvpwrvgnd_1
XFILLER_126_683 VGND VGND VPWR VPWR sky130_fd_sc_hd__fill_1
XFILLER_5_51 VGND VGND VPWR VPWR sky130_fd_sc_hd__decap_4
XFILLER_140_141 VGND VGND VPWR VPWR sky130_fd_sc_hd__decap_8
XFILLER_114_867 VGND VGND VPWR VPWR sky130_fd_sc_hd__fill_1
XFILLER_113_333 VGND VGND VPWR VPWR sky130_fd_sc_hd__decap_3
X_07991_ instr_jal _03810_ _03811_ _03812_ _03813_ VGND VGND VPWR VPWR _03814_ sky130_fd_sc_hd__a32o_1
Xclkbuf_4_7_0_clk clknet_0_clk VGND VGND VPWR VPWR clknet_4_7_0_clk sky130_fd_sc_hd__clkbuf_8
X_06942_ cpuregs\[24\]\[23\] cpuregs\[25\]\[23\] cpuregs\[26\]\[23\] cpuregs\[27\]\[23\]
+ net267 net260 VGND VGND VPWR VPWR _03357_ sky130_fd_sc_hd__mux4_1
XFILLER_113_399 VPWR VGND VPWR VGND sky130_ef_sc_hd__decap_12
XFILLER_101_528 VPWR VGND VPWR VGND sky130_ef_sc_hd__decap_12
X_09730_ _02593_ cpuregs\[6\]\[3\] _04873_ VGND VGND VPWR VPWR _01385_ sky130_fd_sc_hd__mux2_1
X_06873_ _03287_ _03288_ _01579_ VGND VGND VPWR VPWR _03291_ sky130_fd_sc_hd__mux2_1
XTAP_TAPCELL_ROW_128_2380 VGND VPWR sky130_fd_sc_hd__tapvpwrvgnd_1
X_09661_ cpuregs\[4\]\[0\] _02586_ net238 VGND VGND VPWR VPWR _01318_ sky130_fd_sc_hd__mux2_1
XFILLER_27_306 VGND VGND VPWR VPWR sky130_fd_sc_hd__decap_8
X_05824_ _02091_ _02386_ _02238_ _02090_ VGND VGND VPWR VPWR _02387_ sky130_fd_sc_hd__a2bb2o_1
XFILLER_82_412 VGND VGND VPWR VPWR sky130_fd_sc_hd__decap_8
X_09592_ cpuregs\[29\]\[31\] _02712_ net239 VGND VGND VPWR VPWR _01253_ sky130_fd_sc_hd__mux2_1
X_08612_ _01558_ _04306_ VGND VGND VPWR VPWR _04307_ sky130_fd_sc_hd__or2_1
X_05755_ _02156_ _02312_ VGND VGND VPWR VPWR _02325_ sky130_fd_sc_hd__nor2_1
X_08543_ _01559_ _04243_ _00011_ VGND VGND VPWR VPWR _04244_ sky130_fd_sc_hd__a21o_1
XFILLER_42_309 VGND VGND VPWR VPWR sky130_fd_sc_hd__decap_4
XTAP_TAPCELL_ROW_141_2591 VGND VPWR sky130_fd_sc_hd__tapvpwrvgnd_1
XTAP_TAPCELL_ROW_141_2580 VGND VPWR sky130_fd_sc_hd__tapvpwrvgnd_1
X_05686_ _02141_ _02264_ _02242_ VGND VGND VPWR VPWR _02265_ sky130_fd_sc_hd__a21oi_1
X_08474_ net86 net55 _04208_ VGND VGND VPWR VPWR _00772_ sky130_fd_sc_hd__mux2_1
XFILLER_24_27 VGND VGND VPWR VPWR sky130_fd_sc_hd__fill_1
X_07425_ cpuregs\[27\]\[9\] _02621_ _03566_ VGND VGND VPWR VPWR _00365_ sky130_fd_sc_hd__mux2_1
X_07356_ _02612_ cpuregs\[9\]\[7\] _03563_ VGND VGND VPWR VPWR _00299_ sky130_fd_sc_hd__mux2_1
XFILLER_149_797 VPWR VGND VPWR VGND sky130_ef_sc_hd__decap_12
XFILLER_109_617 VGND VGND VPWR VPWR sky130_fd_sc_hd__decap_4
X_07287_ cpuregs\[28\]\[5\] _02603_ net249 VGND VGND VPWR VPWR _00233_ sky130_fd_sc_hd__mux2_1
X_06307_ cpu_state\[4\] _01640_ VGND VGND VPWR VPWR _02745_ sky130_fd_sc_hd__nand2_1
X_06238_ _02683_ cpuregs\[11\]\[24\] _02582_ VGND VGND VPWR VPWR _00061_ sky130_fd_sc_hd__mux2_1
X_09026_ cpuregs\[12\]\[30\] cpuregs\[13\]\[30\] cpuregs\[14\]\[30\] cpuregs\[15\]\[30\]
+ net275 net271 VGND VGND VPWR VPWR _04698_ sky130_fd_sc_hd__mux4_1
XFILLER_40_59 VGND VGND VPWR VPWR sky130_fd_sc_hd__decap_3
XFILLER_124_609 VGND VGND VPWR VPWR sky130_fd_sc_hd__fill_1
X_06169_ _02583_ _02627_ VGND VGND VPWR VPWR _02628_ sky130_fd_sc_hd__nor2_1
XTAP_TAPCELL_ROW_148_2701 VGND VPWR sky130_fd_sc_hd__tapvpwrvgnd_1
X_09928_ clknet_leaf_44_clk _00063_ VGND VGND VPWR VPWR cpuregs\[11\]\[26\] sky130_fd_sc_hd__dfxtp_1
XFILLER_120_837 VPWR VGND VPWR VGND sky130_ef_sc_hd__decap_12
XFILLER_49_57 VGND VGND VPWR VPWR sky130_fd_sc_hd__decap_8
XTAP_TAPCELL_ROW_29_802 VGND VPWR sky130_fd_sc_hd__tapvpwrvgnd_1
X_09859_ net34 net134 _04803_ _04877_ _04209_ VGND VGND VPWR VPWR _01542_ sky130_fd_sc_hd__a41o_1
XFILLER_58_497 VGND VGND VPWR VPWR sky130_fd_sc_hd__decap_8
XFILLER_45_125 VPWR VGND VPWR VGND sky130_ef_sc_hd__decap_12
XFILLER_46_648 VGND VGND VPWR VPWR sky130_fd_sc_hd__fill_2
XFILLER_45_158 VGND VGND VPWR VPWR sky130_fd_sc_hd__fill_1
XFILLER_45_169 VGND VGND VPWR VPWR sky130_fd_sc_hd__decap_4
XFILLER_27_895 VGND VGND VPWR VPWR sky130_fd_sc_hd__fill_1
XFILLER_42_810 VGND VGND VPWR VPWR sky130_fd_sc_hd__fill_2
XTAP_TAPCELL_ROW_64_1357 VGND VPWR sky130_fd_sc_hd__tapvpwrvgnd_1
XFILLER_60_139 VGND VGND VPWR VPWR sky130_fd_sc_hd__fill_1
XFILLER_14_556 VGND VGND VPWR VPWR sky130_fd_sc_hd__decap_8
XFILLER_26_394 VGND VGND VPWR VPWR sky130_fd_sc_hd__decap_8
X_10703_ clknet_leaf_69_clk _00801_ VGND VGND VPWR VPWR net57 sky130_fd_sc_hd__dfxtp_1
X_10634_ clknet_leaf_82_clk _00764_ VGND VGND VPWR VPWR count_cycle\[57\] sky130_fd_sc_hd__dfxtp_1
XFILLER_81_88 VPWR VGND VPWR VGND sky130_ef_sc_hd__decap_12
XFILLER_139_296 VPWR VGND VPWR VGND sky130_ef_sc_hd__decap_12
X_10565_ clknet_leaf_90_clk _00695_ VGND VGND VPWR VPWR reg_next_pc\[20\] sky130_fd_sc_hd__dfxtp_1
X_10496_ clknet_leaf_86_clk _00626_ VGND VGND VPWR VPWR count_instr\[45\] sky130_fd_sc_hd__dfxtp_1
XFILLER_123_653 VPWR VGND VPWR VGND sky130_ef_sc_hd__decap_12
XFILLER_111_848 VGND VGND VPWR VPWR sky130_fd_sc_hd__decap_8
XFILLER_69_729 VPWR VGND VPWR VGND sky130_ef_sc_hd__decap_12
X_11117_ clknet_leaf_1_clk _01164_ VGND VGND VPWR VPWR cpuregs\[31\]\[6\] sky130_fd_sc_hd__dfxtp_1
Xinput8 mem_rdata[16] VGND VGND VPWR VPWR net8 sky130_fd_sc_hd__clkbuf_2
X_11048_ clknet_leaf_111_clk _01105_ VGND VGND VPWR VPWR mem_rdata_q\[11\] sky130_fd_sc_hd__dfxtp_1
XFILLER_64_445 VGND VGND VPWR VPWR sky130_fd_sc_hd__decap_3
XFILLER_24_309 VPWR VGND VPWR VGND sky130_ef_sc_hd__decap_12
X_05540_ net172 net204 VGND VGND VPWR VPWR _02123_ sky130_fd_sc_hd__nor2_1
XFILLER_60_640 VGND VGND VPWR VPWR sky130_fd_sc_hd__decap_4
XFILLER_33_865 VPWR VGND VPWR VGND sky130_ef_sc_hd__decap_12
X_05471_ net189 net221 VGND VGND VPWR VPWR _02054_ sky130_fd_sc_hd__nand2_1
XFILLER_32_353 VGND VGND VPWR VPWR sky130_fd_sc_hd__fill_2
X_07210_ cpuregs\[30\]\[28\] _02699_ net252 VGND VGND VPWR VPWR _00160_ sky130_fd_sc_hd__mux2_1
X_08190_ decoded_imm_j\[20\] _03713_ VGND VGND VPWR VPWR _03997_ sky130_fd_sc_hd__and2_1
XTAP_TAPCELL_ROW_99_1921 VGND VPWR sky130_fd_sc_hd__tapvpwrvgnd_1
XTAP_TAPCELL_ROW_99_1910 VGND VPWR sky130_fd_sc_hd__tapvpwrvgnd_1
XTAP_TAPCELL_ROW_15_573 VGND VPWR sky130_fd_sc_hd__tapvpwrvgnd_1
XFILLER_146_701 VPWR VGND VPWR VGND sky130_ef_sc_hd__decap_12
X_07141_ net194 _03548_ net236 VGND VGND VPWR VPWR _00099_ sky130_fd_sc_hd__mux2_1
X_07072_ net195 _02719_ net254 VGND VGND VPWR VPWR _03482_ sky130_fd_sc_hd__a21o_1
XFILLER_145_299 VGND VGND VPWR VPWR sky130_fd_sc_hd__fill_2
XFILLER_10_29 VPWR VGND VPWR VGND sky130_ef_sc_hd__decap_12
X_06023_ mem_rdata_q\[21\] net14 _01609_ VGND VGND VPWR VPWR _01115_ sky130_fd_sc_hd__mux2_1
XFILLER_126_29 VPWR VGND VPWR VGND sky130_ef_sc_hd__decap_12
XFILLER_87_559 VGND VGND VPWR VPWR sky130_fd_sc_hd__fill_1
X_07974_ decoded_imm_j\[9\] _03696_ VGND VGND VPWR VPWR _03798_ sky130_fd_sc_hd__xnor2_1
XFILLER_19_27 VPWR VGND VPWR VGND sky130_ef_sc_hd__decap_12
X_09713_ _02662_ cpuregs\[5\]\[19\] _04872_ VGND VGND VPWR VPWR _01369_ sky130_fd_sc_hd__mux2_1
X_06925_ _03331_ _03339_ _03340_ _01581_ _01580_ VGND VGND VPWR VPWR _03341_ sky130_fd_sc_hd__a221o_1
XTAP_TAPCELL_ROW_143_2620 VGND VPWR sky130_fd_sc_hd__tapvpwrvgnd_1
X_09644_ _02654_ cpuregs\[22\]\[17\] _04869_ VGND VGND VPWR VPWR _01303_ sky130_fd_sc_hd__mux2_1
X_06856_ _03269_ _03272_ VGND VGND VPWR VPWR _03274_ sky130_fd_sc_hd__nand2_1
XFILLER_27_125 VPWR VGND VPWR VGND sky130_ef_sc_hd__decap_12
X_05807_ net180 _01576_ _02370_ VGND VGND VPWR VPWR _02371_ sky130_fd_sc_hd__a21oi_1
XFILLER_83_765 VGND VGND VPWR VPWR sky130_fd_sc_hd__decap_8
XFILLER_83_754 VGND VGND VPWR VPWR sky130_fd_sc_hd__fill_2
XFILLER_82_231 VGND VGND VPWR VPWR sky130_fd_sc_hd__fill_1
XFILLER_35_15 VPWR VGND VPWR VGND sky130_ef_sc_hd__decap_12
X_06787_ _03197_ _03198_ _00014_ VGND VGND VPWR VPWR _03208_ sky130_fd_sc_hd__mux2_1
X_09575_ cpuregs\[29\]\[14\] _02641_ net239 VGND VGND VPWR VPWR _01236_ sky130_fd_sc_hd__mux2_1
XFILLER_70_404 VPWR VGND VPWR VGND sky130_ef_sc_hd__decap_12
XFILLER_70_448 VGND VGND VPWR VPWR sky130_fd_sc_hd__decap_4
X_05738_ _02120_ _02308_ _02309_ _02241_ VGND VGND VPWR VPWR _02310_ sky130_fd_sc_hd__o211a_1
X_08526_ cpuregs\[20\]\[0\] cpuregs\[21\]\[0\] cpuregs\[22\]\[0\] cpuregs\[23\]\[0\]
+ net279 _00008_ VGND VGND VPWR VPWR _04228_ sky130_fd_sc_hd__mux4_1
X_08457_ net258 _04189_ _04191_ _04193_ VGND VGND VPWR VPWR _04194_ sky130_fd_sc_hd__a22o_1
X_05669_ _02241_ _02249_ _02250_ _02246_ VGND VGND VPWR VPWR alu_out\[1\] sky130_fd_sc_hd__a31o_1
XFILLER_50_150 VGND VGND VPWR VPWR sky130_fd_sc_hd__decap_8
XTAP_TAPCELL_ROW_34_871 VGND VPWR sky130_fd_sc_hd__tapvpwrvgnd_1
XTAP_TAPCELL_ROW_46_1065 VGND VPWR sky130_fd_sc_hd__tapvpwrvgnd_1
X_07408_ cpuregs\[14\]\[26\] _02691_ net247 VGND VGND VPWR VPWR _00350_ sky130_fd_sc_hd__mux2_1
XFILLER_23_397 VGND VGND VPWR VPWR sky130_fd_sc_hd__fill_1
XTAP_TAPCELL_ROW_34_882 VGND VPWR sky130_fd_sc_hd__tapvpwrvgnd_1
XFILLER_149_561 VPWR VGND VPWR VGND sky130_ef_sc_hd__decap_12
X_08388_ count_cycle\[47\] _04139_ _04141_ VGND VGND VPWR VPWR _00754_ sky130_fd_sc_hd__o21a_1
XFILLER_51_69 VPWR VGND VPWR VGND sky130_ef_sc_hd__decap_12
XFILLER_11_559 VGND VGND VPWR VPWR sky130_fd_sc_hd__fill_1
XFILLER_149_594 VGND VGND VPWR VPWR sky130_fd_sc_hd__fill_1
X_07339_ cpuregs\[21\]\[23\] _02678_ net248 VGND VGND VPWR VPWR _00283_ sky130_fd_sc_hd__mux2_1
X_10350_ clknet_leaf_39_clk _00480_ VGND VGND VPWR VPWR cpuregs\[16\]\[28\] sky130_fd_sc_hd__dfxtp_1
XFILLER_151_225 VPWR VGND VPWR VGND sky130_ef_sc_hd__decap_12
X_10281_ clknet_leaf_51_clk _00411_ VGND VGND VPWR VPWR cpuregs\[15\]\[23\] sky130_fd_sc_hd__dfxtp_1
X_09009_ net270 _04681_ VGND VGND VPWR VPWR _04682_ sky130_fd_sc_hd__or2_1
XFILLER_104_174 VPWR VGND VPWR VGND sky130_ef_sc_hd__decap_12
XFILLER_59_740 VGND VGND VPWR VPWR sky130_fd_sc_hd__decap_3
XFILLER_19_615 VGND VGND VPWR VPWR sky130_fd_sc_hd__fill_1
XFILLER_74_732 VGND VGND VPWR VPWR sky130_fd_sc_hd__decap_3
XFILLER_19_626 VGND VGND VPWR VPWR sky130_fd_sc_hd__fill_2
XFILLER_46_401 VGND VGND VPWR VPWR sky130_fd_sc_hd__decap_6
XFILLER_132_83 VGND VGND VPWR VPWR sky130_fd_sc_hd__fill_1
XFILLER_15_821 VPWR VGND VPWR VGND sky130_ef_sc_hd__decap_12
XFILLER_15_865 VPWR VGND VPWR VGND sky130_ef_sc_hd__decap_12
XFILLER_30_813 VPWR VGND VPWR VGND sky130_ef_sc_hd__decap_12
XTAP_TAPCELL_ROW_12_521 VGND VPWR sky130_fd_sc_hd__tapvpwrvgnd_1
XFILLER_14_386 VGND VGND VPWR VPWR sky130_fd_sc_hd__fill_1
XFILLER_41_183 VGND VGND VPWR VPWR sky130_fd_sc_hd__decap_8
X_10617_ clknet_leaf_106_clk _00747_ VGND VGND VPWR VPWR count_cycle\[40\] sky130_fd_sc_hd__dfxtp_1
XFILLER_128_778 VPWR VGND VPWR VGND sky130_ef_sc_hd__decap_12
XFILLER_6_552 VPWR VGND VPWR VGND sky130_ef_sc_hd__decap_12
X_10548_ clknet_leaf_129_clk _00678_ VGND VGND VPWR VPWR reg_next_pc\[3\] sky130_fd_sc_hd__dfxtp_1
XFILLER_143_737 VGND VGND VPWR VPWR sky130_fd_sc_hd__decap_6
XTAP_TAPCELL_ROW_94_1840 VGND VPWR sky130_fd_sc_hd__tapvpwrvgnd_1
XTAP_TAPCELL_ROW_77_1559 VGND VPWR sky130_fd_sc_hd__tapvpwrvgnd_1
XFILLER_6_585 VGND VGND VPWR VPWR sky130_fd_sc_hd__decap_3
X_10479_ clknet_leaf_81_clk _00609_ VGND VGND VPWR VPWR count_instr\[28\] sky130_fd_sc_hd__dfxtp_1
XFILLER_111_645 VGND VGND VPWR VPWR sky130_fd_sc_hd__decap_4
X_04971_ _01596_ _01597_ _01599_ _01600_ VGND VGND VPWR VPWR _01601_ sky130_fd_sc_hd__or4_1
XFILLER_2_41 VPWR VGND VPWR VGND sky130_ef_sc_hd__decap_12
XTAP_TAPCELL_ROW_108_2058 VGND VPWR sky130_fd_sc_hd__tapvpwrvgnd_1
X_06710_ _03131_ _03132_ VGND VGND VPWR VPWR _03133_ sky130_fd_sc_hd__nand2_1
XFILLER_2_85 VPWR VGND VPWR VGND sky130_ef_sc_hd__decap_12
X_07690_ count_instr\[14\] net413 _03602_ VGND VGND VPWR VPWR _00595_ sky130_fd_sc_hd__o21a_1
X_06641_ cpuregs\[0\]\[12\] cpuregs\[1\]\[12\] cpuregs\[2\]\[12\] cpuregs\[3\]\[12\]
+ net263 net259 VGND VGND VPWR VPWR _03067_ sky130_fd_sc_hd__mux4_1
XFILLER_24_106 VGND VGND VPWR VPWR sky130_fd_sc_hd__decap_8
XFILLER_37_489 VGND VGND VPWR VPWR sky130_fd_sc_hd__fill_1
XTAP_TAPCELL_ROW_121_2269 VGND VPWR sky130_fd_sc_hd__tapvpwrvgnd_1
X_09360_ instr_jal decoded_imm_j\[15\] _01589_ mem_rdata_q\[15\] VGND VGND VPWR VPWR
+ _04842_ sky130_fd_sc_hd__a22o_1
XFILLER_52_448 VGND VGND VPWR VPWR sky130_fd_sc_hd__fill_1
X_06572_ _00015_ _02997_ _03000_ _02735_ VGND VGND VPWR VPWR _03001_ sky130_fd_sc_hd__o211a_1
X_09291_ net148 net110 _04206_ VGND VGND VPWR VPWR _00977_ sky130_fd_sc_hd__mux2_1
X_05523_ _02103_ _02105_ VGND VGND VPWR VPWR _02106_ sky130_fd_sc_hd__nor2_1
X_08311_ count_cycle\[19\] _04090_ net34 VGND VGND VPWR VPWR _04093_ sky130_fd_sc_hd__o21ai_1
XANTENNA_13 alu_out_q\[24\] VGND VGND VPWR VPWR sky130_fd_sc_hd__diode_2
XTAP_TAPCELL_ROW_103_1980 VGND VPWR sky130_fd_sc_hd__tapvpwrvgnd_1
X_08242_ decoded_imm_j\[20\] _03718_ VGND VGND VPWR VPWR _04045_ sky130_fd_sc_hd__or2_1
X_05454_ reg_pc\[31\] decoded_imm\[31\] VGND VGND VPWR VPWR _02038_ sky130_fd_sc_hd__xnor2_1
XFILLER_32_161 VGND VGND VPWR VPWR sky130_fd_sc_hd__fill_1
XANTENNA_24 net196 VGND VGND VPWR VPWR sky130_fd_sc_hd__diode_2
XTAP_TAPCELL_ROW_31_830 VGND VPWR sky130_fd_sc_hd__tapvpwrvgnd_1
XANTENNA_35 _04384_ VGND VGND VPWR VPWR sky130_fd_sc_hd__diode_2
X_08173_ _01547_ reg_next_pc\[24\] _01645_ _03711_ VGND VGND VPWR VPWR _03982_ sky130_fd_sc_hd__a22o_1
X_05385_ count_instr\[25\] instr_rdinstr count_cycle\[57\] instr_rdcycleh VGND VGND
+ VPWR VPWR _01975_ sky130_fd_sc_hd__a22o_1
XFILLER_20_389 VPWR VGND VPWR VGND sky130_ef_sc_hd__decap_12
X_07124_ net192 _02721_ _03455_ _01641_ VGND VGND VPWR VPWR _03532_ sky130_fd_sc_hd__o211a_1
XFILLER_21_39 VPWR VGND VPWR VGND sky130_ef_sc_hd__decap_12
XFILLER_137_39 VPWR VGND VPWR VGND sky130_ef_sc_hd__decap_12
XFILLER_134_726 VGND VGND VPWR VPWR sky130_fd_sc_hd__fill_1
X_07055_ cpuregs\[4\]\[27\] cpuregs\[5\]\[27\] cpuregs\[6\]\[27\] cpuregs\[7\]\[27\]
+ net266 net261 VGND VGND VPWR VPWR _03466_ sky130_fd_sc_hd__mux4_1
X_06006_ net188 _02506_ _01582_ VGND VGND VPWR VPWR net81 sky130_fd_sc_hd__mux2_1
Xoutput120 net120 VGND VGND VPWR VPWR mem_la_wdata[30] sky130_fd_sc_hd__buf_2
Xoutput142 net142 VGND VGND VPWR VPWR mem_wdata[16] sky130_fd_sc_hd__buf_2
Xoutput131 net131 VGND VGND VPWR VPWR mem_la_wstrb[1] sky130_fd_sc_hd__buf_2
Xoutput186 net186 VGND VGND VPWR VPWR pcpi_rs1[23] sky130_fd_sc_hd__buf_2
XFILLER_88_813 VGND VGND VPWR VPWR sky130_fd_sc_hd__decap_8
Xoutput153 net153 VGND VGND VPWR VPWR mem_wdata[26] sky130_fd_sc_hd__buf_2
Xoutput175 net175 VGND VGND VPWR VPWR pcpi_rs1[13] sky130_fd_sc_hd__buf_2
XFILLER_0_706 VGND VGND VPWR VPWR sky130_fd_sc_hd__decap_4
Xoutput164 net164 VGND VGND VPWR VPWR mem_wdata[7] sky130_fd_sc_hd__buf_2
XFILLER_153_27 VGND VGND VPWR VPWR sky130_fd_sc_hd__fill_1
XFILLER_102_645 VGND VGND VPWR VPWR sky130_fd_sc_hd__decap_4
XFILLER_102_623 VGND VGND VPWR VPWR sky130_fd_sc_hd__decap_4
XFILLER_101_122 VGND VGND VPWR VPWR sky130_fd_sc_hd__decap_8
XFILLER_101_100 VPWR VGND VPWR VGND sky130_ef_sc_hd__decap_12
XFILLER_88_857 VGND VGND VPWR VPWR sky130_fd_sc_hd__fill_1
XFILLER_87_334 VGND VGND VPWR VPWR sky130_fd_sc_hd__fill_2
Xoutput197 net197 VGND VGND VPWR VPWR pcpi_rs1[4] sky130_fd_sc_hd__buf_2
XFILLER_102_678 VPWR VGND VPWR VGND sky130_ef_sc_hd__decap_12
X_07957_ _03576_ _03782_ VGND VGND VPWR VPWR _03783_ sky130_fd_sc_hd__nor2_1
X_06908_ _03299_ _03321_ _03322_ VGND VGND VPWR VPWR _03324_ sky130_fd_sc_hd__or3b_1
XFILLER_56_732 VGND VGND VPWR VPWR sky130_fd_sc_hd__fill_1
X_07888_ reg_pc\[31\] _01624_ _01628_ _03720_ VGND VGND VPWR VPWR _00675_ sky130_fd_sc_hd__a22o_1
XTAP_TAPCELL_ROW_39_952 VGND VPWR sky130_fd_sc_hd__tapvpwrvgnd_1
XTAP_TAPCELL_ROW_39_963 VGND VPWR sky130_fd_sc_hd__tapvpwrvgnd_1
XFILLER_44_905 VGND VGND VPWR VPWR sky130_fd_sc_hd__decap_3
X_06839_ _00014_ _03256_ _01581_ VGND VGND VPWR VPWR _03258_ sky130_fd_sc_hd__o21a_1
XTAP_TAPCELL_ROW_48_1105 VGND VPWR sky130_fd_sc_hd__tapvpwrvgnd_1
XFILLER_16_629 VGND VGND VPWR VPWR sky130_fd_sc_hd__fill_1
X_09627_ _02586_ cpuregs\[22\]\[0\] _04869_ VGND VGND VPWR VPWR _01286_ sky130_fd_sc_hd__mux2_1
XFILLER_43_404 VGND VGND VPWR VPWR sky130_fd_sc_hd__decap_3
X_09558_ cpuregs\[23\]\[30\] _02709_ _04866_ VGND VGND VPWR VPWR _01220_ sky130_fd_sc_hd__mux2_1
XFILLER_102_53 VPWR VGND VPWR VGND sky130_ef_sc_hd__decap_12
XFILLER_102_97 VGND VGND VPWR VPWR sky130_fd_sc_hd__decap_3
XFILLER_62_24 VGND VGND VPWR VPWR sky130_fd_sc_hd__decap_4
XTAP_TAPCELL_ROW_61_1305 VGND VPWR sky130_fd_sc_hd__tapvpwrvgnd_1
X_08509_ instr_jal cpu_state\[2\] cpu_state\[4\] _01555_ _04213_ VGND VGND VPWR VPWR
+ _04214_ sky130_fd_sc_hd__o41a_1
XFILLER_12_813 VPWR VGND VPWR VGND sky130_ef_sc_hd__decap_12
X_09489_ cpuregs\[24\]\[27\] _02696_ net241 VGND VGND VPWR VPWR _01153_ sky130_fd_sc_hd__mux2_1
XFILLER_23_161 VGND VGND VPWR VPWR sky130_fd_sc_hd__decap_6
XFILLER_134_3 VPWR VGND VPWR VGND sky130_ef_sc_hd__decap_12
X_11451_ clknet_leaf_23_clk _01495_ VGND VGND VPWR VPWR cpuregs\[0\]\[17\] sky130_fd_sc_hd__dfxtp_1
X_10402_ clknet_leaf_54_clk _00532_ VGND VGND VPWR VPWR cpuregs\[20\]\[16\] sky130_fd_sc_hd__dfxtp_1
X_11382_ clknet_leaf_5_clk _01426_ VGND VGND VPWR VPWR cpuregs\[7\]\[12\] sky130_fd_sc_hd__dfxtp_1
X_10333_ clknet_leaf_147_clk _00463_ VGND VGND VPWR VPWR cpuregs\[16\]\[11\] sky130_fd_sc_hd__dfxtp_1
XTAP_TAPCELL_ROW_59_1278 VGND VPWR sky130_fd_sc_hd__tapvpwrvgnd_1
XFILLER_127_94 VPWR VGND VPWR VGND sky130_ef_sc_hd__decap_12
X_10264_ clknet_leaf_1_clk _00394_ VGND VGND VPWR VPWR cpuregs\[15\]\[6\] sky130_fd_sc_hd__dfxtp_1
XFILLER_105_494 VGND VGND VPWR VPWR sky130_fd_sc_hd__decap_6
XTAP_TAPCELL_ROW_72_1478 VGND VPWR sky130_fd_sc_hd__tapvpwrvgnd_1
X_10195_ clknet_leaf_117_clk _00325_ VGND VGND VPWR VPWR cpuregs\[14\]\[1\] sky130_fd_sc_hd__dfxtp_1
XTAP_TAPCELL_ROW_72_1489 VGND VPWR sky130_fd_sc_hd__tapvpwrvgnd_1
XFILLER_35_905 VGND VGND VPWR VPWR sky130_fd_sc_hd__decap_3
XFILLER_74_562 VGND VGND VPWR VPWR sky130_fd_sc_hd__decap_8
XTAP_TAPCELL_ROW_17_602 VGND VPWR sky130_fd_sc_hd__tapvpwrvgnd_1
XFILLER_46_253 VPWR VGND VPWR VGND sky130_ef_sc_hd__decap_12
XFILLER_62_757 VGND VGND VPWR VPWR sky130_fd_sc_hd__decap_4
XFILLER_147_306 VGND VGND VPWR VPWR sky130_fd_sc_hd__fill_1
Xinput22 mem_rdata[29] VGND VGND VPWR VPWR net22 sky130_fd_sc_hd__buf_2
Xinput11 mem_rdata[19] VGND VGND VPWR VPWR net11 sky130_fd_sc_hd__buf_2
X_05170_ count_cycle\[8\] _01588_ net256 _01776_ VGND VGND VPWR VPWR _01777_ sky130_fd_sc_hd__o211a_1
Xinput33 mem_ready VGND VGND VPWR VPWR net33 sky130_fd_sc_hd__dlymetal6s2s_1
XFILLER_115_225 VPWR VGND VPWR VGND sky130_ef_sc_hd__decap_12
XFILLER_6_393 VGND VGND VPWR VPWR sky130_fd_sc_hd__decap_4
XFILLER_131_729 VGND VGND VPWR VPWR sky130_fd_sc_hd__fill_1
XFILLER_115_269 VGND VGND VPWR VPWR sky130_fd_sc_hd__fill_2
X_08860_ net215 _01585_ _04540_ _04541_ VGND VGND VPWR VPWR _00826_ sky130_fd_sc_hd__o22a_1
XFILLER_96_120 VPWR VGND VPWR VGND sky130_ef_sc_hd__decap_12
XFILLER_69_312 VGND VGND VPWR VPWR sky130_fd_sc_hd__fill_2
X_07811_ _03674_ count_instr\[58\] count_instr\[57\] count_instr\[59\] VGND VGND VPWR
+ VPWR _03679_ sky130_fd_sc_hd__and4_1
XFILLER_97_687 VPWR VGND VPWR VGND sky130_ef_sc_hd__decap_12
XFILLER_96_153 VGND VGND VPWR VPWR sky130_fd_sc_hd__decap_6
XFILLER_111_497 VGND VGND VPWR VPWR sky130_fd_sc_hd__decap_6
X_08791_ cpuregs\[12\]\[17\] cpuregs\[13\]\[17\] cpuregs\[14\]\[17\] cpuregs\[15\]\[17\]
+ net277 net272 VGND VGND VPWR VPWR _04476_ sky130_fd_sc_hd__mux4_1
XFILLER_85_849 VGND VGND VPWR VPWR sky130_fd_sc_hd__fill_1
XFILLER_85_838 VGND VGND VPWR VPWR sky130_fd_sc_hd__fill_2
X_07742_ count_instr\[33\] _03634_ _01549_ VGND VGND VPWR VPWR _03636_ sky130_fd_sc_hd__a21oi_1
XFILLER_26_905 VGND VGND VPWR VPWR sky130_fd_sc_hd__decap_3
XFILLER_37_220 VGND VGND VPWR VPWR sky130_fd_sc_hd__decap_4
X_04954_ _01549_ _01552_ VGND VGND VPWR VPWR _01585_ sky130_fd_sc_hd__nor2_8
XFILLER_65_584 VGND VGND VPWR VPWR sky130_fd_sc_hd__fill_1
X_07673_ count_instr\[8\] net393 _01549_ VGND VGND VPWR VPWR _03592_ sky130_fd_sc_hd__a21oi_1
XFILLER_53_724 VGND VGND VPWR VPWR sky130_fd_sc_hd__decap_4
XTAP_TAPCELL_ROW_36_900 VGND VPWR sky130_fd_sc_hd__tapvpwrvgnd_1
XTAP_TAPCELL_ROW_36_911 VGND VPWR sky130_fd_sc_hd__tapvpwrvgnd_1
X_09412_ _02649_ cpuregs\[18\]\[16\] _04862_ VGND VGND VPWR VPWR _01046_ sky130_fd_sc_hd__mux2_1
XFILLER_92_392 VGND VGND VPWR VPWR sky130_fd_sc_hd__fill_1
X_06624_ net258 _03049_ _01581_ VGND VGND VPWR VPWR _03051_ sky130_fd_sc_hd__o21a_1
XFILLER_37_297 VGND VGND VPWR VPWR sky130_fd_sc_hd__decap_4
X_09343_ decoded_imm\[24\] _04746_ _04825_ _04833_ VGND VGND VPWR VPWR _01006_ sky130_fd_sc_hd__o22a_1
X_06555_ net172 _02720_ _02983_ _01641_ VGND VGND VPWR VPWR _02984_ sky130_fd_sc_hd__o211a_1
XFILLER_52_278 VGND VGND VPWR VPWR sky130_fd_sc_hd__decap_3
XTAP_TAPCELL_ROW_43_1013 VGND VPWR sky130_fd_sc_hd__tapvpwrvgnd_1
XTAP_TAPCELL_ROW_43_1024 VGND VPWR sky130_fd_sc_hd__tapvpwrvgnd_1
XTAP_TAPCELL_ROW_138_2541 VGND VPWR sky130_fd_sc_hd__tapvpwrvgnd_1
X_05506_ _02086_ _02087_ VGND VGND VPWR VPWR _02089_ sky130_fd_sc_hd__or2_1
X_09274_ net161 net123 _04206_ VGND VGND VPWR VPWR _00960_ sky130_fd_sc_hd__mux2_1
XFILLER_32_27 VGND VGND VPWR VPWR sky130_fd_sc_hd__fill_1
X_06486_ _01579_ _02910_ _00016_ VGND VGND VPWR VPWR _02918_ sky130_fd_sc_hd__o21a_1
XFILLER_148_27 VGND VGND VPWR VPWR sky130_fd_sc_hd__fill_1
X_08225_ _03717_ _04024_ VGND VGND VPWR VPWR _04029_ sky130_fd_sc_hd__nand2_1
X_05437_ count_instr\[29\] instr_rdinstr _01587_ _02022_ VGND VGND VPWR VPWR _02023_
+ sky130_fd_sc_hd__a211o_1
XFILLER_153_309 VGND VGND VPWR VPWR sky130_fd_sc_hd__decap_8
X_08156_ decoded_imm_j\[20\] _03710_ VGND VGND VPWR VPWR _03966_ sky130_fd_sc_hd__xor2_1
X_05368_ reg_pc\[24\] decoded_imm\[24\] VGND VGND VPWR VPWR _01959_ sky130_fd_sc_hd__nand2_1
XFILLER_107_704 VPWR VGND VPWR VGND sky130_ef_sc_hd__decap_12
XFILLER_5_809 VPWR VGND VPWR VGND sky130_ef_sc_hd__decap_12
XFILLER_20_197 VGND VGND VPWR VPWR sky130_fd_sc_hd__fill_2
XTAP_TAPCELL_ROW_151_2752 VGND VPWR sky130_fd_sc_hd__tapvpwrvgnd_1
XTAP_TAPCELL_ROW_151_2741 VGND VPWR sky130_fd_sc_hd__tapvpwrvgnd_1
XFILLER_147_895 VGND VGND VPWR VPWR sky130_fd_sc_hd__fill_1
X_07107_ cpuregs\[12\]\[29\] cpuregs\[13\]\[29\] cpuregs\[14\]\[29\] cpuregs\[15\]\[29\]
+ net266 net261 VGND VGND VPWR VPWR _03516_ sky130_fd_sc_hd__mux4_1
XFILLER_106_214 VGND VGND VPWR VPWR sky130_fd_sc_hd__fill_2
XFILLER_106_247 VGND VGND VPWR VPWR sky130_fd_sc_hd__decap_4
X_08087_ _03704_ _03885_ _01551_ VGND VGND VPWR VPWR _03903_ sky130_fd_sc_hd__o21ai_1
X_05299_ cpu_state\[6\] _01860_ _01891_ _01895_ VGND VGND VPWR VPWR _01896_ sky130_fd_sc_hd__a31o_1
XFILLER_134_589 VPWR VGND VPWR VGND sky130_ef_sc_hd__decap_12
XFILLER_106_269 VGND VGND VPWR VPWR sky130_fd_sc_hd__fill_1
X_07038_ decoded_imm\[27\] net190 VGND VGND VPWR VPWR _03449_ sky130_fd_sc_hd__and2_1
XFILLER_0_514 VGND VGND VPWR VPWR sky130_fd_sc_hd__decap_3
XFILLER_88_676 VGND VGND VPWR VPWR sky130_fd_sc_hd__decap_8
XTAP_TAPCELL_ROW_54_1197 VGND VPWR sky130_fd_sc_hd__tapvpwrvgnd_1
X_08989_ decoded_imm\[27\] _01654_ _01586_ VGND VGND VPWR VPWR _04664_ sky130_fd_sc_hd__a21o_1
XFILLER_75_337 VPWR VGND VPWR VGND sky130_ef_sc_hd__decap_12
XFILLER_57_57 VGND VGND VPWR VPWR sky130_fd_sc_hd__decap_4
XFILLER_91_819 VGND VGND VPWR VPWR sky130_fd_sc_hd__fill_2
XFILLER_57_79 VGND VGND VPWR VPWR sky130_fd_sc_hd__decap_3
XFILLER_28_231 VGND VGND VPWR VPWR sky130_fd_sc_hd__decap_6
X_10951_ clknet_leaf_88_clk _01013_ VGND VGND VPWR VPWR decoded_imm\[17\] sky130_fd_sc_hd__dfxtp_4
XTAP_TAPCELL_ROW_3_385 VGND VPWR sky130_fd_sc_hd__tapvpwrvgnd_1
XTAP_TAPCELL_ROW_3_374 VGND VPWR sky130_fd_sc_hd__tapvpwrvgnd_1
XFILLER_28_253 VGND VGND VPWR VPWR sky130_fd_sc_hd__decap_6
XFILLER_28_275 VGND VGND VPWR VPWR sky130_fd_sc_hd__decap_6
XFILLER_43_234 VGND VGND VPWR VPWR sky130_fd_sc_hd__decap_4
X_10882_ clknet_leaf_45_clk _00944_ VGND VGND VPWR VPWR cpuregs\[1\]\[26\] sky130_fd_sc_hd__dfxtp_1
XFILLER_71_576 VPWR VGND VPWR VGND sky130_ef_sc_hd__decap_12
XPHY_EDGE_ROW_125_Right_125 VGND VGND VPWR VPWR sky130_fd_sc_hd__decap_3
XFILLER_7_113 VPWR VGND VPWR VGND sky130_ef_sc_hd__decap_12
XFILLER_12_687 VGND VGND VPWR VPWR sky130_fd_sc_hd__fill_1
XFILLER_144_309 VPWR VGND VPWR VGND sky130_ef_sc_hd__decap_12
XTAP_TAPCELL_ROW_22_682 VGND VPWR sky130_fd_sc_hd__tapvpwrvgnd_1
X_11434_ clknet_leaf_127_clk _01478_ VGND VGND VPWR VPWR cpuregs\[0\]\[0\] sky130_fd_sc_hd__dfxtp_1
XFILLER_153_832 VGND VGND VPWR VPWR sky130_fd_sc_hd__decap_4
XFILLER_125_512 VPWR VGND VPWR VGND sky130_ef_sc_hd__decap_12
X_11365_ clknet_leaf_37_clk _01409_ VGND VGND VPWR VPWR cpuregs\[6\]\[27\] sky130_fd_sc_hd__dfxtp_1
XTAP_TAPCELL_ROW_74_1518 VGND VPWR sky130_fd_sc_hd__tapvpwrvgnd_1
Xclkbuf_leaf_100_clk clknet_4_9_0_clk VGND VGND VPWR VPWR clknet_leaf_100_clk sky130_fd_sc_hd__clkbuf_8
X_11296_ clknet_leaf_48_clk _01343_ VGND VGND VPWR VPWR cpuregs\[4\]\[25\] sky130_fd_sc_hd__dfxtp_1
X_10316_ clknet_leaf_43_clk _00446_ VGND VGND VPWR VPWR cpuregs\[26\]\[26\] sky130_fd_sc_hd__dfxtp_1
X_10247_ clknet_leaf_80_clk _00377_ VGND VGND VPWR VPWR cpuregs\[27\]\[21\] sky130_fd_sc_hd__dfxtp_1
XFILLER_106_781 VGND VGND VPWR VPWR sky130_fd_sc_hd__fill_2
XFILLER_3_385 VGND VGND VPWR VPWR sky130_fd_sc_hd__decap_6
XFILLER_79_654 VGND VGND VPWR VPWR sky130_fd_sc_hd__fill_1
XFILLER_78_153 VPWR VGND VPWR VGND sky130_ef_sc_hd__decap_12
X_10178_ clknet_leaf_21_clk _00308_ VGND VGND VPWR VPWR cpuregs\[9\]\[16\] sky130_fd_sc_hd__dfxtp_1
XFILLER_39_529 VPWR VGND VPWR VGND sky130_ef_sc_hd__decap_12
XFILLER_120_283 VGND VGND VPWR VPWR sky130_fd_sc_hd__fill_1
XTAP_TAPCELL_ROW_105_2006 VGND VPWR sky130_fd_sc_hd__tapvpwrvgnd_1
XFILLER_93_134 VGND VGND VPWR VPWR sky130_fd_sc_hd__fill_1
XTAP_TAPCELL_ROW_89_1750 VGND VPWR sky130_fd_sc_hd__tapvpwrvgnd_1
XFILLER_82_808 VGND VGND VPWR VPWR sky130_fd_sc_hd__decap_4
XFILLER_78_197 VGND VGND VPWR VPWR sky130_fd_sc_hd__fill_2
XTAP_TAPCELL_ROW_105_2017 VGND VPWR sky130_fd_sc_hd__tapvpwrvgnd_1
XTAP_TAPCELL_ROW_89_1761 VGND VPWR sky130_fd_sc_hd__tapvpwrvgnd_1
XFILLER_47_595 VGND VGND VPWR VPWR sky130_fd_sc_hd__fill_2
XFILLER_35_768 VGND VGND VPWR VPWR sky130_fd_sc_hd__decap_3
XFILLER_50_738 VGND VGND VPWR VPWR sky130_fd_sc_hd__decap_8
X_06340_ _01579_ _02771_ _02775_ _01581_ VGND VGND VPWR VPWR _02776_ sky130_fd_sc_hd__a211oi_1
XFILLER_147_125 VPWR VGND VPWR VGND sky130_ef_sc_hd__decap_12
X_06271_ reg_pc\[31\] _02707_ VGND VGND VPWR VPWR _02710_ sky130_fd_sc_hd__xnor2_1
XFILLER_147_169 VPWR VGND VPWR VGND sky130_ef_sc_hd__decap_12
X_05222_ count_instr\[12\] instr_rdinstr count_cycle\[44\] instr_rdcycleh VGND VGND
+ VPWR VPWR _01825_ sky130_fd_sc_hd__a22o_1
X_08010_ _03817_ _03823_ _03830_ VGND VGND VPWR VPWR _03831_ sky130_fd_sc_hd__o21ai_1
XTAP_TAPCELL_ROW_41_980 VGND VPWR sky130_fd_sc_hd__tapvpwrvgnd_1
XTAP_TAPCELL_ROW_41_991 VGND VPWR sky130_fd_sc_hd__tapvpwrvgnd_1
XFILLER_129_895 VGND VGND VPWR VPWR sky130_fd_sc_hd__fill_1
XFILLER_118_19 VGND VGND VPWR VPWR sky130_fd_sc_hd__decap_8
XTAP_TAPCELL_ROW_133_2460 VGND VPWR sky130_fd_sc_hd__tapvpwrvgnd_1
X_05153_ count_instr\[39\] instr_rdinstrh instr_rdcycleh count_cycle\[39\] VGND VGND
+ VPWR VPWR _01761_ sky130_fd_sc_hd__a22o_1
X_09961_ clknet_leaf_62_clk _00091_ VGND VGND VPWR VPWR net185 sky130_fd_sc_hd__dfxtp_4
X_05084_ _01687_ _01693_ _01695_ VGND VGND VPWR VPWR _01697_ sky130_fd_sc_hd__and3b_1
X_08912_ _04588_ _04590_ _04266_ _04587_ VGND VGND VPWR VPWR _04591_ sky130_fd_sc_hd__o211a_1
X_09892_ cpuregs\[0\]\[22\] VGND VGND VPWR VPWR _01500_ sky130_fd_sc_hd__clkbuf_1
XFILLER_134_29 VPWR VGND VPWR VGND sky130_ef_sc_hd__decap_12
XFILLER_112_751 VGND VGND VPWR VPWR sky130_fd_sc_hd__decap_4
XFILLER_112_740 VGND VGND VPWR VPWR sky130_fd_sc_hd__fill_2
X_08843_ cpuregs\[16\]\[20\] cpuregs\[17\]\[20\] cpuregs\[18\]\[20\] cpuregs\[19\]\[20\]
+ _00007_ net274 VGND VGND VPWR VPWR _04525_ sky130_fd_sc_hd__mux4_1
XFILLER_97_484 VGND VGND VPWR VPWR sky130_fd_sc_hd__decap_3
XFILLER_57_304 VGND VGND VPWR VPWR sky130_fd_sc_hd__decap_4
X_05986_ net177 _02496_ _01582_ VGND VGND VPWR VPWR net71 sky130_fd_sc_hd__mux2_1
X_08774_ cpuregs\[28\]\[16\] cpuregs\[29\]\[16\] cpuregs\[30\]\[16\] cpuregs\[31\]\[16\]
+ net276 net272 VGND VGND VPWR VPWR _04460_ sky130_fd_sc_hd__mux4_1
XFILLER_27_27 VPWR VGND VPWR VGND sky130_ef_sc_hd__decap_12
X_07725_ _03624_ _03625_ VGND VGND VPWR VPWR _00607_ sky130_fd_sc_hd__nor2_1
XTAP_TAPCELL_ROW_0_311 VGND VPWR sky130_fd_sc_hd__tapvpwrvgnd_1
X_04937_ net108 VGND VGND VPWR VPWR _01570_ sky130_fd_sc_hd__inv_2
XFILLER_81_841 VPWR VGND VPWR VGND sky130_ef_sc_hd__decap_12
XFILLER_65_381 VGND VGND VPWR VPWR sky130_fd_sc_hd__fill_1
XTAP_TAPCELL_ROW_0_322 VGND VPWR sky130_fd_sc_hd__tapvpwrvgnd_1
XTAP_TAPCELL_ROW_0_333 VGND VPWR sky130_fd_sc_hd__tapvpwrvgnd_1
XFILLER_26_757 VGND VGND VPWR VPWR sky130_fd_sc_hd__decap_6
X_07656_ count_instr\[2\] _03579_ VGND VGND VPWR VPWR _03581_ sky130_fd_sc_hd__and2_1
X_06607_ decoded_imm\[11\] net173 VGND VGND VPWR VPWR _03034_ sky130_fd_sc_hd__nor2_1
X_07587_ cpuregs\[20\]\[4\] _02598_ net245 VGND VGND VPWR VPWR _00520_ sky130_fd_sc_hd__mux2_1
XFILLER_40_215 VPWR VGND VPWR VGND sky130_ef_sc_hd__decap_12
X_09326_ mem_rdata_q\[31\] _04823_ _04747_ VGND VGND VPWR VPWR _04824_ sky130_fd_sc_hd__a21o_2
XFILLER_21_440 VGND VGND VPWR VPWR sky130_fd_sc_hd__decap_8
X_06538_ cpuregs\[20\]\[8\] cpuregs\[21\]\[8\] cpuregs\[22\]\[8\] cpuregs\[23\]\[8\]
+ net263 net259 VGND VGND VPWR VPWR _02968_ sky130_fd_sc_hd__mux4_1
XTAP_TAPCELL_ROW_153_2803 VGND VPWR sky130_fd_sc_hd__tapvpwrvgnd_1
X_09257_ _04800_ net65 _04208_ VGND VGND VPWR VPWR _00953_ sky130_fd_sc_hd__mux2_1
X_08208_ _03986_ _03997_ _04013_ _04012_ VGND VGND VPWR VPWR _04014_ sky130_fd_sc_hd__o31ai_2
X_06469_ _02897_ _02900_ VGND VGND VPWR VPWR _02901_ sky130_fd_sc_hd__nand2_1
XFILLER_135_821 VPWR VGND VPWR VGND sky130_ef_sc_hd__decap_12
X_09188_ mem_rdata_q\[30\] net24 _01609_ VGND VGND VPWR VPWR _01124_ sky130_fd_sc_hd__mux2_1
XFILLER_5_617 VPWR VGND VPWR VGND sky130_ef_sc_hd__decap_12
XFILLER_135_865 VPWR VGND VPWR VGND sky130_ef_sc_hd__decap_12
X_08139_ instr_jal _03947_ _03948_ _03950_ VGND VGND VPWR VPWR _03951_ sky130_fd_sc_hd__a31o_1
XFILLER_150_813 VPWR VGND VPWR VGND sky130_ef_sc_hd__decap_12
XFILLER_108_41 VGND VGND VPWR VPWR sky130_fd_sc_hd__decap_8
XTAP_TAPCELL_ROW_56_1226 VGND VPWR sky130_fd_sc_hd__tapvpwrvgnd_1
X_11150_ clknet_leaf_144_clk _01197_ VGND VGND VPWR VPWR cpuregs\[23\]\[7\] sky130_fd_sc_hd__dfxtp_1
XTAP_TAPCELL_ROW_8_455 VGND VPWR sky130_fd_sc_hd__tapvpwrvgnd_1
X_10101_ clknet_leaf_122_clk _00231_ VGND VGND VPWR VPWR cpuregs\[28\]\[3\] sky130_fd_sc_hd__dfxtp_1
X_11081_ clknet_leaf_11_clk _01138_ VGND VGND VPWR VPWR cpuregs\[24\]\[12\] sky130_fd_sc_hd__dfxtp_1
XTAP_TAPCELL_ROW_8_466 VGND VPWR sky130_fd_sc_hd__tapvpwrvgnd_1
XFILLER_103_773 VGND VGND VPWR VPWR sky130_fd_sc_hd__decap_6
X_10032_ clknet_leaf_24_clk _00162_ VGND VGND VPWR VPWR cpuregs\[30\]\[30\] sky130_fd_sc_hd__dfxtp_1
XFILLER_48_304 VGND VGND VPWR VPWR sky130_fd_sc_hd__fill_1
XFILLER_0_399 VGND VGND VPWR VPWR sky130_fd_sc_hd__decap_3
XFILLER_91_638 VPWR VGND VPWR VGND sky130_ef_sc_hd__decap_12
XFILLER_63_329 VGND VGND VPWR VPWR sky130_fd_sc_hd__decap_6
Xclkbuf_leaf_149_clk clknet_4_0_0_clk VGND VGND VPWR VPWR clknet_leaf_149_clk sky130_fd_sc_hd__clkbuf_8
XFILLER_16_201 VGND VGND VPWR VPWR sky130_fd_sc_hd__fill_1
XTAP_TAPCELL_ROW_27_763 VGND VPWR sky130_fd_sc_hd__tapvpwrvgnd_1
X_10934_ clknet_leaf_112_clk _00996_ VGND VGND VPWR VPWR latched_rd\[4\] sky130_fd_sc_hd__dfxtp_2
XFILLER_44_565 VPWR VGND VPWR VGND sky130_ef_sc_hd__decap_12
XFILLER_140_83 VGND VGND VPWR VPWR sky130_fd_sc_hd__fill_1
XTAP_TAPCELL_ROW_84_1680 VGND VPWR sky130_fd_sc_hd__tapvpwrvgnd_1
XFILLER_72_896 VGND VGND VPWR VPWR sky130_fd_sc_hd__decap_8
XFILLER_71_373 VPWR VGND VPWR VGND sky130_ef_sc_hd__decap_12
XTAP_TAPCELL_ROW_67_1399 VGND VPWR sky130_fd_sc_hd__tapvpwrvgnd_1
XFILLER_17_93 VGND VGND VPWR VPWR sky130_fd_sc_hd__decap_8
X_10865_ clknet_leaf_150_clk _00927_ VGND VGND VPWR VPWR cpuregs\[1\]\[9\] sky130_fd_sc_hd__dfxtp_1
XFILLER_31_237 VGND VGND VPWR VPWR sky130_fd_sc_hd__decap_3
XFILLER_83_9 VPWR VGND VPWR VGND sky130_ef_sc_hd__decap_12
X_10796_ clknet_leaf_98_clk _00861_ VGND VGND VPWR VPWR instr_addi sky130_fd_sc_hd__dfxtp_1
XFILLER_149_81 VPWR VGND VPWR VGND sky130_ef_sc_hd__decap_12
XFILLER_129_169 VGND VGND VPWR VPWR sky130_fd_sc_hd__fill_2
XFILLER_117_309 VGND VGND VPWR VPWR sky130_fd_sc_hd__decap_6
X_11417_ clknet_leaf_15_clk _01461_ VGND VGND VPWR VPWR cpuregs\[8\]\[15\] sky130_fd_sc_hd__dfxtp_1
XFILLER_153_673 VPWR VGND VPWR VGND sky130_ef_sc_hd__decap_12
X_11348_ clknet_leaf_3_clk _01392_ VGND VGND VPWR VPWR cpuregs\[6\]\[10\] sky130_fd_sc_hd__dfxtp_1
XFILLER_3_193 VPWR VGND VPWR VGND sky130_ef_sc_hd__decap_12
X_11279_ clknet_leaf_136_clk _01326_ VGND VGND VPWR VPWR cpuregs\[4\]\[8\] sky130_fd_sc_hd__dfxtp_1
XFILLER_121_570 VPWR VGND VPWR VGND sky130_ef_sc_hd__decap_12
XFILLER_67_624 VPWR VGND VPWR VGND sky130_ef_sc_hd__decap_12
X_05840_ _02089_ _02400_ VGND VGND VPWR VPWR _02401_ sky130_fd_sc_hd__nand2_1
XFILLER_94_443 VGND VGND VPWR VPWR sky130_fd_sc_hd__decap_3
XFILLER_94_421 VPWR VGND VPWR VGND sky130_ef_sc_hd__decap_12
XFILLER_66_134 VGND VGND VPWR VPWR sky130_fd_sc_hd__decap_6
XFILLER_12_3 VPWR VGND VPWR VGND sky130_ef_sc_hd__decap_12
XFILLER_39_337 VGND VGND VPWR VPWR sky130_fd_sc_hd__decap_4
XFILLER_54_307 VGND VGND VPWR VPWR sky130_fd_sc_hd__fill_1
X_07510_ cpuregs\[26\]\[28\] _02699_ _03568_ VGND VGND VPWR VPWR _00448_ sky130_fd_sc_hd__mux2_1
X_05771_ _02241_ _02338_ _02339_ _02332_ VGND VGND VPWR VPWR alu_out\[14\] sky130_fd_sc_hd__a31o_1
X_08490_ net74 net43 _04208_ VGND VGND VPWR VPWR _00788_ sky130_fd_sc_hd__mux2_1
X_07441_ cpuregs\[27\]\[25\] _02688_ _03566_ VGND VGND VPWR VPWR _00381_ sky130_fd_sc_hd__mux2_1
X_07372_ _02678_ cpuregs\[9\]\[23\] _03563_ VGND VGND VPWR VPWR _00315_ sky130_fd_sc_hd__mux2_1
XFILLER_22_248 VGND VGND VPWR VPWR sky130_fd_sc_hd__decap_4
XFILLER_148_401 VGND VGND VPWR VPWR sky130_fd_sc_hd__decap_3
XTAP_TAPCELL_ROW_118_2219 VGND VPWR sky130_fd_sc_hd__tapvpwrvgnd_1
X_09111_ mem_rdata_q\[13\] net5 _01609_ VGND VGND VPWR VPWR _01107_ sky130_fd_sc_hd__mux2_1
X_06323_ _02752_ _02753_ _02758_ _02759_ _01579_ _00016_ VGND VGND VPWR VPWR _02760_
+ sky130_fd_sc_hd__mux4_1
XFILLER_129_670 VGND VGND VPWR VPWR sky130_fd_sc_hd__fill_2
X_06254_ _02696_ cpuregs\[11\]\[27\] _02582_ VGND VGND VPWR VPWR _00064_ sky130_fd_sc_hd__mux2_1
XFILLER_108_309 VGND VGND VPWR VPWR sky130_fd_sc_hd__decap_8
X_09042_ cpuregs\[20\]\[31\] cpuregs\[21\]\[31\] cpuregs\[22\]\[31\] cpuregs\[23\]\[31\]
+ net276 net272 VGND VGND VPWR VPWR _04713_ sky130_fd_sc_hd__mux4_1
XFILLER_128_180 VGND VGND VPWR VPWR sky130_fd_sc_hd__decap_6
XFILLER_117_854 VPWR VGND VPWR VGND sky130_ef_sc_hd__decap_12
XFILLER_117_832 VGND VGND VPWR VPWR sky130_fd_sc_hd__decap_8
X_06185_ _02639_ _02640_ _02584_ VGND VGND VPWR VPWR _02641_ sky130_fd_sc_hd__mux2_8
X_05205_ cpu_state\[4\] net173 _01803_ cpu_state\[3\] _01805_ VGND VGND VPWR VPWR
+ _01809_ sky130_fd_sc_hd__a221o_1
XFILLER_150_109 VPWR VGND VPWR VGND sky130_ef_sc_hd__decap_12
XFILLER_132_813 VPWR VGND VPWR VGND sky130_ef_sc_hd__decap_12
X_05136_ _01743_ _01744_ _01737_ VGND VGND VPWR VPWR _01745_ sky130_fd_sc_hd__nand3b_1
XFILLER_145_39 VPWR VGND VPWR VGND sky130_ef_sc_hd__decap_12
XFILLER_143_161 VGND VGND VPWR VPWR sky130_fd_sc_hd__decap_6
XFILLER_131_312 VGND VGND VPWR VPWR sky130_fd_sc_hd__decap_8
XFILLER_104_526 VGND VGND VPWR VPWR sky130_fd_sc_hd__decap_6
X_05067_ net32 net18 net606 VGND VGND VPWR VPWR _01681_ sky130_fd_sc_hd__mux2_1
X_09944_ clknet_leaf_134_clk _00074_ VGND VGND VPWR VPWR net198 sky130_fd_sc_hd__dfxtp_4
XFILLER_131_389 VGND VGND VPWR VPWR sky130_fd_sc_hd__decap_3
X_09875_ cpuregs\[0\]\[5\] VGND VGND VPWR VPWR _01483_ sky130_fd_sc_hd__clkbuf_1
XTAP_TAPCELL_ROW_5_414 VGND VPWR sky130_fd_sc_hd__tapvpwrvgnd_1
XFILLER_38_15 VPWR VGND VPWR VGND sky130_ef_sc_hd__decap_12
XTAP_TAPCELL_ROW_146_2662 VGND VPWR sky130_fd_sc_hd__tapvpwrvgnd_1
X_08826_ cpuregs\[12\]\[19\] cpuregs\[13\]\[19\] cpuregs\[14\]\[19\] cpuregs\[15\]\[19\]
+ net280 net274 VGND VGND VPWR VPWR _04509_ sky130_fd_sc_hd__mux4_1
XFILLER_100_754 VGND VGND VPWR VPWR sky130_fd_sc_hd__fill_2
XFILLER_58_657 VGND VGND VPWR VPWR sky130_fd_sc_hd__decap_4
XTAP_TAPCELL_ROW_51_1145 VGND VPWR sky130_fd_sc_hd__tapvpwrvgnd_1
XTAP_TAPCELL_ROW_146_2673 VGND VPWR sky130_fd_sc_hd__tapvpwrvgnd_1
XFILLER_85_487 VGND VGND VPWR VPWR sky130_fd_sc_hd__fill_2
XFILLER_85_465 VGND VGND VPWR VPWR sky130_fd_sc_hd__fill_1
XFILLER_45_307 VGND VGND VPWR VPWR sky130_fd_sc_hd__decap_8
XFILLER_85_498 VGND VGND VPWR VPWR sky130_fd_sc_hd__decap_6
X_08757_ net270 _04443_ VGND VGND VPWR VPWR _04444_ sky130_fd_sc_hd__or2_1
X_05969_ reg_out\[7\] reg_next_pc\[7\] net597 VGND VGND VPWR VPWR _02488_ sky130_fd_sc_hd__mux2_1
X_07708_ count_instr\[21\] count_instr\[20\] VGND VGND VPWR VPWR _03614_ sky130_fd_sc_hd__and2_1
X_08688_ cpuregs\[16\]\[11\] cpuregs\[17\]\[11\] cpuregs\[18\]\[11\] cpuregs\[19\]\[11\]
+ net279 _00008_ VGND VGND VPWR VPWR _04379_ sky130_fd_sc_hd__mux4_1
XFILLER_26_554 VGND VGND VPWR VPWR sky130_fd_sc_hd__decap_6
X_07639_ _02678_ cpuregs\[17\]\[23\] _03574_ VGND VGND VPWR VPWR _00571_ sky130_fd_sc_hd__mux2_1
XFILLER_81_671 VGND VGND VPWR VPWR sky130_fd_sc_hd__fill_1
XTAP_TAPCELL_ROW_24_711 VGND VPWR sky130_fd_sc_hd__tapvpwrvgnd_1
X_10650_ clknet_leaf_131_clk _04908_ VGND VGND VPWR VPWR reg_out\[8\] sky130_fd_sc_hd__dfxtp_1
XTAP_TAPCELL_ROW_24_722 VGND VPWR sky130_fd_sc_hd__tapvpwrvgnd_1
X_09309_ net133 _04208_ _04814_ _04207_ VGND VGND VPWR VPWR _00991_ sky130_fd_sc_hd__o211a_1
XFILLER_21_270 VGND VGND VPWR VPWR sky130_fd_sc_hd__decap_3
X_10581_ clknet_leaf_109_clk _00711_ VGND VGND VPWR VPWR count_cycle\[4\] sky130_fd_sc_hd__dfxtp_1
XFILLER_127_629 VGND VGND VPWR VPWR sky130_fd_sc_hd__decap_4
XFILLER_79_11 VPWR VGND VPWR VGND sky130_ef_sc_hd__decap_12
XFILLER_5_447 VGND VGND VPWR VPWR sky130_fd_sc_hd__fill_1
XFILLER_5_425 VGND VGND VPWR VPWR sky130_fd_sc_hd__fill_1
X_11202_ clknet_leaf_42_clk _01249_ VGND VGND VPWR VPWR cpuregs\[29\]\[27\] sky130_fd_sc_hd__dfxtp_1
XFILLER_119_73 VGND VGND VPWR VPWR sky130_fd_sc_hd__decap_8
XFILLER_108_876 VGND VGND VPWR VPWR sky130_fd_sc_hd__fill_1
XFILLER_107_364 VPWR VGND VPWR VGND sky130_ef_sc_hd__decap_12
XFILLER_79_55 VGND VGND VPWR VPWR sky130_fd_sc_hd__fill_1
X_11133_ clknet_leaf_43_clk _01180_ VGND VGND VPWR VPWR cpuregs\[31\]\[22\] sky130_fd_sc_hd__dfxtp_1
XFILLER_122_356 VGND VGND VPWR VPWR sky130_fd_sc_hd__decap_8
XFILLER_96_708 VGND VGND VPWR VPWR sky130_fd_sc_hd__decap_8
XFILLER_95_229 VGND VGND VPWR VPWR sky130_fd_sc_hd__fill_1
XFILLER_89_782 VGND VGND VPWR VPWR sky130_fd_sc_hd__fill_2
X_11064_ clknet_leaf_100_clk _01121_ VGND VGND VPWR VPWR mem_rdata_q\[27\] sky130_fd_sc_hd__dfxtp_1
XFILLER_0_141 VPWR VGND VPWR VGND sky130_ef_sc_hd__decap_12
X_10015_ clknet_leaf_10_clk _00145_ VGND VGND VPWR VPWR cpuregs\[30\]\[13\] sky130_fd_sc_hd__dfxtp_1
XFILLER_48_112 VGND VGND VPWR VPWR sky130_fd_sc_hd__fill_1
XFILLER_1_697 VPWR VGND VPWR VGND sky130_ef_sc_hd__decap_12
XTAP_TAPCELL_ROW_69_1428 VGND VPWR sky130_fd_sc_hd__tapvpwrvgnd_1
XTAP_TAPCELL_ROW_69_1439 VGND VPWR sky130_fd_sc_hd__tapvpwrvgnd_1
XFILLER_28_81 VGND VGND VPWR VPWR sky130_fd_sc_hd__decap_3
XFILLER_151_93 VPWR VGND VPWR VGND sky130_ef_sc_hd__decap_12
XFILLER_17_532 VPWR VGND VPWR VGND sky130_ef_sc_hd__decap_12
X_10917_ clknet_leaf_31_clk _00979_ VGND VGND VPWR VPWR net150 sky130_fd_sc_hd__dfxtp_1
XTAP_TAPCELL_ROW_82_1639 VGND VPWR sky130_fd_sc_hd__tapvpwrvgnd_1
X_10848_ clknet_leaf_102_clk _00912_ VGND VGND VPWR VPWR is_lb_lh_lw_lbu_lhu sky130_fd_sc_hd__dfxtp_2
XFILLER_146_905 VGND VGND VPWR VPWR sky130_fd_sc_hd__decap_4
X_10779_ clknet_leaf_102_clk _00844_ VGND VGND VPWR VPWR instr_lui sky130_fd_sc_hd__dfxtp_1
XFILLER_9_797 VPWR VGND VPWR VGND sky130_ef_sc_hd__decap_12
XFILLER_8_274 VGND VGND VPWR VPWR sky130_fd_sc_hd__decap_3
XTAP_TAPCELL_ROW_113_2138 VGND VPWR sky130_fd_sc_hd__tapvpwrvgnd_1
XFILLER_99_502 VGND VGND VPWR VPWR sky130_fd_sc_hd__fill_2
XTAP_TAPCELL_ROW_97_1882 VGND VPWR sky130_fd_sc_hd__tapvpwrvgnd_1
XTAP_TAPCELL_ROW_10_493 VGND VPWR sky130_fd_sc_hd__tapvpwrvgnd_1
XFILLER_153_481 VGND VGND VPWR VPWR sky130_fd_sc_hd__fill_1
XFILLER_114_824 VGND VGND VPWR VPWR sky130_fd_sc_hd__decap_6
X_07990_ _03697_ _03796_ _01551_ VGND VGND VPWR VPWR _03813_ sky130_fd_sc_hd__o21a_1
X_06941_ cpuregs\[28\]\[23\] cpuregs\[29\]\[23\] cpuregs\[30\]\[23\] cpuregs\[31\]\[23\]
+ net267 net260 VGND VGND VPWR VPWR _03356_ sky130_fd_sc_hd__mux4_1
X_09660_ _03550_ _04870_ VGND VGND VPWR VPWR _04871_ sky130_fd_sc_hd__nor2_8
X_06872_ _00014_ _03284_ _00016_ VGND VGND VPWR VPWR _03290_ sky130_fd_sc_hd__o21a_1
XTAP_TAPCELL_ROW_128_2381 VGND VPWR sky130_fd_sc_hd__tapvpwrvgnd_1
XFILLER_95_785 VPWR VGND VPWR VGND sky130_ef_sc_hd__decap_12
XFILLER_83_903 VGND VGND VPWR VPWR sky130_fd_sc_hd__fill_1
XFILLER_67_476 VGND VGND VPWR VPWR sky130_fd_sc_hd__decap_4
X_08611_ cpuregs\[12\]\[7\] cpuregs\[13\]\[7\] cpuregs\[14\]\[7\] cpuregs\[15\]\[7\]
+ net278 net273 VGND VGND VPWR VPWR _04306_ sky130_fd_sc_hd__mux4_1
XFILLER_28_808 VGND VGND VPWR VPWR sky130_fd_sc_hd__decap_4
XFILLER_39_156 VGND VGND VPWR VPWR sky130_fd_sc_hd__fill_1
X_05823_ _02090_ _02239_ _02237_ VGND VGND VPWR VPWR _02386_ sky130_fd_sc_hd__o21ba_1
X_09591_ cpuregs\[29\]\[30\] _02709_ net239 VGND VGND VPWR VPWR _01252_ sky130_fd_sc_hd__mux2_1
XFILLER_67_487 VPWR VGND VPWR VGND sky130_ef_sc_hd__decap_12
X_05754_ _02150_ _02323_ VGND VGND VPWR VPWR _02324_ sky130_fd_sc_hd__nor2_1
X_08542_ _04241_ _04242_ _01558_ VGND VGND VPWR VPWR _04243_ sky130_fd_sc_hd__mux2_1
XPHY_EDGE_ROW_145_Left_299 VGND VGND VPWR VPWR sky130_fd_sc_hd__decap_3
XTAP_TAPCELL_ROW_141_2592 VGND VPWR sky130_fd_sc_hd__tapvpwrvgnd_1
XTAP_TAPCELL_ROW_141_2581 VGND VPWR sky130_fd_sc_hd__tapvpwrvgnd_1
XFILLER_63_671 VGND VGND VPWR VPWR sky130_fd_sc_hd__fill_1
X_08473_ _04208_ VGND VGND VPWR VPWR _04209_ sky130_fd_sc_hd__inv_2
XFILLER_51_866 VGND VGND VPWR VPWR sky130_fd_sc_hd__decap_8
X_05685_ _02263_ _02184_ instr_sub VGND VGND VPWR VPWR _02264_ sky130_fd_sc_hd__mux2_1
X_07424_ cpuregs\[27\]\[8\] _02616_ _03566_ VGND VGND VPWR VPWR _00364_ sky130_fd_sc_hd__mux2_1
XFILLER_50_365 VGND VGND VPWR VPWR sky130_fd_sc_hd__decap_3
X_07355_ _02607_ cpuregs\[9\]\[6\] _03563_ VGND VGND VPWR VPWR _00298_ sky130_fd_sc_hd__mux2_1
XFILLER_148_253 VGND VGND VPWR VPWR sky130_fd_sc_hd__decap_3
X_07286_ cpuregs\[28\]\[4\] _02598_ net249 VGND VGND VPWR VPWR _00232_ sky130_fd_sc_hd__mux2_1
XFILLER_40_27 VGND VGND VPWR VPWR sky130_fd_sc_hd__fill_1
X_06306_ _01554_ _01639_ VGND VGND VPWR VPWR _02744_ sky130_fd_sc_hd__nor2_8
X_06237_ _02679_ _02682_ _02584_ VGND VGND VPWR VPWR _02683_ sky130_fd_sc_hd__mux2_8
X_09025_ net224 _01585_ _04696_ _04697_ VGND VGND VPWR VPWR _00835_ sky130_fd_sc_hd__o22a_1
XFILLER_151_429 VGND VGND VPWR VPWR sky130_fd_sc_hd__decap_8
X_06168_ reg_pc\[11\] reg_pc\[10\] _02619_ VGND VGND VPWR VPWR _02627_ sky130_fd_sc_hd__and3_1
XTAP_TAPCELL_ROW_148_2702 VGND VPWR sky130_fd_sc_hd__tapvpwrvgnd_1
XFILLER_132_643 VGND VGND VPWR VPWR sky130_fd_sc_hd__fill_1
X_05119_ net5 net22 net606 VGND VGND VPWR VPWR _01729_ sky130_fd_sc_hd__mux2_1
X_06099_ _02568_ _02569_ _01558_ VGND VGND VPWR VPWR _02570_ sky130_fd_sc_hd__mux2_1
X_09927_ clknet_leaf_48_clk _00062_ VGND VGND VPWR VPWR cpuregs\[11\]\[25\] sky130_fd_sc_hd__dfxtp_1
XFILLER_120_849 VPWR VGND VPWR VGND sky130_ef_sc_hd__decap_12
XTAP_TAPCELL_ROW_29_803 VGND VPWR sky130_fd_sc_hd__tapvpwrvgnd_1
X_09858_ net33 net235 VGND VGND VPWR VPWR _04877_ sky130_fd_sc_hd__nand2_1
X_08809_ cpuregs\[16\]\[18\] cpuregs\[17\]\[18\] cpuregs\[18\]\[18\] cpuregs\[19\]\[18\]
+ net277 net272 VGND VGND VPWR VPWR _04493_ sky130_fd_sc_hd__mux4_1
X_09789_ _02704_ cpuregs\[7\]\[29\] _04874_ VGND VGND VPWR VPWR _01443_ sky130_fd_sc_hd__mux2_1
XFILLER_65_57 VGND VGND VPWR VPWR sky130_fd_sc_hd__decap_8
XFILLER_27_841 VPWR VGND VPWR VGND sky130_ef_sc_hd__decap_12
XFILLER_45_137 VPWR VGND VPWR VGND sky130_ef_sc_hd__decap_12
X_10702_ clknet_leaf_68_clk _00800_ VGND VGND VPWR VPWR net56 sky130_fd_sc_hd__dfxtp_1
Xclkbuf_leaf_80_clk clknet_4_15_0_clk VGND VGND VPWR VPWR clknet_leaf_80_clk sky130_fd_sc_hd__clkbuf_8
XTAP_TAPCELL_ROW_64_1358 VGND VPWR sky130_fd_sc_hd__tapvpwrvgnd_1
XFILLER_42_833 VPWR VGND VPWR VGND sky130_ef_sc_hd__decap_12
XFILLER_42_866 VGND VGND VPWR VPWR sky130_fd_sc_hd__fill_2
XFILLER_41_376 VPWR VGND VPWR VGND sky130_ef_sc_hd__decap_12
XFILLER_128_905 VGND VGND VPWR VPWR sky130_fd_sc_hd__decap_6
X_10633_ clknet_leaf_82_clk _00763_ VGND VGND VPWR VPWR count_cycle\[56\] sky130_fd_sc_hd__dfxtp_1
X_10564_ clknet_leaf_90_clk _00694_ VGND VGND VPWR VPWR reg_next_pc\[19\] sky130_fd_sc_hd__dfxtp_1
XFILLER_10_752 VGND VGND VPWR VPWR sky130_fd_sc_hd__decap_4
XFILLER_6_701 VGND VGND VPWR VPWR sky130_fd_sc_hd__decap_8
XFILLER_14_83 VGND VGND VPWR VPWR sky130_fd_sc_hd__fill_1
X_10495_ clknet_leaf_105_clk _00625_ VGND VGND VPWR VPWR count_instr\[44\] sky130_fd_sc_hd__dfxtp_1
XFILLER_142_429 VGND VGND VPWR VPWR sky130_fd_sc_hd__decap_3
XFILLER_108_684 VGND VGND VPWR VPWR sky130_fd_sc_hd__decap_3
XTAP_TAPCELL_ROW_79_1590 VGND VPWR sky130_fd_sc_hd__tapvpwrvgnd_1
XFILLER_5_277 VGND VGND VPWR VPWR sky130_fd_sc_hd__decap_3
XFILLER_150_440 VPWR VGND VPWR VGND sky130_ef_sc_hd__decap_12
XFILLER_123_665 VGND VGND VPWR VPWR sky130_fd_sc_hd__decap_6
XFILLER_150_462 VPWR VGND VPWR VGND sky130_ef_sc_hd__decap_12
XFILLER_123_687 VGND VGND VPWR VPWR sky130_fd_sc_hd__decap_4
X_11116_ clknet_leaf_142_clk _01163_ VGND VGND VPWR VPWR cpuregs\[31\]\[5\] sky130_fd_sc_hd__dfxtp_1
XFILLER_77_741 VGND VGND VPWR VPWR sky130_fd_sc_hd__decap_8
XFILLER_49_465 VGND VGND VPWR VPWR sky130_fd_sc_hd__fill_1
X_11047_ clknet_leaf_110_clk _01104_ VGND VGND VPWR VPWR mem_rdata_q\[10\] sky130_fd_sc_hd__dfxtp_1
XFILLER_76_295 VPWR VGND VPWR VGND sky130_ef_sc_hd__decap_12
Xinput9 mem_rdata[17] VGND VGND VPWR VPWR net9 sky130_fd_sc_hd__buf_2
XFILLER_92_755 VGND VGND VPWR VPWR sky130_fd_sc_hd__fill_1
XFILLER_64_468 VGND VGND VPWR VPWR sky130_fd_sc_hd__decap_8
Xclkbuf_leaf_71_clk clknet_4_13_0_clk VGND VGND VPWR VPWR clknet_leaf_71_clk sky130_fd_sc_hd__clkbuf_8
XFILLER_60_630 VGND VGND VPWR VPWR sky130_fd_sc_hd__decap_3
XFILLER_32_321 VGND VGND VPWR VPWR sky130_fd_sc_hd__fill_2
X_05470_ net189 net221 VGND VGND VPWR VPWR _02053_ sky130_fd_sc_hd__and2_1
XFILLER_33_877 VPWR VGND VPWR VGND sky130_ef_sc_hd__decap_12
XFILLER_119_905 VGND VGND VPWR VPWR sky130_fd_sc_hd__decap_3
XTAP_TAPCELL_ROW_99_1911 VGND VPWR sky130_fd_sc_hd__tapvpwrvgnd_1
XTAP_TAPCELL_ROW_15_574 VGND VPWR sky130_fd_sc_hd__tapvpwrvgnd_1
XFILLER_146_713 VGND VGND VPWR VPWR sky130_fd_sc_hd__decap_6
XTAP_TAPCELL_ROW_99_1922 VGND VPWR sky130_fd_sc_hd__tapvpwrvgnd_1
X_07140_ _02714_ _03530_ _03531_ _03532_ _03547_ VGND VGND VPWR VPWR _03548_ sky130_fd_sc_hd__o41a_1
XFILLER_145_223 VGND VGND VPWR VPWR sky130_fd_sc_hd__fill_1
XFILLER_118_437 VGND VGND VPWR VPWR sky130_fd_sc_hd__fill_1
X_07071_ _03477_ _03478_ _03480_ VGND VGND VPWR VPWR _03481_ sky130_fd_sc_hd__o21ba_1
XFILLER_145_278 VGND VGND VPWR VPWR sky130_fd_sc_hd__fill_2
X_06022_ decoded_imm_j\[11\] _01114_ _02513_ VGND VGND VPWR VPWR _00027_ sky130_fd_sc_hd__mux2_1
XFILLER_99_332 VGND VGND VPWR VPWR sky130_fd_sc_hd__decap_4
XFILLER_141_462 VGND VGND VPWR VPWR sky130_fd_sc_hd__fill_1
XFILLER_114_665 VGND VGND VPWR VPWR sky130_fd_sc_hd__fill_1
X_09712_ _02657_ cpuregs\[5\]\[18\] _04872_ VGND VGND VPWR VPWR _01368_ sky130_fd_sc_hd__mux2_1
XFILLER_101_337 VPWR VGND VPWR VGND sky130_ef_sc_hd__decap_12
X_07973_ _03696_ _03786_ _01551_ VGND VGND VPWR VPWR _03797_ sky130_fd_sc_hd__o21ai_1
XFILLER_142_29 VPWR VGND VPWR VGND sky130_ef_sc_hd__decap_12
X_06924_ _03336_ _03337_ _01579_ VGND VGND VPWR VPWR _03340_ sky130_fd_sc_hd__mux2_1
XFILLER_19_39 VPWR VGND VPWR VGND sky130_ef_sc_hd__decap_12
XTAP_TAPCELL_ROW_143_2621 VGND VPWR sky130_fd_sc_hd__tapvpwrvgnd_1
X_09643_ _02649_ cpuregs\[22\]\[16\] _04869_ VGND VGND VPWR VPWR _01302_ sky130_fd_sc_hd__mux2_1
X_06855_ _03269_ _03272_ VGND VGND VPWR VPWR _03273_ sky130_fd_sc_hd__or2_1
XFILLER_82_210 VPWR VGND VPWR VGND sky130_ef_sc_hd__decap_12
XFILLER_55_435 VGND VGND VPWR VPWR sky130_fd_sc_hd__fill_2
XPHY_EDGE_ROW_153_Left_307 VGND VGND VPWR VPWR sky130_fd_sc_hd__decap_3
X_05806_ _02106_ _02365_ VGND VGND VPWR VPWR _02370_ sky130_fd_sc_hd__and2b_1
X_09574_ cpuregs\[29\]\[13\] _02638_ net239 VGND VGND VPWR VPWR _01235_ sky130_fd_sc_hd__mux2_1
XFILLER_55_446 VGND VGND VPWR VPWR sky130_fd_sc_hd__fill_2
XFILLER_27_137 VGND VGND VPWR VPWR sky130_fd_sc_hd__decap_4
X_06786_ _00014_ _03205_ _01581_ VGND VGND VPWR VPWR _03207_ sky130_fd_sc_hd__o21a_1
XFILLER_70_416 VGND VGND VPWR VPWR sky130_fd_sc_hd__decap_4
X_08525_ _04221_ _04223_ _04226_ _00010_ _00011_ VGND VGND VPWR VPWR _04227_ sky130_fd_sc_hd__a221o_1
XFILLER_35_27 VPWR VGND VPWR VGND sky130_ef_sc_hd__decap_12
Xclkbuf_leaf_62_clk clknet_4_12_0_clk VGND VGND VPWR VPWR clknet_leaf_62_clk sky130_fd_sc_hd__clkbuf_8
X_05737_ _02120_ _02308_ VGND VGND VPWR VPWR _02309_ sky130_fd_sc_hd__nand2_1
X_08456_ _01578_ _04192_ _01579_ VGND VGND VPWR VPWR _04193_ sky130_fd_sc_hd__o21a_1
X_05668_ instr_sub _01569_ _02248_ VGND VGND VPWR VPWR _02250_ sky130_fd_sc_hd__o21ai_1
XFILLER_51_652 VGND VGND VPWR VPWR sky130_fd_sc_hd__fill_1
XTAP_TAPCELL_ROW_46_1066 VGND VPWR sky130_fd_sc_hd__tapvpwrvgnd_1
X_07407_ cpuregs\[14\]\[25\] _02688_ net247 VGND VGND VPWR VPWR _00349_ sky130_fd_sc_hd__mux2_1
X_08387_ count_cycle\[47\] _04139_ _01549_ VGND VGND VPWR VPWR _04141_ sky130_fd_sc_hd__a21oi_1
XFILLER_23_387 VGND VGND VPWR VPWR sky130_fd_sc_hd__decap_4
XTAP_TAPCELL_ROW_34_872 VGND VPWR sky130_fd_sc_hd__tapvpwrvgnd_1
XTAP_TAPCELL_ROW_34_883 VGND VPWR sky130_fd_sc_hd__tapvpwrvgnd_1
XFILLER_149_573 VGND VGND VPWR VPWR sky130_fd_sc_hd__decap_6
X_07338_ cpuregs\[21\]\[22\] _02675_ net248 VGND VGND VPWR VPWR _00282_ sky130_fd_sc_hd__mux2_1
XFILLER_137_713 VGND VGND VPWR VPWR sky130_fd_sc_hd__decap_6
X_05599_ _02167_ _02181_ VGND VGND VPWR VPWR _02182_ sky130_fd_sc_hd__and2b_1
X_07269_ cpuregs\[2\]\[20\] _02665_ _03559_ VGND VGND VPWR VPWR _00216_ sky130_fd_sc_hd__mux2_1
X_10280_ clknet_leaf_46_clk _00410_ VGND VGND VPWR VPWR cpuregs\[15\]\[22\] sky130_fd_sc_hd__dfxtp_1
X_09008_ cpuregs\[16\]\[29\] cpuregs\[17\]\[29\] cpuregs\[18\]\[29\] cpuregs\[19\]\[29\]
+ net277 net271 VGND VGND VPWR VPWR _04681_ sky130_fd_sc_hd__mux4_1
XFILLER_151_237 VPWR VGND VPWR VGND sky130_ef_sc_hd__decap_12
XFILLER_120_613 VGND VGND VPWR VPWR sky130_fd_sc_hd__fill_1
XFILLER_116_41 VGND VGND VPWR VPWR sky130_fd_sc_hd__decap_6
XFILLER_104_197 VGND VGND VPWR VPWR sky130_fd_sc_hd__fill_2
XFILLER_104_186 VGND VGND VPWR VPWR sky130_fd_sc_hd__decap_8
XFILLER_86_560 VPWR VGND VPWR VGND sky130_ef_sc_hd__decap_12
XFILLER_76_56 VGND VGND VPWR VPWR sky130_fd_sc_hd__decap_6
XFILLER_58_262 VGND VGND VPWR VPWR sky130_fd_sc_hd__decap_8
XFILLER_46_424 VGND VGND VPWR VPWR sky130_fd_sc_hd__decap_4
XFILLER_74_777 VGND VGND VPWR VPWR sky130_fd_sc_hd__fill_2
Xclkbuf_leaf_53_clk clknet_4_6_0_clk VGND VGND VPWR VPWR clknet_leaf_53_clk sky130_fd_sc_hd__clkbuf_8
XFILLER_73_298 VGND VGND VPWR VPWR sky130_fd_sc_hd__decap_8
XFILLER_61_449 VPWR VGND VPWR VGND sky130_ef_sc_hd__decap_12
XFILLER_14_321 VGND VGND VPWR VPWR sky130_fd_sc_hd__decap_6
XFILLER_15_833 VGND VGND VPWR VPWR sky130_fd_sc_hd__decap_6
XFILLER_15_877 VPWR VGND VPWR VGND sky130_ef_sc_hd__decap_12
XFILLER_42_674 VGND VGND VPWR VPWR sky130_fd_sc_hd__fill_1
XFILLER_30_825 VPWR VGND VPWR VGND sky130_ef_sc_hd__decap_12
XFILLER_41_162 VGND VGND VPWR VPWR sky130_fd_sc_hd__decap_6
XFILLER_42_696 VGND VGND VPWR VPWR sky130_fd_sc_hd__decap_4
Xclkbuf_4_6_0_clk clknet_0_clk VGND VGND VPWR VPWR clknet_4_6_0_clk sky130_fd_sc_hd__clkbuf_8
X_10616_ clknet_leaf_106_clk _00746_ VGND VGND VPWR VPWR count_cycle\[39\] sky130_fd_sc_hd__dfxtp_1
XTAP_TAPCELL_ROW_12_522 VGND VPWR sky130_fd_sc_hd__tapvpwrvgnd_1
XFILLER_30_869 VPWR VGND VPWR VGND sky130_ef_sc_hd__decap_12
XFILLER_127_223 VGND VGND VPWR VPWR sky130_fd_sc_hd__fill_1
X_10547_ clknet_leaf_129_clk _00677_ VGND VGND VPWR VPWR reg_next_pc\[2\] sky130_fd_sc_hd__dfxtp_1
XFILLER_6_531 VGND VGND VPWR VPWR sky130_fd_sc_hd__fill_1
XFILLER_108_470 VGND VGND VPWR VPWR sky130_fd_sc_hd__decap_6
X_10478_ clknet_leaf_81_clk _00608_ VGND VGND VPWR VPWR count_instr\[27\] sky130_fd_sc_hd__dfxtp_1
XTAP_TAPCELL_ROW_94_1841 VGND VPWR sky130_fd_sc_hd__tapvpwrvgnd_1
XTAP_TAPCELL_ROW_94_1830 VGND VPWR sky130_fd_sc_hd__tapvpwrvgnd_1
Xrebuffer190 net577 VGND VGND VPWR VPWR net576 sky130_fd_sc_hd__dlygate4sd1_1
XFILLER_51_7 VPWR VGND VPWR VGND sky130_ef_sc_hd__decap_12
XFILLER_108_492 VGND VGND VPWR VPWR sky130_fd_sc_hd__fill_2
XFILLER_97_836 VGND VGND VPWR VPWR sky130_fd_sc_hd__decap_4
XFILLER_2_781 VPWR VGND VPWR VGND sky130_ef_sc_hd__decap_12
X_04970_ instr_or instr_sra instr_srl instr_xor VGND VGND VPWR VPWR _01600_ sky130_fd_sc_hd__or4_1
XFILLER_49_251 VGND VGND VPWR VPWR sky130_fd_sc_hd__decap_6
XPHY_EDGE_ROW_10_Right_10 VGND VGND VPWR VPWR sky130_fd_sc_hd__decap_3
XFILLER_2_53 VPWR VGND VPWR VGND sky130_ef_sc_hd__decap_12
XFILLER_65_711 VPWR VGND VPWR VGND sky130_ef_sc_hd__decap_12
XPHY_EDGE_ROW_139_Right_139 VGND VGND VPWR VPWR sky130_fd_sc_hd__decap_3
XTAP_TAPCELL_ROW_108_2059 VGND VPWR sky130_fd_sc_hd__tapvpwrvgnd_1
XFILLER_92_541 VGND VGND VPWR VPWR sky130_fd_sc_hd__fill_2
XFILLER_64_232 VGND VGND VPWR VPWR sky130_fd_sc_hd__decap_3
X_06640_ cpuregs\[4\]\[12\] cpuregs\[5\]\[12\] cpuregs\[6\]\[12\] cpuregs\[7\]\[12\]
+ net263 net259 VGND VGND VPWR VPWR _03066_ sky130_fd_sc_hd__mux4_1
XFILLER_2_97 VPWR VGND VPWR VGND sky130_ef_sc_hd__decap_12
XFILLER_80_714 VGND VGND VPWR VPWR sky130_fd_sc_hd__decap_6
Xclkbuf_leaf_44_clk clknet_4_7_0_clk VGND VGND VPWR VPWR clknet_leaf_44_clk sky130_fd_sc_hd__clkbuf_8
XFILLER_92_596 VGND VGND VPWR VPWR sky130_fd_sc_hd__decap_4
XFILLER_17_181 VPWR VGND VPWR VGND sky130_ef_sc_hd__decap_12
X_06571_ _02990_ _02998_ _02999_ _01581_ _01580_ VGND VGND VPWR VPWR _03000_ sky130_fd_sc_hd__a221o_1
X_09290_ net147 net109 _04206_ VGND VGND VPWR VPWR _00976_ sky130_fd_sc_hd__mux2_1
X_05522_ net180 net212 VGND VGND VPWR VPWR _02105_ sky130_fd_sc_hd__nor2_1
X_08310_ _04083_ count_cycle\[19\] count_cycle\[18\] _04087_ VGND VGND VPWR VPWR _04092_
+ sky130_fd_sc_hd__and4_1
XTAP_TAPCELL_ROW_103_1981 VGND VPWR sky130_fd_sc_hd__tapvpwrvgnd_1
X_05453_ cpu_state\[6\] _01860_ _02032_ _02033_ _02037_ VGND VGND VPWR VPWR _04901_
+ sky130_fd_sc_hd__a311o_1
X_08241_ decoded_imm_j\[20\] _03718_ VGND VGND VPWR VPWR _04044_ sky130_fd_sc_hd__nand2_1
XANTENNA_14 clk VGND VGND VPWR VPWR sky130_fd_sc_hd__diode_2
XTAP_TAPCELL_ROW_31_820 VGND VPWR sky130_fd_sc_hd__tapvpwrvgnd_1
XANTENNA_25 net213 VGND VGND VPWR VPWR sky130_fd_sc_hd__diode_2
XANTENNA_36 _04869_ VGND VGND VPWR VPWR sky130_fd_sc_hd__diode_2
XFILLER_119_702 VGND VGND VPWR VPWR sky130_fd_sc_hd__decap_4
XTAP_TAPCELL_ROW_31_831 VGND VPWR sky130_fd_sc_hd__tapvpwrvgnd_1
X_08172_ _03576_ _03980_ VGND VGND VPWR VPWR _03981_ sky130_fd_sc_hd__nor2_1
X_05384_ net18 _01665_ _01856_ VGND VGND VPWR VPWR _01974_ sky130_fd_sc_hd__a21o_1
X_07123_ net189 _02721_ _02744_ _03482_ VGND VGND VPWR VPWR _03531_ sky130_fd_sc_hd__o211a_1
XFILLER_134_738 VGND VGND VPWR VPWR sky130_fd_sc_hd__fill_1
X_07054_ cpuregs\[12\]\[27\] cpuregs\[13\]\[27\] cpuregs\[14\]\[27\] cpuregs\[15\]\[27\]
+ net266 net261 VGND VGND VPWR VPWR _03465_ sky130_fd_sc_hd__mux4_1
Xoutput110 net110 VGND VGND VPWR VPWR mem_la_wdata[21] sky130_fd_sc_hd__buf_2
XFILLER_106_407 VPWR VGND VPWR VGND sky130_ef_sc_hd__decap_12
X_06005_ reg_out\[25\] reg_next_pc\[25\] net596 VGND VGND VPWR VPWR _02506_ sky130_fd_sc_hd__mux2_1
Xoutput143 net143 VGND VGND VPWR VPWR mem_wdata[17] sky130_fd_sc_hd__buf_2
Xoutput121 net121 VGND VGND VPWR VPWR mem_la_wdata[31] sky130_fd_sc_hd__buf_2
Xoutput132 net132 VGND VGND VPWR VPWR mem_la_wstrb[2] sky130_fd_sc_hd__buf_2
Xoutput176 net176 VGND VGND VPWR VPWR pcpi_rs1[14] sky130_fd_sc_hd__buf_2
Xoutput154 net154 VGND VGND VPWR VPWR mem_wdata[27] sky130_fd_sc_hd__buf_2
Xoutput165 net165 VGND VGND VPWR VPWR mem_wdata[8] sky130_fd_sc_hd__buf_2
XFILLER_0_729 VGND VGND VPWR VPWR sky130_fd_sc_hd__fill_2
Xoutput187 net187 VGND VGND VPWR VPWR pcpi_rs1[24] sky130_fd_sc_hd__buf_2
XFILLER_141_281 VPWR VGND VPWR VGND sky130_ef_sc_hd__decap_12
XFILLER_88_869 VPWR VGND VPWR VGND sky130_ef_sc_hd__decap_12
Xoutput198 net198 VGND VGND VPWR VPWR pcpi_rs1[5] sky130_fd_sc_hd__buf_2
X_07956_ _01551_ _03778_ _03779_ _03780_ _03781_ VGND VGND VPWR VPWR _03782_ sky130_fd_sc_hd__o32a_1
X_06907_ _03296_ _03299_ _03300_ _03321_ VGND VGND VPWR VPWR _03323_ sky130_fd_sc_hd__o31ai_2
XPHY_EDGE_ROW_106_Right_106 VGND VGND VPWR VPWR sky130_fd_sc_hd__decap_3
X_07887_ _02711_ reg_next_pc\[31\] net596 VGND VGND VPWR VPWR _03720_ sky130_fd_sc_hd__mux2_1
XTAP_TAPCELL_ROW_39_953 VGND VPWR sky130_fd_sc_hd__tapvpwrvgnd_1
X_06838_ _03250_ _03251_ _03252_ _03253_ _01579_ _01581_ VGND VGND VPWR VPWR _03257_
+ sky130_fd_sc_hd__mux4_1
XTAP_TAPCELL_ROW_48_1106 VGND VPWR sky130_fd_sc_hd__tapvpwrvgnd_1
X_09626_ _03553_ _03572_ VGND VGND VPWR VPWR _04869_ sky130_fd_sc_hd__nand2_8
X_09557_ cpuregs\[23\]\[29\] _02704_ _04866_ VGND VGND VPWR VPWR _01219_ sky130_fd_sc_hd__mux2_1
X_06769_ decoded_imm\[16\] net178 _03186_ VGND VGND VPWR VPWR _03190_ sky130_fd_sc_hd__and3_1
XFILLER_43_449 VGND VGND VPWR VPWR sky130_fd_sc_hd__fill_2
X_09488_ cpuregs\[24\]\[26\] _02691_ net241 VGND VGND VPWR VPWR _01152_ sky130_fd_sc_hd__mux2_1
Xclkbuf_leaf_35_clk clknet_4_5_0_clk VGND VGND VPWR VPWR clknet_leaf_35_clk sky130_fd_sc_hd__clkbuf_8
XFILLER_102_76 VGND VGND VPWR VPWR sky130_fd_sc_hd__decap_8
XFILLER_102_65 VGND VGND VPWR VPWR sky130_fd_sc_hd__fill_2
XTAP_TAPCELL_ROW_61_1306 VGND VPWR sky130_fd_sc_hd__tapvpwrvgnd_1
X_08508_ cpu_state\[2\] _04212_ _02716_ mem_do_prefetch VGND VGND VPWR VPWR _04213_
+ sky130_fd_sc_hd__a211o_1
X_08439_ cpuregs\[12\]\[31\] cpuregs\[13\]\[31\] cpuregs\[14\]\[31\] cpuregs\[15\]\[31\]
+ net264 net259 VGND VGND VPWR VPWR _04176_ sky130_fd_sc_hd__mux4_1
XFILLER_51_471 VPWR VGND VPWR VGND sky130_ef_sc_hd__decap_12
XFILLER_11_313 VGND VGND VPWR VPWR sky130_fd_sc_hd__fill_2
XFILLER_12_825 VPWR VGND VPWR VGND sky130_ef_sc_hd__decap_12
XFILLER_11_346 VPWR VGND VPWR VGND sky130_ef_sc_hd__decap_12
XFILLER_12_869 VPWR VGND VPWR VGND sky130_ef_sc_hd__decap_12
XFILLER_127_3 VPWR VGND VPWR VGND sky130_ef_sc_hd__decap_12
X_11450_ clknet_leaf_57_clk _01494_ VGND VGND VPWR VPWR cpuregs\[0\]\[16\] sky130_fd_sc_hd__dfxtp_1
Xwire237 _02724_ VGND VGND VPWR VPWR net237 sky130_fd_sc_hd__clkbuf_8
XFILLER_109_234 VGND VGND VPWR VPWR sky130_fd_sc_hd__decap_4
X_10401_ clknet_leaf_20_clk _00531_ VGND VGND VPWR VPWR cpuregs\[20\]\[15\] sky130_fd_sc_hd__dfxtp_1
X_11381_ clknet_leaf_149_clk _01425_ VGND VGND VPWR VPWR cpuregs\[7\]\[11\] sky130_fd_sc_hd__dfxtp_1
Xwire259 net262 VGND VGND VPWR VPWR net259 sky130_fd_sc_hd__buf_12
XFILLER_125_727 VGND VGND VPWR VPWR sky130_fd_sc_hd__fill_1
X_10332_ clknet_leaf_13_clk _00462_ VGND VGND VPWR VPWR cpuregs\[16\]\[10\] sky130_fd_sc_hd__dfxtp_1
XFILLER_11_51 VGND VGND VPWR VPWR sky130_fd_sc_hd__decap_4
XFILLER_127_51 VGND VGND VPWR VPWR sky130_fd_sc_hd__decap_4
XTAP_TAPCELL_ROW_59_1279 VGND VPWR sky130_fd_sc_hd__tapvpwrvgnd_1
XTAP_TAPCELL_ROW_59_1268 VGND VPWR sky130_fd_sc_hd__tapvpwrvgnd_1
X_10263_ clknet_leaf_139_clk _00393_ VGND VGND VPWR VPWR cpuregs\[15\]\[5\] sky130_fd_sc_hd__dfxtp_1
XFILLER_105_484 VGND VGND VPWR VPWR sky130_fd_sc_hd__decap_6
XFILLER_87_66 VGND VGND VPWR VPWR sky130_fd_sc_hd__decap_4
XFILLER_87_55 VGND VGND VPWR VPWR sky130_fd_sc_hd__fill_1
XFILLER_79_836 VGND VGND VPWR VPWR sky130_fd_sc_hd__decap_4
X_10194_ clknet_leaf_126_clk _00324_ VGND VGND VPWR VPWR cpuregs\[14\]\[0\] sky130_fd_sc_hd__dfxtp_1
XTAP_TAPCELL_ROW_72_1479 VGND VPWR sky130_fd_sc_hd__tapvpwrvgnd_1
XFILLER_66_519 VPWR VGND VPWR VGND sky130_ef_sc_hd__decap_12
XFILLER_74_552 VGND VGND VPWR VPWR sky130_fd_sc_hd__decap_4
XTAP_TAPCELL_ROW_17_603 VGND VPWR sky130_fd_sc_hd__tapvpwrvgnd_1
XFILLER_34_405 VGND VGND VPWR VPWR sky130_fd_sc_hd__fill_2
XFILLER_46_265 VGND VGND VPWR VPWR sky130_fd_sc_hd__decap_3
XFILLER_47_799 VGND VGND VPWR VPWR sky130_fd_sc_hd__fill_1
XFILLER_62_747 VGND VGND VPWR VPWR sky130_fd_sc_hd__decap_3
Xclkbuf_leaf_26_clk clknet_4_4_0_clk VGND VGND VPWR VPWR clknet_leaf_26_clk sky130_fd_sc_hd__clkbuf_8
XFILLER_62_769 VGND VGND VPWR VPWR sky130_fd_sc_hd__decap_6
XFILLER_61_279 VGND VGND VPWR VPWR sky130_fd_sc_hd__fill_1
XFILLER_14_195 VGND VGND VPWR VPWR sky130_fd_sc_hd__fill_1
Xinput12 mem_rdata[1] VGND VGND VPWR VPWR net12 sky130_fd_sc_hd__dlymetal6s2s_1
Xinput23 mem_rdata[2] VGND VGND VPWR VPWR net23 sky130_fd_sc_hd__buf_1
Xinput34 resetn VGND VGND VPWR VPWR net34 sky130_fd_sc_hd__clkbuf_16
XFILLER_128_576 VPWR VGND VPWR VGND sky130_ef_sc_hd__decap_12
XFILLER_7_895 VGND VGND VPWR VPWR sky130_fd_sc_hd__fill_1
XFILLER_115_237 VPWR VGND VPWR VGND sky130_ef_sc_hd__decap_12
XFILLER_109_790 VGND VGND VPWR VPWR sky130_fd_sc_hd__fill_1
XFILLER_112_900 VGND VGND VPWR VPWR sky130_fd_sc_hd__decap_8
XFILLER_42_3 VGND VGND VPWR VPWR sky130_fd_sc_hd__decap_3
XFILLER_123_281 VPWR VGND VPWR VGND sky130_ef_sc_hd__decap_12
XFILLER_97_622 VGND VGND VPWR VPWR sky130_fd_sc_hd__fill_1
X_07810_ _03678_ net34 _03677_ VGND VGND VPWR VPWR _00639_ sky130_fd_sc_hd__and3b_1
XFILLER_111_454 VPWR VGND VPWR VGND sky130_ef_sc_hd__decap_12
XFILLER_111_443 VGND VGND VPWR VPWR sky130_fd_sc_hd__decap_4
XFILLER_96_132 VGND VGND VPWR VPWR sky130_fd_sc_hd__decap_8
X_08790_ net210 _01585_ _04474_ _04475_ VGND VGND VPWR VPWR _00822_ sky130_fd_sc_hd__o22a_1
XFILLER_69_346 VGND VGND VPWR VPWR sky130_fd_sc_hd__fill_2
XFILLER_97_699 VPWR VGND VPWR VGND sky130_ef_sc_hd__decap_12
XFILLER_96_176 VGND VGND VPWR VPWR sky130_fd_sc_hd__decap_4
X_07741_ _03634_ _03635_ VGND VGND VPWR VPWR _00613_ sky130_fd_sc_hd__nor2_1
X_04953_ mem_do_wdata net34 _01583_ VGND VGND VPWR VPWR net129 sky130_fd_sc_hd__and3_1
XFILLER_93_872 VGND VGND VPWR VPWR sky130_fd_sc_hd__decap_6
X_07672_ _03590_ _03591_ VGND VGND VPWR VPWR _00588_ sky130_fd_sc_hd__nor2_1
XFILLER_25_405 VGND VGND VPWR VPWR sky130_fd_sc_hd__decap_6
XTAP_TAPCELL_ROW_36_901 VGND VPWR sky130_fd_sc_hd__tapvpwrvgnd_1
XTAP_TAPCELL_ROW_36_912 VGND VPWR sky130_fd_sc_hd__tapvpwrvgnd_1
X_09411_ _02646_ cpuregs\[18\]\[15\] _04862_ VGND VGND VPWR VPWR _01045_ sky130_fd_sc_hd__mux2_1
X_06623_ _03041_ _03042_ _03045_ _03046_ _01579_ _01581_ VGND VGND VPWR VPWR _03050_
+ sky130_fd_sc_hd__mux4_1
XFILLER_16_29 VPWR VGND VPWR VGND sky130_ef_sc_hd__decap_12
X_09342_ mem_rdata_q\[24\] _01589_ VGND VGND VPWR VPWR _04833_ sky130_fd_sc_hd__and2_1
Xclkbuf_leaf_17_clk clknet_4_3_0_clk VGND VGND VPWR VPWR clknet_leaf_17_clk sky130_fd_sc_hd__clkbuf_8
X_06554_ net201 _02721_ VGND VGND VPWR VPWR _02983_ sky130_fd_sc_hd__or2_1
XFILLER_53_769 VPWR VGND VPWR VGND sky130_ef_sc_hd__decap_12
X_05505_ _02086_ _02087_ VGND VGND VPWR VPWR _02088_ sky130_fd_sc_hd__nor2_1
XTAP_TAPCELL_ROW_43_1014 VGND VPWR sky130_fd_sc_hd__tapvpwrvgnd_1
XTAP_TAPCELL_ROW_43_1025 VGND VPWR sky130_fd_sc_hd__tapvpwrvgnd_1
XTAP_TAPCELL_ROW_138_2542 VGND VPWR sky130_fd_sc_hd__tapvpwrvgnd_1
XFILLER_138_307 VGND VGND VPWR VPWR sky130_fd_sc_hd__fill_1
X_06485_ _02908_ _02909_ _02913_ _02914_ _01579_ _01581_ VGND VGND VPWR VPWR _02917_
+ sky130_fd_sc_hd__mux4_1
X_09273_ net160 net122 _04206_ VGND VGND VPWR VPWR _00959_ sky130_fd_sc_hd__mux2_1
X_08224_ _04027_ _04028_ net34 VGND VGND VPWR VPWR _00703_ sky130_fd_sc_hd__o21a_1
X_05436_ count_instr\[61\] instr_rdinstrh instr_rdcycleh count_cycle\[61\] VGND VGND
+ VPWR VPWR _02022_ sky130_fd_sc_hd__a22o_1
XFILLER_21_666 VGND VGND VPWR VPWR sky130_fd_sc_hd__decap_6
XFILLER_147_841 VPWR VGND VPWR VGND sky130_ef_sc_hd__decap_12
XFILLER_146_340 VGND VGND VPWR VPWR sky130_fd_sc_hd__decap_3
X_08155_ _03710_ _03959_ _03964_ VGND VGND VPWR VPWR _03965_ sky130_fd_sc_hd__o21ba_1
X_05367_ reg_pc\[24\] decoded_imm\[24\] VGND VGND VPWR VPWR _01958_ sky130_fd_sc_hd__or2_1
XTAP_TAPCELL_ROW_151_2753 VGND VPWR sky130_fd_sc_hd__tapvpwrvgnd_1
XTAP_TAPCELL_ROW_151_2742 VGND VPWR sky130_fd_sc_hd__tapvpwrvgnd_1
X_07106_ cpuregs\[0\]\[29\] cpuregs\[1\]\[29\] cpuregs\[2\]\[29\] cpuregs\[3\]\[29\]
+ net266 net261 VGND VGND VPWR VPWR _03515_ sky130_fd_sc_hd__mux4_1
XFILLER_107_716 VPWR VGND VPWR VGND sky130_ef_sc_hd__decap_12
XFILLER_4_309 VPWR VGND VPWR VGND sky130_ef_sc_hd__decap_12
X_08086_ _03704_ _03885_ VGND VGND VPWR VPWR _03902_ sky130_fd_sc_hd__and2_1
X_05298_ net256 _01893_ _01894_ net180 cpu_state\[4\] VGND VGND VPWR VPWR _01895_
+ sky130_fd_sc_hd__a32o_1
XFILLER_115_760 VGND VGND VPWR VPWR sky130_fd_sc_hd__decap_4
X_07037_ decoded_imm\[27\] net190 VGND VGND VPWR VPWR _03448_ sky130_fd_sc_hd__or2_1
XFILLER_102_421 VGND VGND VPWR VPWR sky130_fd_sc_hd__decap_4
XFILLER_88_611 VGND VGND VPWR VPWR sky130_fd_sc_hd__fill_2
XFILLER_0_559 VGND VGND VPWR VPWR sky130_fd_sc_hd__fill_1
X_08988_ _04661_ _04662_ _04266_ _04659_ VGND VGND VPWR VPWR _04663_ sky130_fd_sc_hd__o211a_1
XTAP_TAPCELL_ROW_54_1198 VGND VPWR sky130_fd_sc_hd__tapvpwrvgnd_1
XFILLER_29_700 VGND VGND VPWR VPWR sky130_fd_sc_hd__fill_1
XFILLER_75_349 VPWR VGND VPWR VGND sky130_ef_sc_hd__decap_12
X_07939_ _03762_ _03764_ _03765_ VGND VGND VPWR VPWR _03766_ sky130_fd_sc_hd__and3_1
X_10950_ clknet_leaf_89_clk _01012_ VGND VGND VPWR VPWR decoded_imm\[18\] sky130_fd_sc_hd__dfxtp_2
XTAP_TAPCELL_ROW_3_386 VGND VPWR sky130_fd_sc_hd__tapvpwrvgnd_1
XTAP_TAPCELL_ROW_3_375 VGND VPWR sky130_fd_sc_hd__tapvpwrvgnd_1
X_10881_ clknet_leaf_47_clk _00943_ VGND VGND VPWR VPWR cpuregs\[1\]\[25\] sky130_fd_sc_hd__dfxtp_1
XFILLER_83_393 VGND VGND VPWR VPWR sky130_fd_sc_hd__decap_4
X_09609_ _02646_ cpuregs\[3\]\[15\] _04868_ VGND VGND VPWR VPWR _01269_ sky130_fd_sc_hd__mux2_1
XFILLER_73_24 VPWR VGND VPWR VGND sky130_ef_sc_hd__decap_12
XFILLER_43_213 VGND VGND VPWR VPWR sky130_fd_sc_hd__fill_2
XFILLER_44_725 VGND VGND VPWR VPWR sky130_fd_sc_hd__decap_4
XFILLER_71_588 VGND VGND VPWR VPWR sky130_fd_sc_hd__decap_4
XFILLER_43_279 VGND VGND VPWR VPWR sky130_fd_sc_hd__fill_1
X_11433_ clknet_leaf_135_clk _01477_ VGND VGND VPWR VPWR cpuregs\[8\]\[31\] sky130_fd_sc_hd__dfxtp_1
XFILLER_7_125 VPWR VGND VPWR VGND sky130_ef_sc_hd__decap_12
XTAP_TAPCELL_ROW_22_683 VGND VPWR sky130_fd_sc_hd__tapvpwrvgnd_1
XFILLER_153_811 VGND VGND VPWR VPWR sky130_fd_sc_hd__fill_1
XFILLER_7_169 VPWR VGND VPWR VGND sky130_ef_sc_hd__decap_12
XFILLER_22_83 VGND VGND VPWR VPWR sky130_fd_sc_hd__fill_1
XFILLER_152_321 VPWR VGND VPWR VGND sky130_ef_sc_hd__decap_12
X_11364_ clknet_leaf_40_clk _01408_ VGND VGND VPWR VPWR cpuregs\[6\]\[26\] sky130_fd_sc_hd__dfxtp_1
XFILLER_138_83 VGND VGND VPWR VPWR sky130_fd_sc_hd__fill_1
XFILLER_125_524 VPWR VGND VPWR VGND sky130_ef_sc_hd__decap_12
XFILLER_99_909 VGND VGND VPWR VPWR sky130_fd_sc_hd__decap_3
XTAP_TAPCELL_ROW_74_1519 VGND VPWR sky130_fd_sc_hd__tapvpwrvgnd_1
XTAP_TAPCELL_ROW_74_1508 VGND VPWR sky130_fd_sc_hd__tapvpwrvgnd_1
XFILLER_153_888 VGND VGND VPWR VPWR sky130_fd_sc_hd__decap_4
XFILLER_152_365 VPWR VGND VPWR VGND sky130_ef_sc_hd__decap_12
X_11295_ clknet_leaf_69_clk _01342_ VGND VGND VPWR VPWR cpuregs\[4\]\[24\] sky130_fd_sc_hd__dfxtp_1
XFILLER_140_516 VPWR VGND VPWR VGND sky130_ef_sc_hd__decap_12
X_10315_ clknet_leaf_50_clk _00445_ VGND VGND VPWR VPWR cpuregs\[26\]\[25\] sky130_fd_sc_hd__dfxtp_1
XFILLER_125_568 VGND VGND VPWR VPWR sky130_fd_sc_hd__decap_6
XFILLER_98_419 VGND VGND VPWR VPWR sky130_fd_sc_hd__fill_1
X_10246_ clknet_leaf_74_clk _00376_ VGND VGND VPWR VPWR cpuregs\[27\]\[20\] sky130_fd_sc_hd__dfxtp_1
XFILLER_79_622 VPWR VGND VPWR VGND sky130_ef_sc_hd__decap_12
XFILLER_78_121 VPWR VGND VPWR VGND sky130_ef_sc_hd__decap_12
XFILLER_121_785 VPWR VGND VPWR VGND sky130_ef_sc_hd__decap_12
XFILLER_94_614 VPWR VGND VPWR VGND sky130_ef_sc_hd__decap_12
XFILLER_93_113 VGND VGND VPWR VPWR sky130_fd_sc_hd__decap_4
XFILLER_78_165 VPWR VGND VPWR VGND sky130_ef_sc_hd__decap_12
X_10177_ clknet_leaf_15_clk _00307_ VGND VGND VPWR VPWR cpuregs\[9\]\[15\] sky130_fd_sc_hd__dfxtp_1
XFILLER_94_658 VGND VGND VPWR VPWR sky130_fd_sc_hd__decap_8
XTAP_TAPCELL_ROW_89_1751 VGND VPWR sky130_fd_sc_hd__tapvpwrvgnd_1
XTAP_TAPCELL_ROW_105_2018 VGND VPWR sky130_fd_sc_hd__tapvpwrvgnd_1
XTAP_TAPCELL_ROW_105_2007 VGND VPWR sky130_fd_sc_hd__tapvpwrvgnd_1
XTAP_TAPCELL_ROW_89_1762 VGND VPWR sky130_fd_sc_hd__tapvpwrvgnd_1
XFILLER_81_308 VPWR VGND VPWR VGND sky130_ef_sc_hd__decap_12
XFILLER_62_533 VGND VGND VPWR VPWR sky130_fd_sc_hd__decap_8
XFILLER_62_566 VGND VGND VPWR VPWR sky130_fd_sc_hd__fill_1
XFILLER_23_909 VGND VGND VPWR VPWR sky130_fd_sc_hd__decap_3
XFILLER_148_616 VGND VGND VPWR VPWR sky130_fd_sc_hd__fill_1
XFILLER_148_638 VGND VGND VPWR VPWR sky130_fd_sc_hd__decap_6
X_06270_ _02709_ cpuregs\[11\]\[30\] _02582_ VGND VGND VPWR VPWR _00067_ sky130_fd_sc_hd__mux2_1
XFILLER_8_41 VPWR VGND VPWR VGND sky130_ef_sc_hd__decap_12
XFILLER_147_137 VPWR VGND VPWR VGND sky130_ef_sc_hd__decap_12
XFILLER_129_841 VPWR VGND VPWR VGND sky130_ef_sc_hd__decap_12
X_05221_ _01771_ _01823_ cpu_state\[6\] VGND VGND VPWR VPWR _01824_ sky130_fd_sc_hd__o21a_1
XFILLER_8_85 VPWR VGND VPWR VGND sky130_ef_sc_hd__decap_12
XTAP_TAPCELL_ROW_41_981 VGND VPWR sky130_fd_sc_hd__tapvpwrvgnd_1
XTAP_TAPCELL_ROW_41_992 VGND VPWR sky130_fd_sc_hd__tapvpwrvgnd_1
XFILLER_144_811 VGND VGND VPWR VPWR sky130_fd_sc_hd__fill_1
XFILLER_128_362 VGND VGND VPWR VPWR sky130_fd_sc_hd__fill_2
XFILLER_143_332 VGND VGND VPWR VPWR sky130_fd_sc_hd__decap_4
XFILLER_143_310 VGND VGND VPWR VPWR sky130_fd_sc_hd__decap_6
XTAP_TAPCELL_ROW_133_2461 VGND VPWR sky130_fd_sc_hd__tapvpwrvgnd_1
X_05152_ net16 _01669_ net130 net30 _01759_ VGND VGND VPWR VPWR _01760_ sky130_fd_sc_hd__a221o_1
XFILLER_116_568 VPWR VGND VPWR VGND sky130_ef_sc_hd__decap_12
X_09960_ clknet_leaf_62_clk _00090_ VGND VGND VPWR VPWR net184 sky130_fd_sc_hd__dfxtp_4
XFILLER_89_419 VPWR VGND VPWR VGND sky130_ef_sc_hd__decap_12
Xclkbuf_leaf_6_clk clknet_4_1_0_clk VGND VGND VPWR VPWR clknet_leaf_6_clk sky130_fd_sc_hd__clkbuf_8
X_05083_ _01693_ _01695_ _01687_ VGND VGND VPWR VPWR _01696_ sky130_fd_sc_hd__a21bo_1
XFILLER_131_549 VGND VGND VPWR VPWR sky130_fd_sc_hd__decap_8
X_08911_ net269 _04589_ _01559_ VGND VGND VPWR VPWR _04590_ sky130_fd_sc_hd__a21o_1
XFILLER_69_110 VGND VGND VPWR VPWR sky130_fd_sc_hd__fill_2
X_09891_ cpuregs\[0\]\[21\] VGND VGND VPWR VPWR _01499_ sky130_fd_sc_hd__clkbuf_1
X_08842_ cpuregs\[20\]\[20\] cpuregs\[21\]\[20\] cpuregs\[22\]\[20\] cpuregs\[23\]\[20\]
+ _00007_ net274 VGND VGND VPWR VPWR _04524_ sky130_fd_sc_hd__mux4_1
X_08773_ cpuregs\[16\]\[16\] cpuregs\[17\]\[16\] cpuregs\[18\]\[16\] cpuregs\[19\]\[16\]
+ net276 net272 VGND VGND VPWR VPWR _04459_ sky130_fd_sc_hd__mux4_1
X_05985_ reg_out\[15\] reg_next_pc\[15\] net597 VGND VGND VPWR VPWR _02496_ sky130_fd_sc_hd__mux2_1
XFILLER_150_29 VPWR VGND VPWR VGND sky130_ef_sc_hd__decap_12
X_07724_ count_instr\[26\] _03622_ net34 VGND VGND VPWR VPWR _03625_ sky130_fd_sc_hd__o21ai_1
X_04936_ net97 VGND VGND VPWR VPWR _01569_ sky130_fd_sc_hd__inv_2
XTAP_TAPCELL_ROW_0_312 VGND VPWR sky130_fd_sc_hd__tapvpwrvgnd_1
XFILLER_27_39 VPWR VGND VPWR VGND sky130_ef_sc_hd__decap_12
XTAP_TAPCELL_ROW_0_323 VGND VPWR sky130_fd_sc_hd__tapvpwrvgnd_1
XTAP_TAPCELL_ROW_0_334 VGND VPWR sky130_fd_sc_hd__tapvpwrvgnd_1
XFILLER_38_585 VGND VGND VPWR VPWR sky130_fd_sc_hd__decap_3
X_07655_ _03579_ _03580_ VGND VGND VPWR VPWR _00582_ sky130_fd_sc_hd__nor2_1
XFILLER_81_853 VGND VGND VPWR VPWR sky130_fd_sc_hd__fill_1
X_06606_ decoded_imm\[11\] net173 VGND VGND VPWR VPWR _03033_ sky130_fd_sc_hd__and2_1
XFILLER_81_897 VGND VGND VPWR VPWR sky130_fd_sc_hd__decap_8
X_07586_ cpuregs\[20\]\[3\] _02593_ net245 VGND VGND VPWR VPWR _00519_ sky130_fd_sc_hd__mux2_1
X_09325_ _04791_ _04822_ VGND VGND VPWR VPWR _04823_ sky130_fd_sc_hd__or2_2
X_06537_ cpuregs\[8\]\[8\] cpuregs\[9\]\[8\] cpuregs\[10\]\[8\] cpuregs\[11\]\[8\]
+ net263 net259 VGND VGND VPWR VPWR _02967_ sky130_fd_sc_hd__mux4_1
XFILLER_40_227 VPWR VGND VPWR VGND sky130_ef_sc_hd__decap_12
XFILLER_40_249 VGND VGND VPWR VPWR sky130_fd_sc_hd__decap_3
X_09256_ mem_do_wdata _01582_ VGND VGND VPWR VPWR _04800_ sky130_fd_sc_hd__and2b_1
X_06468_ _02898_ _02899_ VGND VGND VPWR VPWR _02900_ sky130_fd_sc_hd__nand2_1
X_08207_ _03985_ _03988_ _03999_ VGND VGND VPWR VPWR _04013_ sky130_fd_sc_hd__and3_1
X_05419_ reg_pc\[28\] decoded_imm\[28\] VGND VGND VPWR VPWR _02006_ sky130_fd_sc_hd__or2_1
XFILLER_147_671 VGND VGND VPWR VPWR sky130_fd_sc_hd__fill_1
X_09187_ decoded_imm_j\[9\] _01123_ _02513_ VGND VGND VPWR VPWR _00891_ sky130_fd_sc_hd__mux2_1
XFILLER_5_629 VPWR VGND VPWR VGND sky130_ef_sc_hd__decap_12
X_06399_ _02820_ _02821_ _02833_ _02832_ _00015_ _01581_ VGND VGND VPWR VPWR _02834_
+ sky130_fd_sc_hd__mux4_1
XFILLER_135_833 VGND VGND VPWR VPWR sky130_fd_sc_hd__decap_6
X_08138_ _03708_ _03933_ _03949_ VGND VGND VPWR VPWR _03950_ sky130_fd_sc_hd__o21a_1
XFILLER_4_139 VGND VGND VPWR VPWR sky130_fd_sc_hd__fill_1
XFILLER_135_877 VPWR VGND VPWR VGND sky130_ef_sc_hd__decap_12
XFILLER_107_557 VGND VGND VPWR VPWR sky130_fd_sc_hd__decap_3
X_08069_ _03703_ _03874_ VGND VGND VPWR VPWR _03886_ sky130_fd_sc_hd__nor2_1
XTAP_TAPCELL_ROW_56_1227 VGND VPWR sky130_fd_sc_hd__tapvpwrvgnd_1
XFILLER_150_825 VPWR VGND VPWR VGND sky130_ef_sc_hd__decap_12
X_10100_ clknet_leaf_120_clk _00230_ VGND VGND VPWR VPWR cpuregs\[28\]\[2\] sky130_fd_sc_hd__dfxtp_1
X_11080_ clknet_leaf_148_clk _01137_ VGND VGND VPWR VPWR cpuregs\[24\]\[11\] sky130_fd_sc_hd__dfxtp_1
XFILLER_150_869 VPWR VGND VPWR VGND sky130_ef_sc_hd__decap_12
X_10031_ clknet_leaf_33_clk _00161_ VGND VGND VPWR VPWR cpuregs\[30\]\[29\] sky130_fd_sc_hd__dfxtp_1
XFILLER_88_452 VPWR VGND VPWR VGND sky130_ef_sc_hd__decap_12
XTAP_TAPCELL_ROW_8_467 VGND VPWR sky130_fd_sc_hd__tapvpwrvgnd_1
XTAP_TAPCELL_ROW_8_456 VGND VPWR sky130_fd_sc_hd__tapvpwrvgnd_1
XFILLER_130_571 VGND VGND VPWR VPWR sky130_fd_sc_hd__fill_1
XFILLER_103_796 VPWR VGND VPWR VGND sky130_ef_sc_hd__decap_12
XFILLER_102_251 VGND VGND VPWR VPWR sky130_fd_sc_hd__fill_1
XFILLER_76_614 VPWR VGND VPWR VGND sky130_ef_sc_hd__decap_12
XFILLER_49_839 VGND VGND VPWR VPWR sky130_fd_sc_hd__fill_1
XFILLER_0_378 VGND VGND VPWR VPWR sky130_fd_sc_hd__decap_3
XFILLER_124_74 VGND VGND VPWR VPWR sky130_fd_sc_hd__decap_8
XFILLER_124_41 VPWR VGND VPWR VGND sky130_ef_sc_hd__decap_12
XFILLER_75_113 VGND VGND VPWR VPWR sky130_fd_sc_hd__decap_6
XFILLER_91_617 VGND VGND VPWR VPWR sky130_fd_sc_hd__fill_2
XFILLER_84_89 VGND VGND VPWR VPWR sky130_fd_sc_hd__fill_1
XFILLER_17_725 VGND VGND VPWR VPWR sky130_fd_sc_hd__decap_3
XFILLER_56_393 VGND VGND VPWR VPWR sky130_fd_sc_hd__decap_8
X_10933_ clknet_leaf_111_clk _00995_ VGND VGND VPWR VPWR latched_rd\[3\] sky130_fd_sc_hd__dfxtp_2
XTAP_TAPCELL_ROW_84_1681 VGND VPWR sky130_fd_sc_hd__tapvpwrvgnd_1
XTAP_TAPCELL_ROW_84_1670 VGND VPWR sky130_fd_sc_hd__tapvpwrvgnd_1
XFILLER_71_385 VGND VGND VPWR VPWR sky130_fd_sc_hd__decap_6
XFILLER_16_268 VGND VGND VPWR VPWR sky130_fd_sc_hd__fill_1
XTAP_TAPCELL_ROW_27_764 VGND VPWR sky130_fd_sc_hd__tapvpwrvgnd_1
X_10864_ clknet_leaf_146_clk _00926_ VGND VGND VPWR VPWR cpuregs\[1\]\[8\] sky130_fd_sc_hd__dfxtp_1
XFILLER_44_577 VGND VGND VPWR VPWR sky130_fd_sc_hd__decap_8
X_10795_ clknet_leaf_99_clk _00860_ VGND VGND VPWR VPWR instr_sh sky130_fd_sc_hd__dfxtp_1
XFILLER_31_249 VGND VGND VPWR VPWR sky130_fd_sc_hd__decap_3
XFILLER_8_445 VGND VGND VPWR VPWR sky130_fd_sc_hd__fill_1
XFILLER_149_93 VPWR VGND VPWR VGND sky130_ef_sc_hd__decap_12
XFILLER_144_107 VGND VGND VPWR VPWR sky130_fd_sc_hd__decap_6
XFILLER_126_811 VGND VGND VPWR VPWR sky130_fd_sc_hd__fill_1
X_11416_ clknet_leaf_26_clk _01460_ VGND VGND VPWR VPWR cpuregs\[8\]\[14\] sky130_fd_sc_hd__dfxtp_1
XFILLER_125_354 VGND VGND VPWR VPWR sky130_fd_sc_hd__fill_1
XFILLER_113_505 VGND VGND VPWR VPWR sky130_fd_sc_hd__decap_4
XFILLER_99_717 VGND VGND VPWR VPWR sky130_fd_sc_hd__decap_4
X_11347_ clknet_leaf_150_clk _01391_ VGND VGND VPWR VPWR cpuregs\[6\]\[9\] sky130_fd_sc_hd__dfxtp_1
XFILLER_153_685 VPWR VGND VPWR VGND sky130_ef_sc_hd__decap_12
XFILLER_125_376 VPWR VGND VPWR VGND sky130_ef_sc_hd__decap_12
XFILLER_3_161 VGND VGND VPWR VPWR sky130_fd_sc_hd__decap_6
XFILLER_152_195 VGND VGND VPWR VPWR sky130_fd_sc_hd__fill_1
X_11278_ clknet_leaf_144_clk _01325_ VGND VGND VPWR VPWR cpuregs\[4\]\[7\] sky130_fd_sc_hd__dfxtp_1
XFILLER_94_411 VGND VGND VPWR VPWR sky130_fd_sc_hd__decap_8
X_10229_ clknet_leaf_124_clk _00359_ VGND VGND VPWR VPWR cpuregs\[27\]\[3\] sky130_fd_sc_hd__dfxtp_1
XFILLER_39_316 VPWR VGND VPWR VGND sky130_ef_sc_hd__decap_12
XFILLER_121_582 VGND VGND VPWR VPWR sky130_fd_sc_hd__fill_2
XFILLER_94_433 VGND VGND VPWR VPWR sky130_fd_sc_hd__decap_3
XFILLER_67_636 VGND VGND VPWR VPWR sky130_fd_sc_hd__decap_8
XFILLER_55_809 VGND VGND VPWR VPWR sky130_fd_sc_hd__fill_2
XFILLER_94_477 VGND VGND VPWR VPWR sky130_fd_sc_hd__decap_3
X_05770_ _02146_ _02337_ VGND VGND VPWR VPWR _02339_ sky130_fd_sc_hd__nand2_1
XFILLER_47_371 VPWR VGND VPWR VGND sky130_ef_sc_hd__decap_12
XFILLER_35_533 VGND VGND VPWR VPWR sky130_fd_sc_hd__decap_4
X_07440_ cpuregs\[27\]\[24\] _02683_ _03566_ VGND VGND VPWR VPWR _00380_ sky130_fd_sc_hd__mux2_1
XPHY_EDGE_ROW_8_Right_8 VGND VGND VPWR VPWR sky130_fd_sc_hd__decap_3
XFILLER_22_205 VPWR VGND VPWR VGND sky130_ef_sc_hd__decap_12
X_07371_ _02675_ cpuregs\[9\]\[22\] _03563_ VGND VGND VPWR VPWR _00314_ sky130_fd_sc_hd__mux2_1
XFILLER_16_791 VPWR VGND VPWR VGND sky130_ef_sc_hd__decap_12
XFILLER_22_227 VPWR VGND VPWR VGND sky130_ef_sc_hd__decap_12
X_09110_ mem_rdata_q\[14\] net6 _01609_ VGND VGND VPWR VPWR _01108_ sky130_fd_sc_hd__mux2_1
X_06322_ cpuregs\[16\]\[1\] cpuregs\[17\]\[1\] cpuregs\[18\]\[1\] cpuregs\[19\]\[1\]
+ net268 net262 VGND VGND VPWR VPWR _02759_ sky130_fd_sc_hd__mux4_1
X_09041_ net226 _01585_ _04711_ _04712_ VGND VGND VPWR VPWR _00836_ sky130_fd_sc_hd__o22a_1
XFILLER_136_619 VPWR VGND VPWR VGND sky130_ef_sc_hd__decap_12
X_06253_ _02692_ _02695_ _02584_ VGND VGND VPWR VPWR _02696_ sky130_fd_sc_hd__mux2_8
XFILLER_116_321 VGND VGND VPWR VPWR sky130_fd_sc_hd__decap_8
X_06184_ reg_pc\[14\] _02636_ VGND VGND VPWR VPWR _02640_ sky130_fd_sc_hd__xor2_1
X_05204_ count_cycle\[11\] _01588_ VGND VGND VPWR VPWR _01808_ sky130_fd_sc_hd__or2_1
XFILLER_117_866 VPWR VGND VPWR VGND sky130_ef_sc_hd__decap_12
XFILLER_116_365 VPWR VGND VPWR VGND sky130_ef_sc_hd__decap_12
XFILLER_104_505 VGND VGND VPWR VPWR sky130_fd_sc_hd__fill_1
X_05135_ reg_pc\[5\] decoded_imm\[5\] _01717_ _01718_ _01716_ VGND VGND VPWR VPWR
+ _01744_ sky130_fd_sc_hd__a221o_1
XFILLER_132_825 VPWR VGND VPWR VGND sky130_ef_sc_hd__decap_12
XFILLER_132_869 VPWR VGND VPWR VGND sky130_ef_sc_hd__decap_12
XFILLER_131_335 VGND VGND VPWR VPWR sky130_fd_sc_hd__fill_1
X_05066_ _01677_ _01680_ VGND VGND VPWR VPWR _04878_ sky130_fd_sc_hd__nor2_1
XTAP_TAPCELL_ROW_5_404 VGND VPWR sky130_fd_sc_hd__tapvpwrvgnd_1
X_09943_ clknet_leaf_126_clk _00073_ VGND VGND VPWR VPWR net197 sky130_fd_sc_hd__dfxtp_4
XPHY_EDGE_ROW_39_Right_39 VGND VGND VPWR VPWR sky130_fd_sc_hd__decap_3
XFILLER_98_794 VGND VGND VPWR VPWR sky130_fd_sc_hd__decap_8
XFILLER_58_603 VGND VGND VPWR VPWR sky130_fd_sc_hd__decap_8
XTAP_TAPCELL_ROW_5_415 VGND VPWR sky130_fd_sc_hd__tapvpwrvgnd_1
X_09874_ cpuregs\[0\]\[4\] VGND VGND VPWR VPWR _01482_ sky130_fd_sc_hd__clkbuf_1
XFILLER_38_27 VGND VGND VPWR VPWR sky130_fd_sc_hd__fill_1
X_08825_ net212 _01585_ _04507_ _04508_ VGND VGND VPWR VPWR _00824_ sky130_fd_sc_hd__o22a_1
XFILLER_58_636 VGND VGND VPWR VPWR sky130_fd_sc_hd__decap_8
XTAP_TAPCELL_ROW_51_1146 VGND VPWR sky130_fd_sc_hd__tapvpwrvgnd_1
XFILLER_38_49 VGND VGND VPWR VPWR sky130_fd_sc_hd__fill_2
XTAP_TAPCELL_ROW_146_2674 VGND VPWR sky130_fd_sc_hd__tapvpwrvgnd_1
XTAP_TAPCELL_ROW_146_2663 VGND VPWR sky130_fd_sc_hd__tapvpwrvgnd_1
XFILLER_85_455 VGND VGND VPWR VPWR sky130_fd_sc_hd__fill_1
XFILLER_73_617 VGND VGND VPWR VPWR sky130_fd_sc_hd__fill_2
XFILLER_46_809 VGND VGND VPWR VPWR sky130_fd_sc_hd__decap_3
X_08756_ cpuregs\[16\]\[15\] cpuregs\[17\]\[15\] cpuregs\[18\]\[15\] cpuregs\[19\]\[15\]
+ net277 net272 VGND VGND VPWR VPWR _04443_ sky130_fd_sc_hd__mux4_1
XFILLER_72_116 VPWR VGND VPWR VGND sky130_ef_sc_hd__decap_12
X_05968_ net199 _02487_ _01582_ VGND VGND VPWR VPWR net92 sky130_fd_sc_hd__mux2_1
X_05899_ _02078_ _02448_ VGND VGND VPWR VPWR _02453_ sky130_fd_sc_hd__nor2_1
X_07707_ count_instr\[20\] _03610_ count_instr\[21\] VGND VGND VPWR VPWR _03613_ sky130_fd_sc_hd__a21o_1
X_04919_ cpu_state\[2\] VGND VGND VPWR VPWR _01552_ sky130_fd_sc_hd__inv_2
X_08687_ cpuregs\[20\]\[11\] cpuregs\[21\]\[11\] cpuregs\[22\]\[11\] cpuregs\[23\]\[11\]
+ net279 _00008_ VGND VGND VPWR VPWR _04378_ sky130_fd_sc_hd__mux4_1
XFILLER_26_533 VGND VGND VPWR VPWR sky130_fd_sc_hd__decap_4
X_07638_ _02675_ cpuregs\[17\]\[22\] _03574_ VGND VGND VPWR VPWR _00570_ sky130_fd_sc_hd__mux2_1
XFILLER_54_897 VGND VGND VPWR VPWR sky130_fd_sc_hd__fill_1
XFILLER_53_374 VGND VGND VPWR VPWR sky130_fd_sc_hd__decap_4
XTAP_TAPCELL_ROW_24_712 VGND VPWR sky130_fd_sc_hd__tapvpwrvgnd_1
X_07569_ cpuregs\[25\]\[20\] _02665_ _03571_ VGND VGND VPWR VPWR _00504_ sky130_fd_sc_hd__mux2_1
XPHY_EDGE_ROW_48_Right_48 VGND VGND VPWR VPWR sky130_fd_sc_hd__decap_3
XTAP_TAPCELL_ROW_24_723 VGND VPWR sky130_fd_sc_hd__tapvpwrvgnd_1
X_09308_ net170 _04206_ VGND VGND VPWR VPWR _04814_ sky130_fd_sc_hd__or2_1
XFILLER_139_446 VGND VGND VPWR VPWR sky130_fd_sc_hd__fill_2
X_10580_ clknet_leaf_109_clk _00710_ VGND VGND VPWR VPWR count_cycle\[3\] sky130_fd_sc_hd__dfxtp_2
X_09239_ cpuregs\[1\]\[18\] _02657_ net244 VGND VGND VPWR VPWR _00936_ sky130_fd_sc_hd__mux2_1
XFILLER_6_905 VGND VGND VPWR VPWR sky130_fd_sc_hd__decap_4
XFILLER_135_641 VGND VGND VPWR VPWR sky130_fd_sc_hd__fill_1
X_11201_ clknet_leaf_42_clk _01248_ VGND VGND VPWR VPWR cpuregs\[29\]\[26\] sky130_fd_sc_hd__dfxtp_1
XFILLER_79_23 VPWR VGND VPWR VGND sky130_ef_sc_hd__decap_12
XFILLER_134_162 VGND VGND VPWR VPWR sky130_fd_sc_hd__decap_3
X_11132_ clknet_leaf_80_clk _01179_ VGND VGND VPWR VPWR cpuregs\[31\]\[21\] sky130_fd_sc_hd__dfxtp_1
XFILLER_107_376 VGND VGND VPWR VPWR sky130_fd_sc_hd__decap_6
XPHY_EDGE_ROW_57_Right_57 VGND VGND VPWR VPWR sky130_fd_sc_hd__decap_3
XFILLER_134_195 VGND VGND VPWR VPWR sky130_fd_sc_hd__fill_1
XFILLER_135_51 VGND VGND VPWR VPWR sky130_fd_sc_hd__decap_4
X_11063_ clknet_leaf_100_clk _01120_ VGND VGND VPWR VPWR mem_rdata_q\[26\] sky130_fd_sc_hd__dfxtp_1
XFILLER_49_614 VGND VGND VPWR VPWR sky130_fd_sc_hd__fill_2
XFILLER_0_153 VPWR VGND VPWR VGND sky130_ef_sc_hd__decap_12
XFILLER_95_66 VGND VGND VPWR VPWR sky130_fd_sc_hd__decap_4
XFILLER_95_55 VGND VGND VPWR VPWR sky130_fd_sc_hd__fill_1
X_10014_ clknet_leaf_12_clk _00144_ VGND VGND VPWR VPWR cpuregs\[30\]\[12\] sky130_fd_sc_hd__dfxtp_1
XFILLER_0_197 VPWR VGND VPWR VGND sky130_ef_sc_hd__decap_12
XFILLER_64_606 VGND VGND VPWR VPWR sky130_fd_sc_hd__fill_1
XPHY_EDGE_ROW_48_Left_202 VGND VGND VPWR VPWR sky130_fd_sc_hd__decap_3
XTAP_TAPCELL_ROW_86_1710 VGND VPWR sky130_fd_sc_hd__tapvpwrvgnd_1
XTAP_TAPCELL_ROW_69_1429 VGND VPWR sky130_fd_sc_hd__tapvpwrvgnd_1
XFILLER_48_179 VPWR VGND VPWR VGND sky130_ef_sc_hd__decap_12
XFILLER_29_382 VGND VGND VPWR VPWR sky130_fd_sc_hd__fill_1
XFILLER_29_393 VGND VGND VPWR VPWR sky130_fd_sc_hd__decap_8
X_10916_ clknet_leaf_29_clk _00978_ VGND VGND VPWR VPWR net149 sky130_fd_sc_hd__dfxtp_1
XPHY_EDGE_ROW_66_Right_66 VGND VGND VPWR VPWR sky130_fd_sc_hd__decap_3
XFILLER_44_363 VGND VGND VPWR VPWR sky130_fd_sc_hd__fill_1
XFILLER_45_897 VGND VGND VPWR VPWR sky130_fd_sc_hd__decap_8
XFILLER_44_396 VPWR VGND VPWR VGND sky130_ef_sc_hd__decap_12
X_10847_ clknet_leaf_93_clk _00001_ VGND VGND VPWR VPWR is_lui_auipc_jal sky130_fd_sc_hd__dfxtp_2
X_10778_ clknet_leaf_57_clk alu_out\[31\] VGND VGND VPWR VPWR alu_out_q\[31\] sky130_fd_sc_hd__dfxtp_1
XFILLER_81_7 VGND VGND VPWR VPWR sky130_fd_sc_hd__decap_4
XPHY_EDGE_ROW_57_Left_211 VGND VGND VPWR VPWR sky130_fd_sc_hd__decap_3
XFILLER_117_129 VGND VGND VPWR VPWR sky130_fd_sc_hd__decap_6
XTAP_TAPCELL_ROW_113_2139 VGND VPWR sky130_fd_sc_hd__tapvpwrvgnd_1
XTAP_TAPCELL_ROW_97_1883 VGND VPWR sky130_fd_sc_hd__tapvpwrvgnd_1
XPHY_EDGE_ROW_75_Right_75 VGND VGND VPWR VPWR sky130_fd_sc_hd__decap_3
XTAP_TAPCELL_ROW_10_494 VGND VPWR sky130_fd_sc_hd__tapvpwrvgnd_1
XFILLER_125_151 VGND VGND VPWR VPWR sky130_fd_sc_hd__decap_6
XFILLER_114_847 VPWR VGND VPWR VGND sky130_ef_sc_hd__decap_12
XFILLER_114_869 VPWR VGND VPWR VGND sky130_ef_sc_hd__decap_12
XFILLER_113_346 VGND VGND VPWR VPWR sky130_fd_sc_hd__decap_8
XFILLER_99_558 VGND VGND VPWR VPWR sky130_fd_sc_hd__fill_2
X_06940_ cpuregs\[16\]\[23\] cpuregs\[17\]\[23\] cpuregs\[18\]\[23\] cpuregs\[19\]\[23\]
+ net267 net260 VGND VGND VPWR VPWR _03355_ sky130_fd_sc_hd__mux4_1
X_06871_ _03280_ _03281_ _03285_ _03286_ _01579_ _01581_ VGND VGND VPWR VPWR _03289_
+ sky130_fd_sc_hd__mux4_1
XFILLER_79_271 VGND VGND VPWR VPWR sky130_fd_sc_hd__decap_8
XPHY_EDGE_ROW_66_Left_220 VGND VGND VPWR VPWR sky130_fd_sc_hd__decap_3
XFILLER_39_113 VGND VGND VPWR VPWR sky130_fd_sc_hd__fill_2
XFILLER_39_124 VGND VGND VPWR VPWR sky130_fd_sc_hd__decap_6
X_05822_ _02092_ _02383_ VGND VGND VPWR VPWR _02385_ sky130_fd_sc_hd__nand2_1
XFILLER_67_444 VGND VGND VPWR VPWR sky130_fd_sc_hd__fill_1
XFILLER_55_617 VGND VGND VPWR VPWR sky130_fd_sc_hd__fill_2
X_08610_ cpuregs\[0\]\[7\] cpuregs\[1\]\[7\] cpuregs\[2\]\[7\] cpuregs\[3\]\[7\] net279
+ _00008_ VGND VGND VPWR VPWR _04305_ sky130_fd_sc_hd__mux4_1
XTAP_TAPCELL_ROW_128_2382 VGND VPWR sky130_fd_sc_hd__tapvpwrvgnd_1
X_09590_ cpuregs\[29\]\[29\] _02704_ net239 VGND VGND VPWR VPWR _01251_ sky130_fd_sc_hd__mux2_1
XFILLER_95_797 VGND VGND VPWR VPWR sky130_fd_sc_hd__decap_8
XPHY_EDGE_ROW_84_Right_84 VGND VGND VPWR VPWR sky130_fd_sc_hd__decap_3
XFILLER_67_499 VGND VGND VPWR VPWR sky130_fd_sc_hd__decap_4
X_05753_ _02151_ _02239_ _02237_ VGND VGND VPWR VPWR _02323_ sky130_fd_sc_hd__o21ba_1
XFILLER_54_138 VGND VGND VPWR VPWR sky130_fd_sc_hd__fill_2
X_08541_ cpuregs\[0\]\[1\] cpuregs\[1\]\[1\] cpuregs\[2\]\[1\] cpuregs\[3\]\[1\] _00007_
+ _00008_ VGND VGND VPWR VPWR _04242_ sky130_fd_sc_hd__mux4_1
XTAP_TAPCELL_ROW_141_2582 VGND VPWR sky130_fd_sc_hd__tapvpwrvgnd_1
XFILLER_63_661 VGND VGND VPWR VPWR sky130_fd_sc_hd__fill_1
X_08472_ _04206_ _04207_ VGND VGND VPWR VPWR _04208_ sky130_fd_sc_hd__and2b_4
X_05684_ _02126_ _02259_ _02125_ VGND VGND VPWR VPWR _02263_ sky130_fd_sc_hd__a21oi_1
XTAP_TAPCELL_ROW_141_2593 VGND VPWR sky130_fd_sc_hd__tapvpwrvgnd_1
XFILLER_62_182 VPWR VGND VPWR VGND sky130_ef_sc_hd__decap_12
XFILLER_62_171 VGND VGND VPWR VPWR sky130_fd_sc_hd__fill_2
X_07423_ cpuregs\[27\]\[7\] _02612_ _03566_ VGND VGND VPWR VPWR _00363_ sky130_fd_sc_hd__mux2_1
XFILLER_24_29 VPWR VGND VPWR VGND sky130_ef_sc_hd__decap_12
XFILLER_149_700 VGND VGND VPWR VPWR sky130_fd_sc_hd__decap_3
X_07354_ _02603_ cpuregs\[9\]\[5\] _03563_ VGND VGND VPWR VPWR _00297_ sky130_fd_sc_hd__mux2_1
X_07285_ cpuregs\[28\]\[3\] _02593_ net249 VGND VGND VPWR VPWR _00231_ sky130_fd_sc_hd__mux2_1
X_06305_ _02737_ _02739_ _02742_ _00015_ _01581_ VGND VGND VPWR VPWR _02743_ sky130_fd_sc_hd__a221o_1
X_06236_ _02680_ _02681_ VGND VGND VPWR VPWR _02682_ sky130_fd_sc_hd__nor2_1
X_09024_ decoded_imm\[29\] _01654_ _01586_ VGND VGND VPWR VPWR _04697_ sky130_fd_sc_hd__a21o_1
XPHY_EDGE_ROW_93_Right_93 VGND VGND VPWR VPWR sky130_fd_sc_hd__decap_3
XFILLER_117_685 VGND VGND VPWR VPWR sky130_fd_sc_hd__fill_1
XFILLER_116_151 VPWR VGND VPWR VGND sky130_ef_sc_hd__decap_12
XFILLER_104_302 VGND VGND VPWR VPWR sky130_fd_sc_hd__decap_6
X_06167_ reg_pc\[10\] _02619_ reg_pc\[11\] VGND VGND VPWR VPWR _02626_ sky130_fd_sc_hd__a21o_1
XTAP_TAPCELL_ROW_148_2703 VGND VPWR sky130_fd_sc_hd__tapvpwrvgnd_1
XFILLER_104_346 VPWR VGND VPWR VGND sky130_ef_sc_hd__decap_12
X_06098_ cpuregs\[16\]\[4\] cpuregs\[17\]\[4\] cpuregs\[18\]\[4\] cpuregs\[19\]\[4\]
+ net278 net273 VGND VGND VPWR VPWR _02569_ sky130_fd_sc_hd__mux4_1
X_05118_ _01721_ _01727_ _01728_ VGND VGND VPWR VPWR _04904_ sky130_fd_sc_hd__or3_1
X_09926_ clknet_leaf_67_clk _00061_ VGND VGND VPWR VPWR cpuregs\[11\]\[24\] sky130_fd_sc_hd__dfxtp_1
XFILLER_132_699 VGND VGND VPWR VPWR sky130_fd_sc_hd__fill_1
X_05049_ mem_wordsize\[2\] mem_wordsize\[1\] VGND VGND VPWR VPWR _01665_ sky130_fd_sc_hd__nor2_8
XFILLER_131_176 VPWR VGND VPWR VGND sky130_ef_sc_hd__decap_12
X_09857_ _02712_ cpuregs\[10\]\[31\] _04876_ VGND VGND VPWR VPWR _01541_ sky130_fd_sc_hd__mux2_1
XFILLER_19_809 VPWR VGND VPWR VGND sky130_ef_sc_hd__decap_12
X_09788_ _02699_ cpuregs\[7\]\[28\] _04874_ VGND VGND VPWR VPWR _01442_ sky130_fd_sc_hd__mux2_1
X_08808_ _01558_ _04491_ VGND VGND VPWR VPWR _04492_ sky130_fd_sc_hd__or2_1
XFILLER_58_477 VGND VGND VPWR VPWR sky130_fd_sc_hd__fill_1
X_08739_ _01558_ _04426_ VGND VGND VPWR VPWR _04427_ sky130_fd_sc_hd__or2_1
XFILLER_27_853 VPWR VGND VPWR VGND sky130_ef_sc_hd__decap_12
XFILLER_121_31 VGND VGND VPWR VPWR sky130_fd_sc_hd__fill_1
XFILLER_27_897 VGND VGND VPWR VPWR sky130_fd_sc_hd__decap_8
XFILLER_42_823 VGND VGND VPWR VPWR sky130_fd_sc_hd__decap_4
X_10701_ clknet_leaf_69_clk _00799_ VGND VGND VPWR VPWR net54 sky130_fd_sc_hd__dfxtp_1
XTAP_TAPCELL_ROW_64_1348 VGND VPWR sky130_fd_sc_hd__tapvpwrvgnd_1
XFILLER_42_845 VGND VGND VPWR VPWR sky130_fd_sc_hd__fill_2
XTAP_TAPCELL_ROW_64_1359 VGND VPWR sky130_fd_sc_hd__tapvpwrvgnd_1
X_10632_ clknet_leaf_83_clk _00762_ VGND VGND VPWR VPWR count_cycle\[55\] sky130_fd_sc_hd__dfxtp_1
XFILLER_41_388 VGND VGND VPWR VPWR sky130_fd_sc_hd__decap_4
XFILLER_41_399 VGND VGND VPWR VPWR sky130_fd_sc_hd__fill_1
X_10563_ clknet_leaf_90_clk _00693_ VGND VGND VPWR VPWR reg_next_pc\[18\] sky130_fd_sc_hd__dfxtp_1
XFILLER_10_731 VGND VGND VPWR VPWR sky130_fd_sc_hd__fill_1
XFILLER_139_276 VGND VGND VPWR VPWR sky130_fd_sc_hd__decap_4
XFILLER_127_449 VGND VGND VPWR VPWR sky130_fd_sc_hd__fill_1
XFILLER_127_438 VGND VGND VPWR VPWR sky130_fd_sc_hd__fill_1
XFILLER_143_909 VGND VGND VPWR VPWR sky130_fd_sc_hd__decap_3
XFILLER_108_641 VGND VGND VPWR VPWR sky130_fd_sc_hd__decap_3
X_10494_ clknet_leaf_105_clk _00624_ VGND VGND VPWR VPWR count_instr\[43\] sky130_fd_sc_hd__dfxtp_1
XFILLER_6_757 VPWR VGND VPWR VGND sky130_ef_sc_hd__decap_12
XFILLER_5_223 VGND VGND VPWR VPWR sky130_fd_sc_hd__fill_1
XFILLER_142_419 VGND VGND VPWR VPWR sky130_fd_sc_hd__fill_1
XFILLER_135_460 VGND VGND VPWR VPWR sky130_fd_sc_hd__decap_4
XFILLER_107_151 VGND VGND VPWR VPWR sky130_fd_sc_hd__fill_1
XTAP_TAPCELL_ROW_79_1591 VGND VPWR sky130_fd_sc_hd__tapvpwrvgnd_1
XFILLER_146_83 VGND VGND VPWR VPWR sky130_fd_sc_hd__fill_1
XFILLER_150_474 VGND VGND VPWR VPWR sky130_fd_sc_hd__fill_2
XFILLER_150_452 VGND VGND VPWR VPWR sky130_fd_sc_hd__fill_1
XFILLER_123_677 VGND VGND VPWR VPWR sky130_fd_sc_hd__fill_1
XFILLER_111_839 VGND VGND VPWR VPWR sky130_fd_sc_hd__fill_1
X_11115_ clknet_leaf_139_clk _01162_ VGND VGND VPWR VPWR cpuregs\[31\]\[4\] sky130_fd_sc_hd__dfxtp_1
XFILLER_49_422 VGND VGND VPWR VPWR sky130_fd_sc_hd__decap_4
X_11046_ clknet_leaf_110_clk _01103_ VGND VGND VPWR VPWR mem_rdata_q\[9\] sky130_fd_sc_hd__dfxtp_1
XFILLER_92_701 VGND VGND VPWR VPWR sky130_fd_sc_hd__decap_6
XFILLER_49_477 VGND VGND VPWR VPWR sky130_fd_sc_hd__decap_8
XFILLER_51_119 VGND VGND VPWR VPWR sky130_fd_sc_hd__fill_1
XFILLER_32_300 VGND VGND VPWR VPWR sky130_fd_sc_hd__decap_8
XFILLER_33_889 VGND VGND VPWR VPWR sky130_fd_sc_hd__decap_6
XTAP_TAPCELL_ROW_99_1912 VGND VPWR sky130_fd_sc_hd__tapvpwrvgnd_1
XTAP_TAPCELL_ROW_15_564 VGND VPWR sky130_fd_sc_hd__tapvpwrvgnd_1
XTAP_TAPCELL_ROW_15_575 VGND VPWR sky130_fd_sc_hd__tapvpwrvgnd_1
XTAP_TAPCELL_ROW_99_1923 VGND VPWR sky130_fd_sc_hd__tapvpwrvgnd_1
XFILLER_145_213 VGND VGND VPWR VPWR sky130_fd_sc_hd__fill_1
X_07070_ _01622_ _03479_ VGND VGND VPWR VPWR _03480_ sky130_fd_sc_hd__nand2_1
XFILLER_72_3 VGND VGND VPWR VPWR sky130_fd_sc_hd__decap_3
X_06021_ mem_rdata_q\[20\] net13 _01609_ VGND VGND VPWR VPWR _01114_ sky130_fd_sc_hd__mux2_1
XFILLER_99_322 VGND VGND VPWR VPWR sky130_fd_sc_hd__fill_1
XFILLER_99_377 VGND VGND VPWR VPWR sky130_fd_sc_hd__fill_2
XFILLER_59_219 VGND VGND VPWR VPWR sky130_fd_sc_hd__decap_4
XFILLER_114_699 VGND VGND VPWR VPWR sky130_fd_sc_hd__fill_1
XFILLER_101_316 VPWR VGND VPWR VGND sky130_ef_sc_hd__decap_12
X_09711_ _02654_ cpuregs\[5\]\[17\] _04872_ VGND VGND VPWR VPWR _01367_ sky130_fd_sc_hd__mux2_1
XFILLER_68_731 VPWR VGND VPWR VGND sky130_ef_sc_hd__decap_12
X_07972_ _03769_ _03695_ _03696_ _03694_ VGND VGND VPWR VPWR _03796_ sky130_fd_sc_hd__and4_1
X_06923_ _00014_ _03329_ _00016_ VGND VGND VPWR VPWR _03339_ sky130_fd_sc_hd__o21a_1
XFILLER_101_349 VGND VGND VPWR VPWR sky130_fd_sc_hd__decap_6
XFILLER_95_561 VPWR VGND VPWR VGND sky130_ef_sc_hd__decap_12
XTAP_TAPCELL_ROW_143_2622 VGND VPWR sky130_fd_sc_hd__tapvpwrvgnd_1
X_06854_ _03270_ _03271_ VGND VGND VPWR VPWR _03272_ sky130_fd_sc_hd__and2_1
X_09642_ _02646_ cpuregs\[22\]\[15\] _04869_ VGND VGND VPWR VPWR _01301_ sky130_fd_sc_hd__mux2_1
XFILLER_55_425 VGND VGND VPWR VPWR sky130_fd_sc_hd__decap_4
X_05805_ net255 _02367_ _02369_ VGND VGND VPWR VPWR alu_out\[18\] sky130_fd_sc_hd__a21o_1
X_06785_ _03199_ _03200_ _03201_ _03202_ _01579_ _01581_ VGND VGND VPWR VPWR _03206_
+ sky130_fd_sc_hd__mux4_1
X_09573_ cpuregs\[29\]\[12\] _02633_ net239 VGND VGND VPWR VPWR _01234_ sky130_fd_sc_hd__mux2_1
X_05736_ _02307_ _02306_ instr_sub VGND VGND VPWR VPWR _02308_ sky130_fd_sc_hd__mux2_1
X_08524_ _04224_ _04225_ _01558_ VGND VGND VPWR VPWR _04226_ sky130_fd_sc_hd__mux2_1
XFILLER_35_39 VPWR VGND VPWR VGND sky130_ef_sc_hd__decap_12
X_08455_ cpuregs\[26\]\[31\] cpuregs\[27\]\[31\] net264 VGND VGND VPWR VPWR _04192_
+ sky130_fd_sc_hd__mux2_1
X_05667_ instr_sub _01569_ _02248_ VGND VGND VPWR VPWR _02249_ sky130_fd_sc_hd__or3_1
XFILLER_51_642 VGND VGND VPWR VPWR sky130_fd_sc_hd__decap_4
XFILLER_24_867 VGND VGND VPWR VPWR sky130_fd_sc_hd__fill_1
XTAP_TAPCELL_ROW_46_1067 VGND VPWR sky130_fd_sc_hd__tapvpwrvgnd_1
X_07406_ cpuregs\[14\]\[24\] _02683_ net247 VGND VGND VPWR VPWR _00348_ sky130_fd_sc_hd__mux2_1
X_08386_ _04139_ _04140_ VGND VGND VPWR VPWR _00753_ sky130_fd_sc_hd__nor2_1
XFILLER_51_697 VGND VGND VPWR VPWR sky130_fd_sc_hd__decap_6
X_05598_ net607 _01570_ _02180_ VGND VGND VPWR VPWR _02181_ sky130_fd_sc_hd__a21o_1
XFILLER_11_539 VPWR VGND VPWR VGND sky130_ef_sc_hd__decap_12
XTAP_TAPCELL_ROW_34_873 VGND VPWR sky130_fd_sc_hd__tapvpwrvgnd_1
X_07337_ cpuregs\[21\]\[21\] _02670_ _03562_ VGND VGND VPWR VPWR _00281_ sky130_fd_sc_hd__mux2_1
X_07268_ cpuregs\[2\]\[19\] _02662_ _03559_ VGND VGND VPWR VPWR _00215_ sky130_fd_sc_hd__mux2_1
XFILLER_152_717 VPWR VGND VPWR VGND sky130_ef_sc_hd__decap_12
XFILLER_151_205 VPWR VGND VPWR VGND sky130_ef_sc_hd__decap_12
XFILLER_124_419 VGND VGND VPWR VPWR sky130_fd_sc_hd__fill_1
XFILLER_124_408 VGND VGND VPWR VPWR sky130_fd_sc_hd__fill_2
X_06219_ reg_pc\[21\] reg_pc\[20\] _02660_ VGND VGND VPWR VPWR _02668_ sky130_fd_sc_hd__and3_1
X_09007_ cpuregs\[20\]\[29\] cpuregs\[21\]\[29\] cpuregs\[22\]\[29\] cpuregs\[23\]\[29\]
+ net275 net271 VGND VGND VPWR VPWR _04680_ sky130_fd_sc_hd__mux4_1
X_07199_ cpuregs\[30\]\[17\] _02654_ net252 VGND VGND VPWR VPWR _00149_ sky130_fd_sc_hd__mux2_1
XFILLER_3_727 VGND VGND VPWR VPWR sky130_fd_sc_hd__fill_1
XFILLER_151_249 VPWR VGND VPWR VGND sky130_ef_sc_hd__decap_12
XFILLER_105_677 VGND VGND VPWR VPWR sky130_fd_sc_hd__fill_1
XFILLER_78_517 VGND VGND VPWR VPWR sky130_fd_sc_hd__decap_8
XFILLER_116_64 VGND VGND VPWR VPWR sky130_fd_sc_hd__fill_2
X_09909_ clknet_leaf_146_clk _00044_ VGND VGND VPWR VPWR cpuregs\[11\]\[7\] sky130_fd_sc_hd__dfxtp_1
XFILLER_101_872 VGND VGND VPWR VPWR sky130_fd_sc_hd__fill_1
XFILLER_86_572 VPWR VGND VPWR VGND sky130_ef_sc_hd__decap_12
XFILLER_74_701 VGND VGND VPWR VPWR sky130_fd_sc_hd__fill_2
XFILLER_132_41 VPWR VGND VPWR VGND sky130_ef_sc_hd__decap_12
XFILLER_73_233 VPWR VGND VPWR VGND sky130_ef_sc_hd__decap_12
XFILLER_132_85 VPWR VGND VPWR VGND sky130_ef_sc_hd__decap_12
XFILLER_61_439 VGND VGND VPWR VPWR sky130_fd_sc_hd__decap_4
XFILLER_14_300 VGND VGND VPWR VPWR sky130_fd_sc_hd__decap_8
XFILLER_15_889 VGND VGND VPWR VPWR sky130_fd_sc_hd__decap_6
XFILLER_42_653 VGND VGND VPWR VPWR sky130_fd_sc_hd__fill_1
XFILLER_30_837 VPWR VGND VPWR VGND sky130_ef_sc_hd__decap_12
X_10615_ clknet_leaf_106_clk _00745_ VGND VGND VPWR VPWR count_cycle\[38\] sky130_fd_sc_hd__dfxtp_1
XTAP_TAPCELL_ROW_12_523 VGND VPWR sky130_fd_sc_hd__tapvpwrvgnd_1
XFILLER_128_725 VGND VGND VPWR VPWR sky130_fd_sc_hd__fill_1
XFILLER_127_235 VGND VGND VPWR VPWR sky130_fd_sc_hd__decap_4
X_10546_ clknet_leaf_101_clk _00676_ VGND VGND VPWR VPWR reg_next_pc\[1\] sky130_fd_sc_hd__dfxtp_1
XFILLER_108_460 VGND VGND VPWR VPWR sky130_fd_sc_hd__decap_3
X_10477_ clknet_leaf_82_clk _00607_ VGND VGND VPWR VPWR count_instr\[26\] sky130_fd_sc_hd__dfxtp_1
XTAP_TAPCELL_ROW_94_1842 VGND VPWR sky130_fd_sc_hd__tapvpwrvgnd_1
XTAP_TAPCELL_ROW_94_1831 VGND VPWR sky130_fd_sc_hd__tapvpwrvgnd_1
Xrebuffer191 net578 VGND VGND VPWR VPWR net577 sky130_fd_sc_hd__dlygate4sd1_1
Xrebuffer180 net567 VGND VGND VPWR VPWR net566 sky130_fd_sc_hd__clkbuf_2
XFILLER_151_783 VGND VGND VPWR VPWR sky130_fd_sc_hd__fill_1
XFILLER_111_625 VGND VGND VPWR VPWR sky130_fd_sc_hd__fill_1
XFILLER_110_102 VGND VGND VPWR VPWR sky130_fd_sc_hd__fill_1
XFILLER_2_793 VPWR VGND VPWR VGND sky130_ef_sc_hd__decap_12
XFILLER_96_347 VPWR VGND VPWR VGND sky130_ef_sc_hd__decap_12
XFILLER_49_241 VGND VGND VPWR VPWR sky130_fd_sc_hd__fill_1
XFILLER_1_281 VPWR VGND VPWR VGND sky130_ef_sc_hd__decap_12
XFILLER_110_179 VGND VGND VPWR VPWR sky130_fd_sc_hd__decap_6
X_11029_ clknet_leaf_32_clk _01091_ VGND VGND VPWR VPWR cpuregs\[19\]\[29\] sky130_fd_sc_hd__dfxtp_1
XFILLER_77_561 VPWR VGND VPWR VGND sky130_ef_sc_hd__decap_12
XFILLER_65_723 VGND VGND VPWR VPWR sky130_fd_sc_hd__decap_4
XFILLER_49_274 VGND VGND VPWR VPWR sky130_fd_sc_hd__decap_6
XFILLER_2_65 VPWR VGND VPWR VGND sky130_ef_sc_hd__decap_12
XFILLER_37_414 VGND VGND VPWR VPWR sky130_fd_sc_hd__fill_2
XTAP_TAPCELL_ROW_125_2330 VGND VPWR sky130_fd_sc_hd__tapvpwrvgnd_1
XFILLER_92_531 VGND VGND VPWR VPWR sky130_fd_sc_hd__fill_1
XFILLER_64_222 VGND VGND VPWR VPWR sky130_fd_sc_hd__fill_1
XFILLER_37_436 VGND VGND VPWR VPWR sky130_fd_sc_hd__decap_4
XFILLER_65_789 VGND VGND VPWR VPWR sky130_fd_sc_hd__fill_1
XFILLER_52_417 VGND VGND VPWR VPWR sky130_fd_sc_hd__decap_3
X_06570_ _02993_ _02994_ net258 VGND VGND VPWR VPWR _02999_ sky130_fd_sc_hd__mux2_1
X_05521_ net180 net212 VGND VGND VPWR VPWR _02104_ sky130_fd_sc_hd__nand2_1
XFILLER_17_193 VGND VGND VPWR VPWR sky130_fd_sc_hd__decap_3
X_08240_ _04032_ _04035_ _04033_ VGND VGND VPWR VPWR _04043_ sky130_fd_sc_hd__a21o_1
XTAP_TAPCELL_ROW_103_1982 VGND VPWR sky130_fd_sc_hd__tapvpwrvgnd_1
X_05452_ cpu_state\[3\] _02030_ _02031_ _02036_ VGND VGND VPWR VPWR _02037_ sky130_fd_sc_hd__a31o_1
XFILLER_33_697 VGND VGND VPWR VPWR sky130_fd_sc_hd__decap_4
X_08171_ instr_jal _03978_ _03979_ _03976_ _03977_ VGND VGND VPWR VPWR _03980_ sky130_fd_sc_hd__o32a_1
XANTENNA_26 net217 VGND VGND VPWR VPWR sky130_fd_sc_hd__diode_2
XANTENNA_37 net175 VGND VGND VPWR VPWR sky130_fd_sc_hd__diode_2
XANTENNA_15 mem_wordsize\[2\] VGND VGND VPWR VPWR sky130_fd_sc_hd__diode_2
XFILLER_20_325 VPWR VGND VPWR VGND sky130_ef_sc_hd__decap_12
XTAP_TAPCELL_ROW_31_821 VGND VPWR sky130_fd_sc_hd__tapvpwrvgnd_1
XTAP_TAPCELL_ROW_31_832 VGND VPWR sky130_fd_sc_hd__tapvpwrvgnd_1
XFILLER_118_213 VGND VGND VPWR VPWR sky130_fd_sc_hd__decap_6
X_05383_ _01959_ _01961_ _01971_ VGND VGND VPWR VPWR _01973_ sky130_fd_sc_hd__a21o_1
X_07122_ _01622_ _03528_ _03529_ VGND VGND VPWR VPWR _03530_ sky130_fd_sc_hd__and3_1
XFILLER_146_533 VPWR VGND VPWR VGND sky130_ef_sc_hd__decap_12
XFILLER_9_381 VGND VGND VPWR VPWR sky130_fd_sc_hd__decap_8
X_07053_ cpuregs\[8\]\[27\] cpuregs\[9\]\[27\] cpuregs\[10\]\[27\] cpuregs\[11\]\[27\]
+ net266 net261 VGND VGND VPWR VPWR _03464_ sky130_fd_sc_hd__mux4_1
XFILLER_118_268 VGND VGND VPWR VPWR sky130_fd_sc_hd__fill_1
XFILLER_106_419 VGND VGND VPWR VPWR sky130_fd_sc_hd__fill_1
Xoutput100 net100 VGND VGND VPWR VPWR mem_la_wdata[12] sky130_fd_sc_hd__buf_2
X_06004_ net187 _02505_ _01582_ VGND VGND VPWR VPWR net80 sky130_fd_sc_hd__mux2_1
XFILLER_114_430 VGND VGND VPWR VPWR sky130_fd_sc_hd__fill_1
Xoutput111 net111 VGND VGND VPWR VPWR mem_la_wdata[22] sky130_fd_sc_hd__buf_2
Xoutput122 net122 VGND VGND VPWR VPWR mem_la_wdata[3] sky130_fd_sc_hd__buf_2
Xoutput133 net133 VGND VGND VPWR VPWR mem_la_wstrb[3] sky130_fd_sc_hd__buf_2
XFILLER_114_463 VGND VGND VPWR VPWR sky130_fd_sc_hd__fill_1
Xoutput144 net144 VGND VGND VPWR VPWR mem_wdata[18] sky130_fd_sc_hd__buf_2
Xoutput155 net155 VGND VGND VPWR VPWR mem_wdata[28] sky130_fd_sc_hd__buf_2
Xoutput177 net177 VGND VGND VPWR VPWR pcpi_rs1[15] sky130_fd_sc_hd__buf_2
Xoutput166 net166 VGND VGND VPWR VPWR mem_wdata[9] sky130_fd_sc_hd__buf_2
Xoutput188 net188 VGND VGND VPWR VPWR pcpi_rs1[25] sky130_fd_sc_hd__buf_2
XFILLER_153_29 VPWR VGND VPWR VGND sky130_ef_sc_hd__decap_12
Xoutput199 net199 VGND VGND VPWR VPWR pcpi_rs1[6] sky130_fd_sc_hd__buf_2
XFILLER_141_293 VPWR VGND VPWR VGND sky130_ef_sc_hd__decap_12
XFILLER_102_658 VGND VGND VPWR VPWR sky130_fd_sc_hd__decap_4
XFILLER_101_146 VGND VGND VPWR VPWR sky130_fd_sc_hd__decap_6
XFILLER_87_358 VPWR VGND VPWR VGND sky130_ef_sc_hd__decap_12
X_07955_ _03694_ _03769_ _01551_ VGND VGND VPWR VPWR _03781_ sky130_fd_sc_hd__o21ai_1
X_06906_ _03296_ _03300_ VGND VGND VPWR VPWR _03322_ sky130_fd_sc_hd__nor2_1
XFILLER_56_701 VGND VGND VPWR VPWR sky130_fd_sc_hd__decap_4
X_07886_ reg_pc\[30\] _01624_ _01628_ _03718_ VGND VGND VPWR VPWR _00674_ sky130_fd_sc_hd__a22o_1
XFILLER_83_531 VGND VGND VPWR VPWR sky130_fd_sc_hd__decap_6
X_09625_ _02712_ cpuregs\[3\]\[31\] _04868_ VGND VGND VPWR VPWR _01285_ sky130_fd_sc_hd__mux2_1
XTAP_TAPCELL_ROW_39_954 VGND VPWR sky130_fd_sc_hd__tapvpwrvgnd_1
XFILLER_46_27 VGND VGND VPWR VPWR sky130_fd_sc_hd__fill_1
X_06837_ cpuregs\[8\]\[19\] cpuregs\[9\]\[19\] cpuregs\[10\]\[19\] cpuregs\[11\]\[19\]
+ net267 _00013_ VGND VGND VPWR VPWR _03256_ sky130_fd_sc_hd__mux4_1
XFILLER_83_553 VGND VGND VPWR VPWR sky130_fd_sc_hd__decap_6
XFILLER_56_789 VGND VGND VPWR VPWR sky130_fd_sc_hd__decap_4
XTAP_TAPCELL_ROW_48_1107 VGND VPWR sky130_fd_sc_hd__tapvpwrvgnd_1
XFILLER_15_108 VGND VGND VPWR VPWR sky130_fd_sc_hd__decap_4
X_09556_ cpuregs\[23\]\[28\] _02699_ _04866_ VGND VGND VPWR VPWR _01218_ sky130_fd_sc_hd__mux2_1
X_06768_ decoded_imm\[16\] net178 _03186_ VGND VGND VPWR VPWR _03189_ sky130_fd_sc_hd__a21oi_1
XFILLER_24_620 VGND VGND VPWR VPWR sky130_fd_sc_hd__decap_3
X_09487_ cpuregs\[24\]\[25\] _02688_ _04864_ VGND VGND VPWR VPWR _01151_ sky130_fd_sc_hd__mux2_1
X_06699_ cpuregs\[24\]\[14\] cpuregs\[25\]\[14\] cpuregs\[26\]\[14\] cpuregs\[27\]\[14\]
+ net265 net260 VGND VGND VPWR VPWR _03123_ sky130_fd_sc_hd__mux4_1
X_05719_ _02135_ _02237_ _02238_ _02136_ VGND VGND VPWR VPWR _02293_ sky130_fd_sc_hd__a22o_1
X_08507_ is_sb_sh_sw _01653_ _01664_ VGND VGND VPWR VPWR _04212_ sky130_fd_sc_hd__a21o_1
X_08438_ _04172_ _04173_ _04174_ _02714_ VGND VGND VPWR VPWR _04175_ sky130_fd_sc_hd__a211o_1
XTAP_TAPCELL_ROW_61_1307 VGND VPWR sky130_fd_sc_hd__tapvpwrvgnd_1
XFILLER_51_483 VGND VGND VPWR VPWR sky130_fd_sc_hd__decap_3
XFILLER_12_837 VPWR VGND VPWR VGND sky130_ef_sc_hd__decap_12
XFILLER_23_185 VGND VGND VPWR VPWR sky130_fd_sc_hd__decap_3
XFILLER_109_213 VGND VGND VPWR VPWR sky130_fd_sc_hd__decap_8
X_08369_ count_cycle\[40\] _04128_ net34 VGND VGND VPWR VPWR _04130_ sky130_fd_sc_hd__o21ai_1
XFILLER_11_358 VGND VGND VPWR VPWR sky130_fd_sc_hd__decap_6
XFILLER_149_393 VPWR VGND VPWR VGND sky130_ef_sc_hd__decap_12
X_10400_ clknet_leaf_26_clk _00530_ VGND VGND VPWR VPWR cpuregs\[20\]\[14\] sky130_fd_sc_hd__dfxtp_1
XPHY_EDGE_ROW_12_Left_166 VGND VGND VPWR VPWR sky130_fd_sc_hd__decap_3
XFILLER_20_881 VPWR VGND VPWR VGND sky130_ef_sc_hd__decap_12
Xwire249 _03560_ VGND VGND VPWR VPWR net249 sky130_fd_sc_hd__buf_12
X_11380_ clknet_leaf_3_clk _01424_ VGND VGND VPWR VPWR cpuregs\[7\]\[10\] sky130_fd_sc_hd__dfxtp_1
XFILLER_125_739 VGND VGND VPWR VPWR sky130_fd_sc_hd__decap_4
X_10331_ clknet_leaf_0_clk _00461_ VGND VGND VPWR VPWR cpuregs\[16\]\[9\] sky130_fd_sc_hd__dfxtp_1
XTAP_TAPCELL_ROW_76_1550 VGND VPWR sky130_fd_sc_hd__tapvpwrvgnd_1
XTAP_TAPCELL_ROW_59_1269 VGND VPWR sky130_fd_sc_hd__tapvpwrvgnd_1
X_10262_ clknet_leaf_135_clk _00392_ VGND VGND VPWR VPWR cpuregs\[15\]\[4\] sky130_fd_sc_hd__dfxtp_1
XFILLER_133_750 VPWR VGND VPWR VGND sky130_ef_sc_hd__decap_12
XFILLER_127_74 VGND VGND VPWR VPWR sky130_fd_sc_hd__decap_4
XFILLER_117_290 VGND VGND VPWR VPWR sky130_fd_sc_hd__decap_3
XFILLER_87_23 VPWR VGND VPWR VGND sky130_ef_sc_hd__decap_12
XFILLER_79_826 VGND VGND VPWR VPWR sky130_fd_sc_hd__decap_3
XFILLER_2_3 VPWR VGND VPWR VGND sky130_ef_sc_hd__decap_12
X_10193_ clknet_leaf_135_clk _00323_ VGND VGND VPWR VPWR cpuregs\[9\]\[31\] sky130_fd_sc_hd__dfxtp_1
XFILLER_143_51 VGND VGND VPWR VPWR sky130_fd_sc_hd__decap_4
XFILLER_59_561 VGND VGND VPWR VPWR sky130_fd_sc_hd__decap_6
XFILLER_74_542 VGND VGND VPWR VPWR sky130_fd_sc_hd__decap_6
XPHY_EDGE_ROW_21_Left_175 VGND VGND VPWR VPWR sky130_fd_sc_hd__decap_3
XTAP_TAPCELL_ROW_17_604 VGND VPWR sky130_fd_sc_hd__tapvpwrvgnd_1
XFILLER_61_214 VGND VGND VPWR VPWR sky130_fd_sc_hd__fill_1
XFILLER_148_809 VGND VGND VPWR VPWR sky130_fd_sc_hd__decap_3
XFILLER_70_792 VPWR VGND VPWR VGND sky130_ef_sc_hd__decap_12
XFILLER_30_645 VPWR VGND VPWR VGND sky130_ef_sc_hd__decap_12
XPHY_EDGE_ROW_30_Left_184 VGND VGND VPWR VPWR sky130_fd_sc_hd__decap_3
Xinput13 mem_rdata[20] VGND VGND VPWR VPWR net13 sky130_fd_sc_hd__buf_2
XFILLER_128_533 VGND VGND VPWR VPWR sky130_fd_sc_hd__decap_8
Xinput24 mem_rdata[30] VGND VGND VPWR VPWR net24 sky130_fd_sc_hd__buf_2
XFILLER_7_841 VPWR VGND VPWR VGND sky130_ef_sc_hd__decap_12
XFILLER_143_503 VGND VGND VPWR VPWR sky130_fd_sc_hd__fill_1
XFILLER_128_566 VGND VGND VPWR VPWR sky130_fd_sc_hd__fill_1
X_10529_ clknet_leaf_94_clk _00659_ VGND VGND VPWR VPWR reg_pc\[15\] sky130_fd_sc_hd__dfxtp_1
XFILLER_115_249 VPWR VGND VPWR VGND sky130_ef_sc_hd__decap_12
XFILLER_35_3 VPWR VGND VPWR VGND sky130_ef_sc_hd__decap_12
XFILLER_123_293 VPWR VGND VPWR VGND sky130_ef_sc_hd__decap_12
XFILLER_111_466 VGND VGND VPWR VPWR sky130_fd_sc_hd__decap_8
X_07740_ count_instr\[32\] _03633_ net34 VGND VGND VPWR VPWR _03635_ sky130_fd_sc_hd__o21ai_1
XFILLER_38_701 VPWR VGND VPWR VGND sky130_ef_sc_hd__decap_12
X_04952_ mem_do_rdata _01582_ _01583_ net34 VGND VGND VPWR VPWR net96 sky130_fd_sc_hd__o211a_1
XFILLER_84_339 VGND VGND VPWR VPWR sky130_fd_sc_hd__decap_8
X_07671_ count_instr\[7\] _03589_ net34 VGND VGND VPWR VPWR _03591_ sky130_fd_sc_hd__o21ai_1
XTAP_TAPCELL_ROW_36_902 VGND VPWR sky130_fd_sc_hd__tapvpwrvgnd_1
XFILLER_93_895 VGND VGND VPWR VPWR sky130_fd_sc_hd__fill_1
X_09410_ _02641_ cpuregs\[18\]\[14\] _04862_ VGND VGND VPWR VPWR _01044_ sky130_fd_sc_hd__mux2_1
X_06622_ cpuregs\[8\]\[11\] cpuregs\[9\]\[11\] cpuregs\[10\]\[11\] cpuregs\[11\]\[11\]
+ net268 net259 VGND VGND VPWR VPWR _03049_ sky130_fd_sc_hd__mux4_1
XTAP_TAPCELL_ROW_36_913 VGND VPWR sky130_fd_sc_hd__tapvpwrvgnd_1
XFILLER_37_277 VGND VGND VPWR VPWR sky130_fd_sc_hd__decap_3
X_09341_ decoded_imm\[25\] _04746_ _04825_ _04832_ VGND VGND VPWR VPWR _01005_ sky130_fd_sc_hd__o22a_1
X_06553_ _02981_ VGND VGND VPWR VPWR _02982_ sky130_fd_sc_hd__inv_2
X_05504_ net185 net217 VGND VGND VPWR VPWR _02087_ sky130_fd_sc_hd__nor2_1
XTAP_TAPCELL_ROW_43_1015 VGND VPWR sky130_fd_sc_hd__tapvpwrvgnd_1
XFILLER_139_809 VPWR VGND VPWR VGND sky130_ef_sc_hd__decap_12
XTAP_TAPCELL_ROW_138_2532 VGND VPWR sky130_fd_sc_hd__tapvpwrvgnd_1
XFILLER_60_280 VGND VGND VPWR VPWR sky130_fd_sc_hd__fill_1
XFILLER_32_29 VPWR VGND VPWR VGND sky130_ef_sc_hd__decap_12
XFILLER_33_494 VGND VGND VPWR VPWR sky130_fd_sc_hd__decap_3
X_06484_ cpuregs\[8\]\[6\] cpuregs\[9\]\[6\] cpuregs\[10\]\[6\] cpuregs\[11\]\[6\]
+ net263 net259 VGND VGND VPWR VPWR _02916_ sky130_fd_sc_hd__mux4_1
XTAP_TAPCELL_ROW_43_1026 VGND VPWR sky130_fd_sc_hd__tapvpwrvgnd_1
X_09272_ net157 net119 _04206_ VGND VGND VPWR VPWR _00958_ sky130_fd_sc_hd__mux2_1
XFILLER_148_29 VPWR VGND VPWR VGND sky130_ef_sc_hd__decap_12
XTAP_TAPCELL_ROW_138_2543 VGND VPWR sky130_fd_sc_hd__tapvpwrvgnd_1
X_08223_ _01547_ reg_next_pc\[28\] _01645_ _03716_ VGND VGND VPWR VPWR _04028_ sky130_fd_sc_hd__a22o_1
X_05435_ net22 _01665_ _01856_ VGND VGND VPWR VPWR _02021_ sky130_fd_sc_hd__a21o_1
XFILLER_147_853 VPWR VGND VPWR VGND sky130_ef_sc_hd__decap_12
X_08154_ _03710_ _03959_ instr_jal VGND VGND VPWR VPWR _03964_ sky130_fd_sc_hd__a21o_1
X_05366_ _01912_ _01954_ _01956_ VGND VGND VPWR VPWR _01957_ sky130_fd_sc_hd__o21ba_1
XTAP_TAPCELL_ROW_151_2754 VGND VPWR sky130_fd_sc_hd__tapvpwrvgnd_1
XTAP_TAPCELL_ROW_151_2743 VGND VPWR sky130_fd_sc_hd__tapvpwrvgnd_1
XFILLER_147_897 VPWR VGND VPWR VGND sky130_ef_sc_hd__decap_12
XFILLER_134_503 VGND VGND VPWR VPWR sky130_fd_sc_hd__fill_2
X_07105_ cpuregs\[4\]\[29\] cpuregs\[5\]\[29\] cpuregs\[6\]\[29\] cpuregs\[7\]\[29\]
+ net266 net261 VGND VGND VPWR VPWR _03514_ sky130_fd_sc_hd__mux4_1
X_08085_ _03898_ _03899_ VGND VGND VPWR VPWR _03901_ sky130_fd_sc_hd__nor2_1
X_07036_ net190 _02725_ VGND VGND VPWR VPWR _03447_ sky130_fd_sc_hd__and2_1
X_05297_ count_cycle\[18\] _01588_ VGND VGND VPWR VPWR _01894_ sky130_fd_sc_hd__or2_1
XFILLER_115_794 VPWR VGND VPWR VGND sky130_ef_sc_hd__decap_12
XFILLER_87_111 VGND VGND VPWR VPWR sky130_fd_sc_hd__fill_1
XTAP_TAPCELL_ROW_54_1188 VGND VPWR sky130_fd_sc_hd__tapvpwrvgnd_1
X_08987_ net269 _04660_ _01559_ VGND VGND VPWR VPWR _04662_ sky130_fd_sc_hd__a21o_1
Xclkbuf_4_5_0_clk clknet_0_clk VGND VGND VPWR VPWR clknet_4_5_0_clk sky130_fd_sc_hd__clkbuf_8
XTAP_TAPCELL_ROW_54_1199 VGND VPWR sky130_fd_sc_hd__tapvpwrvgnd_1
X_07938_ _03753_ _03754_ _03752_ VGND VGND VPWR VPWR _03765_ sky130_fd_sc_hd__a21o_1
X_07869_ _02676_ reg_next_pc\[23\] net596 VGND VGND VPWR VPWR _03710_ sky130_fd_sc_hd__mux2_2
XFILLER_90_309 VGND VGND VPWR VPWR sky130_fd_sc_hd__decap_8
XTAP_TAPCELL_ROW_3_387 VGND VPWR sky130_fd_sc_hd__tapvpwrvgnd_1
XTAP_TAPCELL_ROW_3_376 VGND VPWR sky130_fd_sc_hd__tapvpwrvgnd_1
XFILLER_16_406 VPWR VGND VPWR VGND sky130_ef_sc_hd__decap_12
X_10880_ clknet_leaf_69_clk _00942_ VGND VGND VPWR VPWR cpuregs\[1\]\[24\] sky130_fd_sc_hd__dfxtp_1
X_09608_ _02641_ cpuregs\[3\]\[14\] _04868_ VGND VGND VPWR VPWR _01268_ sky130_fd_sc_hd__mux2_1
XFILLER_84_895 VGND VGND VPWR VPWR sky130_fd_sc_hd__fill_1
XFILLER_73_36 VPWR VGND VPWR VGND sky130_ef_sc_hd__decap_12
X_09539_ cpuregs\[23\]\[11\] _02630_ _04866_ VGND VGND VPWR VPWR _01201_ sky130_fd_sc_hd__mux2_1
XFILLER_52_781 VGND VGND VPWR VPWR sky130_fd_sc_hd__fill_1
XFILLER_11_111 VGND VGND VPWR VPWR sky130_fd_sc_hd__fill_1
XFILLER_12_645 VPWR VGND VPWR VGND sky130_ef_sc_hd__decap_12
X_11432_ clknet_leaf_24_clk _01476_ VGND VGND VPWR VPWR cpuregs\[8\]\[30\] sky130_fd_sc_hd__dfxtp_1
XFILLER_7_137 VPWR VGND VPWR VGND sky130_ef_sc_hd__decap_12
XTAP_TAPCELL_ROW_22_684 VGND VPWR sky130_fd_sc_hd__tapvpwrvgnd_1
XFILLER_4_811 VGND VGND VPWR VPWR sky130_fd_sc_hd__fill_1
XFILLER_152_333 VGND VGND VPWR VPWR sky130_fd_sc_hd__decap_6
X_11363_ clknet_leaf_47_clk _01407_ VGND VGND VPWR VPWR cpuregs\[6\]\[25\] sky130_fd_sc_hd__dfxtp_1
XFILLER_125_536 VGND VGND VPWR VPWR sky130_fd_sc_hd__fill_2
XTAP_TAPCELL_ROW_74_1509 VGND VPWR sky130_fd_sc_hd__tapvpwrvgnd_1
XFILLER_153_867 VGND VGND VPWR VPWR sky130_fd_sc_hd__fill_1
X_10314_ clknet_leaf_67_clk _00444_ VGND VGND VPWR VPWR cpuregs\[26\]\[24\] sky130_fd_sc_hd__dfxtp_1
X_11294_ clknet_leaf_42_clk _01341_ VGND VGND VPWR VPWR cpuregs\[4\]\[23\] sky130_fd_sc_hd__dfxtp_1
XFILLER_98_66 VPWR VGND VPWR VGND sky130_ef_sc_hd__decap_12
XFILLER_152_377 VPWR VGND VPWR VGND sky130_ef_sc_hd__decap_12
XFILLER_140_528 VGND VGND VPWR VPWR sky130_fd_sc_hd__decap_4
X_10245_ clknet_leaf_64_clk _00375_ VGND VGND VPWR VPWR cpuregs\[27\]\[19\] sky130_fd_sc_hd__dfxtp_1
X_10176_ clknet_leaf_26_clk _00306_ VGND VGND VPWR VPWR cpuregs\[9\]\[14\] sky130_fd_sc_hd__dfxtp_1
XFILLER_78_133 VGND VGND VPWR VPWR sky130_fd_sc_hd__decap_6
XFILLER_121_797 VPWR VGND VPWR VGND sky130_ef_sc_hd__decap_12
XFILLER_120_241 VGND VGND VPWR VPWR sky130_fd_sc_hd__decap_8
XFILLER_94_626 VGND VGND VPWR VPWR sky130_fd_sc_hd__decap_4
XFILLER_78_177 VGND VGND VPWR VPWR sky130_fd_sc_hd__decap_8
XFILLER_47_531 VGND VGND VPWR VPWR sky130_fd_sc_hd__decap_8
XTAP_TAPCELL_ROW_105_2019 VGND VPWR sky130_fd_sc_hd__tapvpwrvgnd_1
XTAP_TAPCELL_ROW_105_2008 VGND VPWR sky130_fd_sc_hd__tapvpwrvgnd_1
XFILLER_93_169 VGND VGND VPWR VPWR sky130_fd_sc_hd__decap_4
XTAP_TAPCELL_ROW_89_1763 VGND VPWR sky130_fd_sc_hd__tapvpwrvgnd_1
XTAP_TAPCELL_ROW_89_1752 VGND VPWR sky130_fd_sc_hd__tapvpwrvgnd_1
XFILLER_75_862 VGND VGND VPWR VPWR sky130_fd_sc_hd__fill_2
XFILLER_90_832 VPWR VGND VPWR VGND sky130_ef_sc_hd__decap_12
XFILLER_62_501 VGND VGND VPWR VPWR sky130_fd_sc_hd__decap_4
XFILLER_34_203 VGND VGND VPWR VPWR sky130_fd_sc_hd__fill_1
XFILLER_90_876 VGND VGND VPWR VPWR sky130_fd_sc_hd__decap_6
XFILLER_62_589 VPWR VGND VPWR VGND sky130_ef_sc_hd__decap_12
XFILLER_50_718 VGND VGND VPWR VPWR sky130_fd_sc_hd__fill_2
XFILLER_15_472 VGND VGND VPWR VPWR sky130_fd_sc_hd__decap_6
XFILLER_43_781 VGND VGND VPWR VPWR sky130_fd_sc_hd__decap_3
XTAP_TAPCELL_ROW_100_1930 VGND VPWR sky130_fd_sc_hd__tapvpwrvgnd_1
XFILLER_147_105 VGND VGND VPWR VPWR sky130_fd_sc_hd__decap_6
XFILLER_147_149 VPWR VGND VPWR VGND sky130_ef_sc_hd__decap_12
XFILLER_129_853 VPWR VGND VPWR VGND sky130_ef_sc_hd__decap_12
X_05220_ net4 _01666_ _01667_ net21 _01772_ VGND VGND VPWR VPWR _01823_ sky130_fd_sc_hd__o221a_1
XFILLER_8_53 VPWR VGND VPWR VGND sky130_ef_sc_hd__decap_12
XFILLER_30_475 VGND VGND VPWR VPWR sky130_fd_sc_hd__fill_1
XFILLER_30_486 VGND VGND VPWR VPWR sky130_fd_sc_hd__decap_4
XTAP_TAPCELL_ROW_41_982 VGND VPWR sky130_fd_sc_hd__tapvpwrvgnd_1
XTAP_TAPCELL_ROW_41_993 VGND VPWR sky130_fd_sc_hd__tapvpwrvgnd_1
XFILLER_129_897 VPWR VGND VPWR VGND sky130_ef_sc_hd__decap_12
X_05151_ net606 net7 _01758_ net171 mem_wordsize\[1\] VGND VGND VPWR VPWR _01759_
+ sky130_fd_sc_hd__o2111a_1
XFILLER_8_97 VPWR VGND VPWR VGND sky130_ef_sc_hd__decap_12
XTAP_TAPCELL_ROW_133_2462 VGND VPWR sky130_fd_sc_hd__tapvpwrvgnd_1
XFILLER_144_867 VGND VGND VPWR VPWR sky130_fd_sc_hd__fill_1
X_05082_ reg_pc\[2\] decoded_imm\[2\] VGND VGND VPWR VPWR _01695_ sky130_fd_sc_hd__or2_1
X_09890_ cpuregs\[0\]\[20\] VGND VGND VPWR VPWR _01498_ sky130_fd_sc_hd__clkbuf_1
X_08910_ _04578_ _04579_ _01558_ VGND VGND VPWR VPWR _04589_ sky130_fd_sc_hd__mux2_1
X_08841_ net213 _01585_ _04522_ _04523_ VGND VGND VPWR VPWR _00825_ sky130_fd_sc_hd__o22a_1
XFILLER_111_263 VGND VGND VPWR VPWR sky130_fd_sc_hd__fill_1
XFILLER_85_615 VGND VGND VPWR VPWR sky130_fd_sc_hd__fill_1
X_08772_ cpuregs\[20\]\[16\] cpuregs\[21\]\[16\] cpuregs\[22\]\[16\] cpuregs\[23\]\[16\]
+ net276 net272 VGND VGND VPWR VPWR _04458_ sky130_fd_sc_hd__mux4_1
X_05984_ net176 _02495_ _01582_ VGND VGND VPWR VPWR net70 sky130_fd_sc_hd__mux2_2
XFILLER_38_531 VGND VGND VPWR VPWR sky130_fd_sc_hd__fill_1
X_07723_ _03618_ count_instr\[25\] count_instr\[24\] count_instr\[26\] VGND VGND VPWR
+ VPWR _03624_ sky130_fd_sc_hd__and4_1
X_04935_ net195 VGND VGND VPWR VPWR _01568_ sky130_fd_sc_hd__inv_2
XFILLER_72_309 VGND VGND VPWR VPWR sky130_fd_sc_hd__decap_4
XFILLER_93_670 VGND VGND VPWR VPWR sky130_fd_sc_hd__fill_2
XFILLER_53_512 VGND VGND VPWR VPWR sky130_fd_sc_hd__decap_8
XFILLER_53_501 VGND VGND VPWR VPWR sky130_fd_sc_hd__decap_3
X_07654_ count_instr\[1\] _03577_ net34 VGND VGND VPWR VPWR _03580_ sky130_fd_sc_hd__o21ai_1
XTAP_TAPCELL_ROW_0_313 VGND VPWR sky130_fd_sc_hd__tapvpwrvgnd_1
XTAP_TAPCELL_ROW_0_324 VGND VPWR sky130_fd_sc_hd__tapvpwrvgnd_1
XTAP_TAPCELL_ROW_0_335 VGND VPWR sky130_fd_sc_hd__tapvpwrvgnd_1
X_06605_ net173 _02725_ VGND VGND VPWR VPWR _03032_ sky130_fd_sc_hd__and2_1
XFILLER_25_225 VPWR VGND VPWR VGND sky130_ef_sc_hd__decap_12
X_07585_ cpuregs\[20\]\[2\] _02590_ net245 VGND VGND VPWR VPWR _00518_ sky130_fd_sc_hd__mux2_1
XFILLER_41_718 VGND VGND VPWR VPWR sky130_fd_sc_hd__decap_8
XFILLER_41_729 VGND VGND VPWR VPWR sky130_fd_sc_hd__decap_8
X_09324_ is_beq_bne_blt_bge_bltu_bgeu is_sb_sh_sw VGND VGND VPWR VPWR _04822_ sky130_fd_sc_hd__or2_1
XFILLER_40_239 VGND VGND VPWR VPWR sky130_fd_sc_hd__fill_1
X_06536_ _01579_ _02965_ VGND VGND VPWR VPWR _02966_ sky130_fd_sc_hd__or2_1
XFILLER_139_617 VGND VGND VPWR VPWR sky130_fd_sc_hd__decap_3
X_09255_ is_beq_bne_blt_bge_bltu_bgeu _01593_ _04748_ VGND VGND VPWR VPWR _00952_
+ sky130_fd_sc_hd__o21a_1
X_06467_ decoded_imm\[6\] net199 VGND VGND VPWR VPWR _02899_ sky130_fd_sc_hd__nand2_1
XFILLER_138_138 VGND VGND VPWR VPWR sky130_fd_sc_hd__fill_2
X_08206_ _04010_ _04011_ VGND VGND VPWR VPWR _04012_ sky130_fd_sc_hd__and2_1
X_05418_ _01961_ _02001_ _02004_ VGND VGND VPWR VPWR _02005_ sky130_fd_sc_hd__o21a_1
XFILLER_107_503 VGND VGND VPWR VPWR sky130_fd_sc_hd__fill_1
X_09186_ mem_rdata_q\[29\] net22 _01609_ VGND VGND VPWR VPWR _01123_ sky130_fd_sc_hd__mux2_1
X_06398_ _02829_ _02830_ _02831_ net258 VGND VGND VPWR VPWR _02833_ sky130_fd_sc_hd__a22o_1
X_08137_ _03708_ _03933_ instr_jal VGND VGND VPWR VPWR _03949_ sky130_fd_sc_hd__a21oi_1
X_05349_ _01936_ _01940_ _01941_ VGND VGND VPWR VPWR _04892_ sky130_fd_sc_hd__or3_1
XFILLER_135_889 VGND VGND VPWR VPWR sky130_fd_sc_hd__decap_6
XFILLER_107_569 VGND VGND VPWR VPWR sky130_fd_sc_hd__decap_3
X_08068_ _03702_ _03703_ _03862_ VGND VGND VPWR VPWR _03885_ sky130_fd_sc_hd__and3_1
XTAP_TAPCELL_ROW_56_1228 VGND VPWR sky130_fd_sc_hd__tapvpwrvgnd_1
XFILLER_150_837 VPWR VGND VPWR VGND sky130_ef_sc_hd__decap_12
Xpicorv32_380 VGND VGND VPWR VPWR picorv32_380/HI trace_data[30] sky130_fd_sc_hd__conb_1
XFILLER_134_388 VGND VGND VPWR VPWR sky130_fd_sc_hd__decap_6
XFILLER_103_720 VGND VGND VPWR VPWR sky130_fd_sc_hd__decap_8
X_07019_ _03425_ _03426_ _03430_ VGND VGND VPWR VPWR _03431_ sky130_fd_sc_hd__o21ai_1
X_10030_ clknet_leaf_41_clk _00160_ VGND VGND VPWR VPWR cpuregs\[30\]\[28\] sky130_fd_sc_hd__dfxtp_1
XFILLER_115_580 VGND VGND VPWR VPWR sky130_fd_sc_hd__fill_1
XTAP_TAPCELL_ROW_8_457 VGND VPWR sky130_fd_sc_hd__tapvpwrvgnd_1
XFILLER_88_464 VPWR VGND VPWR VGND sky130_ef_sc_hd__decap_12
XFILLER_76_626 VPWR VGND VPWR VGND sky130_ef_sc_hd__decap_12
XFILLER_0_357 VGND VGND VPWR VPWR sky130_fd_sc_hd__decap_3
XFILLER_124_53 VPWR VGND VPWR VGND sky130_ef_sc_hd__decap_12
XFILLER_102_296 VGND VGND VPWR VPWR sky130_fd_sc_hd__decap_3
XFILLER_102_274 VGND VGND VPWR VPWR sky130_fd_sc_hd__decap_4
XFILLER_90_106 VGND VGND VPWR VPWR sky130_fd_sc_hd__decap_8
XFILLER_56_383 VGND VGND VPWR VPWR sky130_fd_sc_hd__fill_1
X_10932_ clknet_leaf_112_clk _00994_ VGND VGND VPWR VPWR latched_rd\[2\] sky130_fd_sc_hd__dfxtp_4
XFILLER_44_501 VPWR VGND VPWR VGND sky130_ef_sc_hd__decap_12
XFILLER_140_41 VPWR VGND VPWR VGND sky130_ef_sc_hd__decap_12
XFILLER_83_180 VGND VGND VPWR VPWR sky130_fd_sc_hd__decap_3
XFILLER_72_854 VGND VGND VPWR VPWR sky130_fd_sc_hd__fill_1
XFILLER_16_225 VPWR VGND VPWR VGND sky130_ef_sc_hd__decap_12
XFILLER_17_51 VGND VGND VPWR VPWR sky130_fd_sc_hd__decap_4
XFILLER_140_85 VGND VGND VPWR VPWR sky130_fd_sc_hd__decap_4
XTAP_TAPCELL_ROW_84_1671 VGND VPWR sky130_fd_sc_hd__tapvpwrvgnd_1
X_10863_ clknet_leaf_144_clk _00925_ VGND VGND VPWR VPWR cpuregs\[1\]\[7\] sky130_fd_sc_hd__dfxtp_1
XTAP_TAPCELL_ROW_27_765 VGND VPWR sky130_fd_sc_hd__tapvpwrvgnd_1
XFILLER_44_589 VPWR VGND VPWR VGND sky130_ef_sc_hd__decap_12
XTAP_TAPCELL_ROW_84_1682 VGND VPWR sky130_fd_sc_hd__tapvpwrvgnd_1
X_10794_ clknet_leaf_103_clk _00859_ VGND VGND VPWR VPWR instr_sb sky130_fd_sc_hd__dfxtp_1
XFILLER_24_280 VPWR VGND VPWR VGND sky130_ef_sc_hd__decap_12
XFILLER_25_781 VGND VGND VPWR VPWR sky130_fd_sc_hd__decap_3
XFILLER_40_751 VGND VGND VPWR VPWR sky130_fd_sc_hd__decap_4
XFILLER_129_138 VGND VGND VPWR VPWR sky130_fd_sc_hd__fill_1
XFILLER_12_486 VGND VGND VPWR VPWR sky130_fd_sc_hd__decap_4
XFILLER_145_609 VGND VGND VPWR VPWR sky130_fd_sc_hd__decap_6
XFILLER_138_672 VGND VGND VPWR VPWR sky130_fd_sc_hd__decap_4
X_11415_ clknet_leaf_10_clk _01459_ VGND VGND VPWR VPWR cpuregs\[8\]\[13\] sky130_fd_sc_hd__dfxtp_1
XFILLER_152_141 VPWR VGND VPWR VGND sky130_ef_sc_hd__decap_12
XFILLER_126_867 VGND VGND VPWR VPWR sky130_fd_sc_hd__fill_1
XTAP_TAPCELL_ROW_115_2170 VGND VPWR sky130_fd_sc_hd__tapvpwrvgnd_1
X_11346_ clknet_leaf_136_clk _01390_ VGND VGND VPWR VPWR cpuregs\[6\]\[8\] sky130_fd_sc_hd__dfxtp_1
XFILLER_153_697 VGND VGND VPWR VPWR sky130_fd_sc_hd__decap_3
XFILLER_125_388 VGND VGND VPWR VPWR sky130_fd_sc_hd__decap_4
X_11277_ clknet_leaf_151_clk _01324_ VGND VGND VPWR VPWR cpuregs\[4\]\[6\] sky130_fd_sc_hd__dfxtp_1
XFILLER_79_453 VGND VGND VPWR VPWR sky130_fd_sc_hd__decap_3
X_10228_ clknet_leaf_120_clk _00358_ VGND VGND VPWR VPWR cpuregs\[27\]\[2\] sky130_fd_sc_hd__dfxtp_1
X_10159_ clknet_leaf_36_clk _00289_ VGND VGND VPWR VPWR cpuregs\[21\]\[29\] sky130_fd_sc_hd__dfxtp_1
XFILLER_39_328 VGND VGND VPWR VPWR sky130_fd_sc_hd__decap_8
XFILLER_94_456 VGND VGND VPWR VPWR sky130_fd_sc_hd__fill_1
XFILLER_54_309 VPWR VGND VPWR VGND sky130_ef_sc_hd__decap_12
XFILLER_48_862 VGND VGND VPWR VPWR sky130_fd_sc_hd__fill_1
XFILLER_47_383 VGND VGND VPWR VPWR sky130_fd_sc_hd__decap_8
XFILLER_74_191 VGND VGND VPWR VPWR sky130_fd_sc_hd__decap_4
XFILLER_50_504 VPWR VGND VPWR VGND sky130_ef_sc_hd__decap_12
XFILLER_23_729 VGND VGND VPWR VPWR sky130_fd_sc_hd__decap_4
X_07370_ _02670_ cpuregs\[9\]\[21\] _03563_ VGND VGND VPWR VPWR _00313_ sky130_fd_sc_hd__mux2_1
XFILLER_90_695 VGND VGND VPWR VPWR sky130_fd_sc_hd__decap_4
XFILLER_22_217 VGND VGND VPWR VPWR sky130_fd_sc_hd__fill_1
X_06321_ cpuregs\[20\]\[1\] cpuregs\[21\]\[1\] cpuregs\[22\]\[1\] cpuregs\[23\]\[1\]
+ net268 net262 VGND VGND VPWR VPWR _02758_ sky130_fd_sc_hd__mux4_1
X_06252_ _02693_ _02694_ VGND VGND VPWR VPWR _02695_ sky130_fd_sc_hd__nor2_1
X_09040_ decoded_imm\[30\] _01654_ _01586_ VGND VGND VPWR VPWR _04712_ sky130_fd_sc_hd__a21o_1
XFILLER_30_250 VGND VGND VPWR VPWR sky130_fd_sc_hd__fill_2
X_05203_ count_instr\[43\] instr_rdinstrh net257 _01806_ VGND VGND VPWR VPWR _01807_
+ sky130_fd_sc_hd__a211o_1
X_06183_ reg_out\[14\] alu_out_q\[14\] net593 VGND VGND VPWR VPWR _02639_ sky130_fd_sc_hd__mux2_1
XFILLER_117_878 VPWR VGND VPWR VGND sky130_ef_sc_hd__decap_12
X_05134_ _01741_ _01742_ VGND VGND VPWR VPWR _01743_ sky130_fd_sc_hd__nand2_1
XFILLER_132_837 VPWR VGND VPWR VGND sky130_ef_sc_hd__decap_12
XFILLER_116_377 VPWR VGND VPWR VGND sky130_ef_sc_hd__decap_12
X_05065_ net453 net257 _01679_ VGND VGND VPWR VPWR _01680_ sky130_fd_sc_hd__a21oi_1
X_09942_ clknet_leaf_126_clk _00072_ VGND VGND VPWR VPWR net196 sky130_fd_sc_hd__dfxtp_4
XFILLER_98_751 VGND VGND VPWR VPWR sky130_fd_sc_hd__fill_2
XFILLER_100_712 VGND VGND VPWR VPWR sky130_fd_sc_hd__decap_8
XFILLER_98_773 VGND VGND VPWR VPWR sky130_fd_sc_hd__decap_4
X_09873_ cpuregs\[0\]\[3\] VGND VGND VPWR VPWR _01481_ sky130_fd_sc_hd__clkbuf_1
XTAP_TAPCELL_ROW_5_416 VGND VPWR sky130_fd_sc_hd__tapvpwrvgnd_1
XTAP_TAPCELL_ROW_5_405 VGND VPWR sky130_fd_sc_hd__tapvpwrvgnd_1
XFILLER_140_881 VPWR VGND VPWR VGND sky130_ef_sc_hd__decap_12
X_08824_ decoded_imm\[18\] _01654_ _01586_ VGND VGND VPWR VPWR _04508_ sky130_fd_sc_hd__a21o_1
XTAP_TAPCELL_ROW_51_1147 VGND VPWR sky130_fd_sc_hd__tapvpwrvgnd_1
XTAP_TAPCELL_ROW_146_2675 VGND VPWR sky130_fd_sc_hd__tapvpwrvgnd_1
XTAP_TAPCELL_ROW_146_2664 VGND VPWR sky130_fd_sc_hd__tapvpwrvgnd_1
X_08755_ cpuregs\[20\]\[15\] cpuregs\[21\]\[15\] cpuregs\[22\]\[15\] cpuregs\[23\]\[15\]
+ net276 net272 VGND VGND VPWR VPWR _04442_ sky130_fd_sc_hd__mux4_1
XFILLER_57_169 VGND VGND VPWR VPWR sky130_fd_sc_hd__fill_2
XFILLER_57_147 VGND VGND VPWR VPWR sky130_fd_sc_hd__fill_2
X_07706_ count_instr\[20\] _03610_ _03612_ VGND VGND VPWR VPWR _00601_ sky130_fd_sc_hd__o21a_1
XFILLER_72_128 VPWR VGND VPWR VGND sky130_ef_sc_hd__decap_12
XFILLER_72_106 VGND VGND VPWR VPWR sky130_fd_sc_hd__decap_4
XFILLER_66_681 VGND VGND VPWR VPWR sky130_fd_sc_hd__decap_8
X_05967_ reg_out\[6\] reg_next_pc\[6\] net597 VGND VGND VPWR VPWR _02487_ sky130_fd_sc_hd__mux2_1
XFILLER_26_501 VGND VGND VPWR VPWR sky130_fd_sc_hd__decap_8
XFILLER_38_361 VGND VGND VPWR VPWR sky130_fd_sc_hd__decap_3
X_04918_ instr_jal VGND VGND VPWR VPWR _01551_ sky130_fd_sc_hd__inv_6
X_05898_ _02076_ _02447_ _02077_ VGND VGND VPWR VPWR _02452_ sky130_fd_sc_hd__a21bo_1
XFILLER_54_854 VPWR VGND VPWR VGND sky130_ef_sc_hd__decap_12
XFILLER_54_843 VGND VGND VPWR VPWR sky130_fd_sc_hd__fill_1
XFILLER_54_27 VGND VGND VPWR VPWR sky130_fd_sc_hd__fill_1
X_08686_ cpuregs\[0\]\[11\] cpuregs\[1\]\[11\] cpuregs\[2\]\[11\] cpuregs\[3\]\[11\]
+ net279 _00008_ VGND VGND VPWR VPWR _04377_ sky130_fd_sc_hd__mux4_1
XFILLER_38_383 VGND VGND VPWR VPWR sky130_fd_sc_hd__decap_8
X_07637_ _02670_ cpuregs\[17\]\[21\] _03574_ VGND VGND VPWR VPWR _00569_ sky130_fd_sc_hd__mux2_1
XFILLER_80_150 VGND VGND VPWR VPWR sky130_fd_sc_hd__decap_4
XFILLER_54_876 VPWR VGND VPWR VGND sky130_ef_sc_hd__decap_12
X_07568_ cpuregs\[25\]\[19\] _02662_ _03571_ VGND VGND VPWR VPWR _00503_ sky130_fd_sc_hd__mux2_1
XTAP_TAPCELL_ROW_66_1390 VGND VPWR sky130_fd_sc_hd__tapvpwrvgnd_1
XTAP_TAPCELL_ROW_24_713 VGND VPWR sky130_fd_sc_hd__tapvpwrvgnd_1
XFILLER_70_15 VPWR VGND VPWR VGND sky130_ef_sc_hd__decap_12
X_09307_ net132 _04208_ _04813_ _04207_ VGND VGND VPWR VPWR _00990_ sky130_fd_sc_hd__o211a_1
X_06519_ net201 _02725_ VGND VGND VPWR VPWR _02949_ sky130_fd_sc_hd__and2_1
X_07499_ cpuregs\[26\]\[17\] _02654_ _03568_ VGND VGND VPWR VPWR _00437_ sky130_fd_sc_hd__mux2_1
XFILLER_70_59 VGND VGND VPWR VPWR sky130_fd_sc_hd__decap_4
XFILLER_22_784 VPWR VGND VPWR VGND sky130_ef_sc_hd__decap_12
X_09238_ cpuregs\[1\]\[17\] _02654_ net244 VGND VGND VPWR VPWR _00935_ sky130_fd_sc_hd__mux2_1
XFILLER_119_31 VPWR VGND VPWR VGND sky130_ef_sc_hd__decap_12
XFILLER_107_311 VGND VGND VPWR VPWR sky130_fd_sc_hd__fill_1
X_09169_ _04783_ _04785_ instr_rdcycleh _04747_ VGND VGND VPWR VPWR _00882_ sky130_fd_sc_hd__a2bb2o_1
XFILLER_5_405 VPWR VGND VPWR VGND sky130_ef_sc_hd__decap_12
X_11200_ clknet_leaf_50_clk _01247_ VGND VGND VPWR VPWR cpuregs\[29\]\[25\] sky130_fd_sc_hd__dfxtp_1
XFILLER_107_333 VGND VGND VPWR VPWR sky130_fd_sc_hd__decap_3
XFILLER_79_35 VPWR VGND VPWR VGND sky130_ef_sc_hd__decap_12
XFILLER_5_449 VPWR VGND VPWR VGND sky130_ef_sc_hd__decap_12
XFILLER_150_601 VGND VGND VPWR VPWR sky130_fd_sc_hd__fill_2
X_11131_ clknet_leaf_73_clk _01178_ VGND VGND VPWR VPWR cpuregs\[31\]\[20\] sky130_fd_sc_hd__dfxtp_1
XFILLER_107_388 VGND VGND VPWR VPWR sky130_fd_sc_hd__decap_4
XFILLER_102_3 VGND VGND VPWR VPWR sky130_fd_sc_hd__decap_3
XFILLER_79_57 VGND VGND VPWR VPWR sky130_fd_sc_hd__decap_6
XFILLER_107_399 VGND VGND VPWR VPWR sky130_fd_sc_hd__decap_6
XFILLER_1_633 VPWR VGND VPWR VGND sky130_ef_sc_hd__decap_12
XFILLER_150_678 VGND VGND VPWR VPWR sky130_fd_sc_hd__decap_6
XFILLER_103_561 VGND VGND VPWR VPWR sky130_fd_sc_hd__decap_8
XFILLER_95_23 VPWR VGND VPWR VGND sky130_ef_sc_hd__decap_12
X_11062_ clknet_leaf_100_clk _01119_ VGND VGND VPWR VPWR mem_rdata_q\[25\] sky130_fd_sc_hd__dfxtp_1
XFILLER_76_434 VGND VGND VPWR VPWR sky130_fd_sc_hd__decap_8
X_10013_ clknet_leaf_148_clk _00143_ VGND VGND VPWR VPWR cpuregs\[30\]\[11\] sky130_fd_sc_hd__dfxtp_1
XFILLER_0_165 VGND VGND VPWR VPWR sky130_fd_sc_hd__decap_3
XFILLER_151_51 VGND VGND VPWR VPWR sky130_fd_sc_hd__decap_4
XTAP_TAPCELL_ROW_86_1711 VGND VPWR sky130_fd_sc_hd__tapvpwrvgnd_1
XTAP_TAPCELL_ROW_86_1700 VGND VPWR sky130_fd_sc_hd__tapvpwrvgnd_1
XFILLER_57_670 VGND VGND VPWR VPWR sky130_fd_sc_hd__fill_2
XFILLER_17_501 VGND VGND VPWR VPWR sky130_fd_sc_hd__decap_3
XFILLER_28_61 VGND VGND VPWR VPWR sky130_fd_sc_hd__decap_3
XFILLER_29_361 VGND VGND VPWR VPWR sky130_fd_sc_hd__decap_4
XFILLER_56_191 VGND VGND VPWR VPWR sky130_fd_sc_hd__decap_4
X_10915_ clknet_leaf_31_clk _00977_ VGND VGND VPWR VPWR net148 sky130_fd_sc_hd__dfxtp_1
XFILLER_32_526 VGND VGND VPWR VPWR sky130_fd_sc_hd__decap_6
X_10846_ clknet_leaf_111_clk _00911_ VGND VGND VPWR VPWR decoded_imm\[0\] sky130_fd_sc_hd__dfxtp_2
XFILLER_44_71 VPWR VGND VPWR VGND sky130_ef_sc_hd__decap_12
XFILLER_13_740 VPWR VGND VPWR VGND sky130_ef_sc_hd__decap_12
X_10777_ clknet_leaf_58_clk alu_out\[30\] VGND VGND VPWR VPWR alu_out_q\[30\] sky130_fd_sc_hd__dfxtp_1
XPHY_EDGE_ROW_4_Left_158 VGND VGND VPWR VPWR sky130_fd_sc_hd__decap_3
XFILLER_145_417 VGND VGND VPWR VPWR sky130_fd_sc_hd__fill_1
XTAP_TAPCELL_ROW_117_2210 VGND VPWR sky130_fd_sc_hd__tapvpwrvgnd_1
XFILLER_12_283 VGND VGND VPWR VPWR sky130_fd_sc_hd__fill_1
XTAP_TAPCELL_ROW_130_2410 VGND VPWR sky130_fd_sc_hd__tapvpwrvgnd_1
XFILLER_126_642 VGND VGND VPWR VPWR sky130_fd_sc_hd__fill_2
XTAP_TAPCELL_ROW_97_1884 VGND VPWR sky130_fd_sc_hd__tapvpwrvgnd_1
XTAP_TAPCELL_ROW_10_495 VGND VPWR sky130_fd_sc_hd__tapvpwrvgnd_1
XTAP_TAPCELL_ROW_10_484 VGND VPWR sky130_fd_sc_hd__tapvpwrvgnd_1
X_11329_ clknet_leaf_44_clk _01376_ VGND VGND VPWR VPWR cpuregs\[5\]\[26\] sky130_fd_sc_hd__dfxtp_1
XFILLER_114_859 VGND VGND VPWR VPWR sky130_fd_sc_hd__decap_8
X_06870_ cpuregs\[8\]\[20\] cpuregs\[9\]\[20\] cpuregs\[10\]\[20\] cpuregs\[11\]\[20\]
+ net267 _00013_ VGND VGND VPWR VPWR _03288_ sky130_fd_sc_hd__mux4_1
XFILLER_122_881 VPWR VGND VPWR VGND sky130_ef_sc_hd__decap_12
XTAP_TAPCELL_ROW_128_2372 VGND VPWR sky130_fd_sc_hd__tapvpwrvgnd_1
X_05821_ _02092_ _02383_ VGND VGND VPWR VPWR _02384_ sky130_fd_sc_hd__or2_1
XFILLER_94_253 VGND VGND VPWR VPWR sky130_fd_sc_hd__decap_4
XTAP_TAPCELL_ROW_128_2383 VGND VPWR sky130_fd_sc_hd__tapvpwrvgnd_1
XFILLER_94_286 VGND VGND VPWR VPWR sky130_fd_sc_hd__decap_6
XFILLER_39_169 VGND VGND VPWR VPWR sky130_fd_sc_hd__decap_3
XFILLER_82_459 VGND VGND VPWR VPWR sky130_fd_sc_hd__decap_3
X_05752_ _02241_ _02319_ _02320_ _02322_ VGND VGND VPWR VPWR alu_out\[12\] sky130_fd_sc_hd__a31o_1
X_08540_ cpuregs\[4\]\[1\] cpuregs\[5\]\[1\] cpuregs\[6\]\[1\] cpuregs\[7\]\[1\] net279
+ _00008_ VGND VGND VPWR VPWR _04241_ sky130_fd_sc_hd__mux4_1
XFILLER_35_331 VGND VGND VPWR VPWR sky130_fd_sc_hd__decap_4
XTAP_TAPCELL_ROW_141_2583 VGND VPWR sky130_fd_sc_hd__tapvpwrvgnd_1
XFILLER_51_813 VPWR VGND VPWR VGND sky130_ef_sc_hd__decap_12
X_08471_ net235 net96 VGND VGND VPWR VPWR _04207_ sky130_fd_sc_hd__nand2b_2
X_05683_ _02125_ _02238_ _02258_ _02262_ VGND VGND VPWR VPWR alu_out\[3\] sky130_fd_sc_hd__a211o_1
XTAP_TAPCELL_ROW_141_2594 VGND VPWR sky130_fd_sc_hd__tapvpwrvgnd_1
XFILLER_23_537 VGND VGND VPWR VPWR sky130_fd_sc_hd__fill_2
X_07422_ cpuregs\[27\]\[6\] _02607_ _03566_ VGND VGND VPWR VPWR _00362_ sky130_fd_sc_hd__mux2_1
XFILLER_62_194 VGND VGND VPWR VPWR sky130_fd_sc_hd__fill_2
XFILLER_50_334 VGND VGND VPWR VPWR sky130_fd_sc_hd__decap_4
XFILLER_10_209 VGND VGND VPWR VPWR sky130_fd_sc_hd__fill_1
X_07353_ _02598_ cpuregs\[9\]\[4\] _03563_ VGND VGND VPWR VPWR _00296_ sky130_fd_sc_hd__mux2_1
X_07284_ cpuregs\[28\]\[2\] _02590_ net249 VGND VGND VPWR VPWR _00230_ sky130_fd_sc_hd__mux2_1
X_06304_ _02740_ _02741_ net258 VGND VGND VPWR VPWR _02742_ sky130_fd_sc_hd__mux2_1
X_06235_ reg_pc\[24\] reg_pc\[23\] _02673_ VGND VGND VPWR VPWR _02681_ sky130_fd_sc_hd__and3_1
X_09023_ _04694_ _04695_ _04266_ _04692_ VGND VGND VPWR VPWR _04696_ sky130_fd_sc_hd__o211a_1
XFILLER_40_29 VPWR VGND VPWR VGND sky130_ef_sc_hd__decap_12
XFILLER_3_909 VGND VGND VPWR VPWR sky130_fd_sc_hd__decap_3
XFILLER_144_461 VPWR VGND VPWR VGND sky130_ef_sc_hd__decap_12
XFILLER_116_163 VGND VGND VPWR VPWR sky130_fd_sc_hd__fill_1
XFILLER_116_141 VGND VGND VPWR VPWR sky130_fd_sc_hd__fill_1
XFILLER_105_837 VGND VGND VPWR VPWR sky130_fd_sc_hd__decap_3
X_06166_ reg_out\[11\] alu_out_q\[11\] net591 VGND VGND VPWR VPWR _02625_ sky130_fd_sc_hd__mux2_1
XFILLER_2_419 VGND VGND VPWR VPWR sky130_fd_sc_hd__fill_1
XTAP_TAPCELL_ROW_148_2704 VGND VPWR sky130_fd_sc_hd__tapvpwrvgnd_1
XFILLER_132_645 VPWR VGND VPWR VGND sky130_ef_sc_hd__decap_12
X_06097_ cpuregs\[20\]\[4\] cpuregs\[21\]\[4\] cpuregs\[22\]\[4\] cpuregs\[23\]\[4\]
+ net278 net273 VGND VGND VPWR VPWR _02568_ sky130_fd_sc_hd__mux4_1
X_05117_ cpu_state\[4\] net197 _01724_ cpu_state\[6\] VGND VGND VPWR VPWR _01728_
+ sky130_fd_sc_hd__a22o_1
X_09925_ clknet_leaf_49_clk _00060_ VGND VGND VPWR VPWR cpuregs\[11\]\[23\] sky130_fd_sc_hd__dfxtp_1
XFILLER_104_358 VGND VGND VPWR VPWR sky130_fd_sc_hd__decap_6
X_05048_ cpu_state\[6\] _01633_ _01648_ _01649_ _01664_ VGND VGND VPWR VPWR _00023_
+ sky130_fd_sc_hd__a32o_1
XFILLER_131_188 VGND VGND VPWR VPWR sky130_fd_sc_hd__decap_8
XFILLER_105_11 VPWR VGND VPWR VGND sky130_ef_sc_hd__decap_12
XFILLER_98_592 VGND VGND VPWR VPWR sky130_fd_sc_hd__decap_3
X_09856_ _02709_ cpuregs\[10\]\[30\] _04876_ VGND VGND VPWR VPWR _01540_ sky130_fd_sc_hd__mux2_1
X_08807_ cpuregs\[20\]\[18\] cpuregs\[21\]\[18\] cpuregs\[22\]\[18\] cpuregs\[23\]\[18\]
+ net277 net272 VGND VGND VPWR VPWR _04491_ sky130_fd_sc_hd__mux4_1
XFILLER_105_55 VGND VGND VPWR VPWR sky130_fd_sc_hd__fill_1
XFILLER_65_15 VPWR VGND VPWR VGND sky130_ef_sc_hd__decap_12
X_06999_ cpuregs\[8\]\[25\] cpuregs\[9\]\[25\] cpuregs\[10\]\[25\] cpuregs\[11\]\[25\]
+ net267 net261 VGND VGND VPWR VPWR _03412_ sky130_fd_sc_hd__mux4_1
X_09787_ _02696_ cpuregs\[7\]\[27\] _04874_ VGND VGND VPWR VPWR _01441_ sky130_fd_sc_hd__mux2_1
XFILLER_73_426 VGND VGND VPWR VPWR sky130_fd_sc_hd__decap_4
XFILLER_73_404 VGND VGND VPWR VPWR sky130_fd_sc_hd__fill_1
XFILLER_18_309 VGND VGND VPWR VPWR sky130_fd_sc_hd__decap_4
XFILLER_27_821 VPWR VGND VPWR VGND sky130_ef_sc_hd__decap_12
X_08738_ cpuregs\[4\]\[14\] cpuregs\[5\]\[14\] cpuregs\[6\]\[14\] cpuregs\[7\]\[14\]
+ net277 net271 VGND VGND VPWR VPWR _04426_ sky130_fd_sc_hd__mux4_1
XFILLER_26_331 VGND VGND VPWR VPWR sky130_fd_sc_hd__fill_1
XFILLER_121_43 VGND VGND VPWR VPWR sky130_fd_sc_hd__decap_4
X_08669_ _01558_ _04360_ VGND VGND VPWR VPWR _04361_ sky130_fd_sc_hd__or2_1
XFILLER_27_865 VPWR VGND VPWR VGND sky130_ef_sc_hd__decap_12
X_10700_ clknet_leaf_47_clk _00798_ VGND VGND VPWR VPWR net53 sky130_fd_sc_hd__dfxtp_1
XTAP_TAPCELL_ROW_64_1349 VGND VPWR sky130_fd_sc_hd__tapvpwrvgnd_1
XFILLER_54_695 VGND VGND VPWR VPWR sky130_fd_sc_hd__decap_4
XTAP_TAPCELL_ROW_81_1630 VGND VPWR sky130_fd_sc_hd__tapvpwrvgnd_1
XFILLER_139_233 VGND VGND VPWR VPWR sky130_fd_sc_hd__fill_2
X_10631_ clknet_leaf_83_clk _00761_ VGND VGND VPWR VPWR count_cycle\[54\] sky130_fd_sc_hd__dfxtp_1
XFILLER_14_41 VPWR VGND VPWR VGND sky130_ef_sc_hd__decap_12
X_10562_ clknet_leaf_89_clk _00692_ VGND VGND VPWR VPWR reg_next_pc\[17\] sky130_fd_sc_hd__dfxtp_1
XFILLER_14_85 VGND VGND VPWR VPWR sky130_fd_sc_hd__decap_6
XFILLER_22_581 VGND VGND VPWR VPWR sky130_fd_sc_hd__decap_6
XFILLER_6_725 VGND VGND VPWR VPWR sky130_fd_sc_hd__fill_1
X_10493_ clknet_leaf_104_clk _00623_ VGND VGND VPWR VPWR count_instr\[42\] sky130_fd_sc_hd__dfxtp_1
XFILLER_6_769 VPWR VGND VPWR VGND sky130_ef_sc_hd__decap_12
XTAP_TAPCELL_ROW_79_1592 VGND VPWR sky130_fd_sc_hd__tapvpwrvgnd_1
XFILLER_135_483 VPWR VGND VPWR VGND sky130_ef_sc_hd__decap_12
XFILLER_123_645 VGND VGND VPWR VPWR sky130_fd_sc_hd__fill_1
XFILLER_96_518 VPWR VGND VPWR VGND sky130_ef_sc_hd__decap_12
X_11114_ clknet_leaf_123_clk _01161_ VGND VGND VPWR VPWR cpuregs\[31\]\[3\] sky130_fd_sc_hd__dfxtp_1
XFILLER_49_401 VGND VGND VPWR VPWR sky130_fd_sc_hd__fill_2
X_11045_ clknet_leaf_111_clk _01102_ VGND VGND VPWR VPWR mem_rdata_q\[8\] sky130_fd_sc_hd__dfxtp_1
XFILLER_76_253 VGND VGND VPWR VPWR sky130_fd_sc_hd__decap_4
XFILLER_92_757 VPWR VGND VPWR VGND sky130_ef_sc_hd__decap_12
XFILLER_91_223 VGND VGND VPWR VPWR sky130_fd_sc_hd__fill_1
XFILLER_64_459 VGND VGND VPWR VPWR sky130_fd_sc_hd__fill_2
XFILLER_36_139 VGND VGND VPWR VPWR sky130_fd_sc_hd__fill_1
XFILLER_17_353 VGND VGND VPWR VPWR sky130_fd_sc_hd__fill_1
XFILLER_45_673 VGND VGND VPWR VPWR sky130_fd_sc_hd__decap_4
XFILLER_44_183 VGND VGND VPWR VPWR sky130_fd_sc_hd__decap_8
X_10829_ clknet_leaf_88_clk _00894_ VGND VGND VPWR VPWR decoded_imm_j\[13\] sky130_fd_sc_hd__dfxtp_1
XTAP_TAPCELL_ROW_15_565 VGND VPWR sky130_fd_sc_hd__tapvpwrvgnd_1
XTAP_TAPCELL_ROW_15_576 VGND VPWR sky130_fd_sc_hd__tapvpwrvgnd_1
XTAP_TAPCELL_ROW_99_1913 VGND VPWR sky130_fd_sc_hd__tapvpwrvgnd_1
XFILLER_65_3 VGND VGND VPWR VPWR sky130_fd_sc_hd__decap_3
X_06020_ _01546_ _01613_ VGND VGND VPWR VPWR _02514_ sky130_fd_sc_hd__or2_4
XFILLER_114_612 VPWR VGND VPWR VGND sky130_ef_sc_hd__decap_12
XFILLER_114_601 VGND VGND VPWR VPWR sky130_fd_sc_hd__decap_4
XFILLER_99_345 VPWR VGND VPWR VGND sky130_ef_sc_hd__decap_12
XFILLER_114_656 VGND VGND VPWR VPWR sky130_fd_sc_hd__decap_4
X_07971_ _03794_ _03795_ net34 VGND VGND VPWR VPWR _00683_ sky130_fd_sc_hd__o21a_1
X_06922_ _03332_ _03333_ _03334_ _03335_ _01579_ _01581_ VGND VGND VPWR VPWR _03338_
+ sky130_fd_sc_hd__mux4_1
XFILLER_101_328 VGND VGND VPWR VPWR sky130_fd_sc_hd__decap_8
X_09710_ _02649_ cpuregs\[5\]\[16\] _04872_ VGND VGND VPWR VPWR _01366_ sky130_fd_sc_hd__mux2_1
XFILLER_68_743 VPWR VGND VPWR VGND sky130_ef_sc_hd__decap_12
XTAP_TAPCELL_ROW_143_2623 VGND VPWR sky130_fd_sc_hd__tapvpwrvgnd_1
XTAP_TAPCELL_ROW_143_2612 VGND VPWR sky130_fd_sc_hd__tapvpwrvgnd_1
X_06853_ decoded_imm\[20\] net183 VGND VGND VPWR VPWR _03271_ sky130_fd_sc_hd__nand2_1
XFILLER_95_573 VPWR VGND VPWR VGND sky130_ef_sc_hd__decap_12
X_09641_ _02641_ cpuregs\[22\]\[14\] _04869_ VGND VGND VPWR VPWR _01300_ sky130_fd_sc_hd__mux2_1
X_05804_ _02105_ _02368_ _02238_ _02103_ VGND VGND VPWR VPWR _02369_ sky130_fd_sc_hd__a2bb2o_1
X_06784_ cpuregs\[8\]\[17\] cpuregs\[9\]\[17\] cpuregs\[10\]\[17\] cpuregs\[11\]\[17\]
+ net265 net260 VGND VGND VPWR VPWR _03205_ sky130_fd_sc_hd__mux4_1
XFILLER_83_746 VGND VGND VPWR VPWR sky130_fd_sc_hd__decap_8
X_09572_ cpuregs\[29\]\[11\] _02630_ net239 VGND VGND VPWR VPWR _01233_ sky130_fd_sc_hd__mux2_1
X_05735_ _02123_ _02300_ _02122_ VGND VGND VPWR VPWR _02307_ sky130_fd_sc_hd__o21a_1
XFILLER_24_813 VPWR VGND VPWR VGND sky130_ef_sc_hd__decap_12
X_08523_ cpuregs\[8\]\[0\] cpuregs\[9\]\[0\] cpuregs\[10\]\[0\] cpuregs\[11\]\[0\]
+ net279 net273 VGND VGND VPWR VPWR _04225_ sky130_fd_sc_hd__mux4_1
XFILLER_36_695 VGND VGND VPWR VPWR sky130_fd_sc_hd__decap_4
X_08454_ net260 _04190_ VGND VGND VPWR VPWR _04191_ sky130_fd_sc_hd__or2_1
X_05666_ _02180_ _02247_ VGND VGND VPWR VPWR _02248_ sky130_fd_sc_hd__or2_1
XTAP_TAPCELL_ROW_46_1068 VGND VPWR sky130_fd_sc_hd__tapvpwrvgnd_1
X_07405_ cpuregs\[14\]\[23\] _02678_ net247 VGND VGND VPWR VPWR _00347_ sky130_fd_sc_hd__mux2_1
X_08385_ count_cycle\[46\] _04138_ net34 VGND VGND VPWR VPWR _04140_ sky130_fd_sc_hd__o21ai_1
X_05597_ _01553_ net97 _02143_ VGND VGND VPWR VPWR _02180_ sky130_fd_sc_hd__a21oi_1
XFILLER_11_529 VGND VGND VPWR VPWR sky130_fd_sc_hd__decap_3
XTAP_TAPCELL_ROW_34_874 VGND VPWR sky130_fd_sc_hd__tapvpwrvgnd_1
X_07336_ cpuregs\[21\]\[20\] _02665_ _03562_ VGND VGND VPWR VPWR _00280_ sky130_fd_sc_hd__mux2_1
XFILLER_50_197 VGND VGND VPWR VPWR sky130_fd_sc_hd__decap_3
X_09006_ net223 _01585_ _04678_ _04679_ VGND VGND VPWR VPWR _00834_ sky130_fd_sc_hd__o22a_1
X_07267_ cpuregs\[2\]\[18\] _02657_ net250 VGND VGND VPWR VPWR _00214_ sky130_fd_sc_hd__mux2_1
XFILLER_152_729 VPWR VGND VPWR VGND sky130_ef_sc_hd__decap_12
XFILLER_151_217 VGND VGND VPWR VPWR sky130_fd_sc_hd__decap_6
XFILLER_117_461 VGND VGND VPWR VPWR sky130_fd_sc_hd__decap_4
X_06218_ reg_pc\[20\] _02660_ reg_pc\[21\] VGND VGND VPWR VPWR _02667_ sky130_fd_sc_hd__a21oi_1
X_07198_ cpuregs\[30\]\[16\] _02649_ net252 VGND VGND VPWR VPWR _00148_ sky130_fd_sc_hd__mux2_1
X_06149_ _02583_ _02608_ _02609_ _02611_ VGND VGND VPWR VPWR _02612_ sky130_fd_sc_hd__a22o_4
XFILLER_78_507 VGND VGND VPWR VPWR sky130_fd_sc_hd__decap_4
XFILLER_86_540 VGND VGND VPWR VPWR sky130_fd_sc_hd__fill_2
XFILLER_76_25 VGND VGND VPWR VPWR sky130_fd_sc_hd__decap_3
X_09908_ clknet_leaf_3_clk _00043_ VGND VGND VPWR VPWR cpuregs\[11\]\[6\] sky130_fd_sc_hd__dfxtp_1
XFILLER_86_584 VGND VGND VPWR VPWR sky130_fd_sc_hd__decap_4
X_09839_ _02638_ cpuregs\[10\]\[13\] _04876_ VGND VGND VPWR VPWR _01523_ sky130_fd_sc_hd__mux2_1
XFILLER_132_53 VPWR VGND VPWR VGND sky130_ef_sc_hd__decap_12
XFILLER_74_757 VPWR VGND VPWR VGND sky130_ef_sc_hd__decap_12
XPHY_EDGE_ROW_85_Left_239 VGND VGND VPWR VPWR sky130_fd_sc_hd__decap_3
XFILLER_73_245 VGND VGND VPWR VPWR sky130_fd_sc_hd__decap_6
XFILLER_61_418 VPWR VGND VPWR VGND sky130_ef_sc_hd__decap_12
XFILLER_132_97 VGND VGND VPWR VPWR sky130_fd_sc_hd__decap_4
XFILLER_25_51 VGND VGND VPWR VPWR sky130_fd_sc_hd__decap_4
XFILLER_26_194 VGND VGND VPWR VPWR sky130_fd_sc_hd__fill_2
XPHY_EDGE_ROW_153_Right_153 VGND VGND VPWR VPWR sky130_fd_sc_hd__decap_3
X_10614_ clknet_leaf_108_clk _00744_ VGND VGND VPWR VPWR count_cycle\[37\] sky130_fd_sc_hd__dfxtp_1
XTAP_TAPCELL_ROW_12_524 VGND VPWR sky130_fd_sc_hd__tapvpwrvgnd_1
XFILLER_30_849 VPWR VGND VPWR VGND sky130_ef_sc_hd__decap_12
XFILLER_6_500 VGND VGND VPWR VPWR sky130_fd_sc_hd__decap_8
XFILLER_127_225 VGND VGND VPWR VPWR sky130_fd_sc_hd__fill_1
X_10545_ clknet_leaf_59_clk _00675_ VGND VGND VPWR VPWR reg_pc\[31\] sky130_fd_sc_hd__dfxtp_1
XFILLER_6_533 VGND VGND VPWR VPWR sky130_fd_sc_hd__decap_3
Xclkbuf_leaf_130_clk clknet_4_9_0_clk VGND VGND VPWR VPWR clknet_leaf_130_clk sky130_fd_sc_hd__clkbuf_8
X_10476_ clknet_leaf_82_clk _00606_ VGND VGND VPWR VPWR count_instr\[25\] sky130_fd_sc_hd__dfxtp_1
XTAP_TAPCELL_ROW_94_1843 VGND VPWR sky130_fd_sc_hd__tapvpwrvgnd_1
XTAP_TAPCELL_ROW_94_1832 VGND VPWR sky130_fd_sc_hd__tapvpwrvgnd_1
XPHY_EDGE_ROW_94_Left_248 VGND VGND VPWR VPWR sky130_fd_sc_hd__decap_3
Xrebuffer192 net579 VGND VGND VPWR VPWR net578 sky130_fd_sc_hd__dlygate4sd1_1
Xrebuffer181 net568 VGND VGND VPWR VPWR net567 sky130_fd_sc_hd__clkbuf_2
XFILLER_150_294 VPWR VGND VPWR VGND sky130_ef_sc_hd__decap_12
XFILLER_96_359 VGND VGND VPWR VPWR sky130_fd_sc_hd__decap_4
XFILLER_1_293 VPWR VGND VPWR VGND sky130_ef_sc_hd__decap_12
X_11028_ clknet_leaf_39_clk _01090_ VGND VGND VPWR VPWR cpuregs\[19\]\[28\] sky130_fd_sc_hd__dfxtp_1
XFILLER_77_573 VGND VGND VPWR VPWR sky130_fd_sc_hd__decap_8
XFILLER_2_77 VGND VGND VPWR VPWR sky130_fd_sc_hd__decap_6
XTAP_TAPCELL_ROW_125_2331 VGND VPWR sky130_fd_sc_hd__tapvpwrvgnd_1
XFILLER_65_746 VPWR VGND VPWR VGND sky130_ef_sc_hd__decap_12
XFILLER_49_297 VGND VGND VPWR VPWR sky130_fd_sc_hd__fill_1
XFILLER_73_790 VPWR VGND VPWR VGND sky130_ef_sc_hd__decap_12
XFILLER_17_161 VGND VGND VPWR VPWR sky130_fd_sc_hd__decap_6
XFILLER_18_695 VGND VGND VPWR VPWR sky130_fd_sc_hd__decap_4
XFILLER_33_621 VPWR VGND VPWR VGND sky130_ef_sc_hd__decap_12
X_05520_ net180 net212 VGND VGND VPWR VPWR _02103_ sky130_fd_sc_hd__and2_1
XFILLER_32_131 VGND VGND VPWR VPWR sky130_fd_sc_hd__decap_8
XTAP_TAPCELL_ROW_103_1972 VGND VPWR sky130_fd_sc_hd__tapvpwrvgnd_1
X_05451_ count_cycle\[30\] _01588_ _01674_ _02035_ VGND VGND VPWR VPWR _02036_ sky130_fd_sc_hd__o211a_1
XANTENNA_38 net187 VGND VGND VPWR VPWR sky130_fd_sc_hd__diode_2
X_08170_ _03710_ _03959_ _03711_ VGND VGND VPWR VPWR _03979_ sky130_fd_sc_hd__a21oi_1
XPHY_EDGE_ROW_120_Right_120 VGND VGND VPWR VPWR sky130_fd_sc_hd__decap_3
XANTENNA_27 net217 VGND VGND VPWR VPWR sky130_fd_sc_hd__diode_2
XTAP_TAPCELL_ROW_103_1983 VGND VPWR sky130_fd_sc_hd__tapvpwrvgnd_1
XANTENNA_16 net19 VGND VGND VPWR VPWR sky130_fd_sc_hd__diode_2
XFILLER_20_337 VGND VGND VPWR VPWR sky130_fd_sc_hd__fill_2
XTAP_TAPCELL_ROW_31_822 VGND VPWR sky130_fd_sc_hd__tapvpwrvgnd_1
XTAP_TAPCELL_ROW_31_833 VGND VPWR sky130_fd_sc_hd__tapvpwrvgnd_1
XFILLER_32_197 VGND VGND VPWR VPWR sky130_fd_sc_hd__decap_6
X_05382_ _01959_ _01961_ _01971_ VGND VGND VPWR VPWR _01972_ sky130_fd_sc_hd__nand3_1
X_07121_ _03502_ _03527_ _03526_ _03525_ VGND VGND VPWR VPWR _03529_ sky130_fd_sc_hd__o211ai_2
XFILLER_146_545 VGND VGND VPWR VPWR sky130_fd_sc_hd__decap_4
Xclkbuf_leaf_121_clk clknet_4_8_0_clk VGND VGND VPWR VPWR clknet_leaf_121_clk sky130_fd_sc_hd__clkbuf_8
XFILLER_146_589 VGND VGND VPWR VPWR sky130_fd_sc_hd__decap_4
X_07052_ cpuregs\[24\]\[27\] cpuregs\[25\]\[27\] cpuregs\[26\]\[27\] cpuregs\[27\]\[27\]
+ net266 net261 VGND VGND VPWR VPWR _03463_ sky130_fd_sc_hd__mux4_1
Xoutput101 net101 VGND VGND VPWR VPWR mem_la_wdata[13] sky130_fd_sc_hd__buf_2
X_06003_ reg_out\[24\] reg_next_pc\[24\] net596 VGND VGND VPWR VPWR _02505_ sky130_fd_sc_hd__mux2_1
Xoutput112 net112 VGND VGND VPWR VPWR mem_la_wdata[23] sky130_fd_sc_hd__buf_2
Xoutput134 net134 VGND VGND VPWR VPWR mem_valid sky130_fd_sc_hd__buf_2
Xoutput123 net123 VGND VGND VPWR VPWR mem_la_wdata[4] sky130_fd_sc_hd__buf_2
Xoutput145 net145 VGND VGND VPWR VPWR mem_wdata[19] sky130_fd_sc_hd__buf_2
Xoutput156 net156 VGND VGND VPWR VPWR mem_wdata[29] sky130_fd_sc_hd__buf_2
Xoutput167 net167 VGND VGND VPWR VPWR mem_wstrb[0] sky130_fd_sc_hd__buf_2
Xoutput189 net189 VGND VGND VPWR VPWR pcpi_rs1[26] sky130_fd_sc_hd__buf_2
XFILLER_114_497 VGND VGND VPWR VPWR sky130_fd_sc_hd__decap_4
Xoutput178 net178 VGND VGND VPWR VPWR pcpi_rs1[16] sky130_fd_sc_hd__buf_2
XFILLER_87_348 VGND VGND VPWR VPWR sky130_fd_sc_hd__fill_1
X_07954_ _03694_ _03769_ VGND VGND VPWR VPWR _03780_ sky130_fd_sc_hd__and2_1
XFILLER_29_905 VGND VGND VPWR VPWR sky130_fd_sc_hd__decap_3
X_06905_ _03319_ _03320_ VGND VGND VPWR VPWR _03321_ sky130_fd_sc_hd__and2_1
X_07885_ _03718_ VGND VGND VPWR VPWR _03719_ sky130_fd_sc_hd__inv_2
XFILLER_56_724 VGND VGND VPWR VPWR sky130_fd_sc_hd__decap_8
X_06836_ _01579_ _03254_ VGND VGND VPWR VPWR _03255_ sky130_fd_sc_hd__or2_1
X_09624_ _02709_ cpuregs\[3\]\[30\] _04868_ VGND VGND VPWR VPWR _01284_ sky130_fd_sc_hd__mux2_1
XFILLER_56_757 VGND VGND VPWR VPWR sky130_fd_sc_hd__decap_3
XTAP_TAPCELL_ROW_39_955 VGND VPWR sky130_fd_sc_hd__tapvpwrvgnd_1
X_09555_ cpuregs\[23\]\[27\] _02696_ _04866_ VGND VGND VPWR VPWR _01217_ sky130_fd_sc_hd__mux2_1
X_06767_ _03166_ _03187_ VGND VGND VPWR VPWR _03188_ sky130_fd_sc_hd__nor2_1
XFILLER_83_587 VGND VGND VPWR VPWR sky130_fd_sc_hd__decap_8
X_09486_ cpuregs\[24\]\[24\] _02683_ _04864_ VGND VGND VPWR VPWR _01150_ sky130_fd_sc_hd__mux2_1
X_06698_ _01579_ _03121_ VGND VGND VPWR VPWR _03122_ sky130_fd_sc_hd__or2_1
X_05718_ _02241_ _02289_ _02290_ _02292_ VGND VGND VPWR VPWR alu_out\[8\] sky130_fd_sc_hd__a31o_1
X_08506_ _01585_ _01655_ _02716_ _01624_ _01662_ VGND VGND VPWR VPWR _04211_ sky130_fd_sc_hd__a221o_1
XFILLER_24_643 VGND VGND VPWR VPWR sky130_fd_sc_hd__fill_1
X_08437_ net190 _01639_ _02033_ _02744_ net254 VGND VGND VPWR VPWR _04174_ sky130_fd_sc_hd__o221a_1
X_05649_ _02231_ instr_bge VGND VGND VPWR VPWR _02232_ sky130_fd_sc_hd__and2b_1
XTAP_TAPCELL_ROW_61_1308 VGND VPWR sky130_fd_sc_hd__tapvpwrvgnd_1
XFILLER_12_805 VGND VGND VPWR VPWR sky130_fd_sc_hd__decap_6
XFILLER_8_809 VGND VGND VPWR VPWR sky130_fd_sc_hd__decap_3
XFILLER_12_849 VPWR VGND VPWR VGND sky130_ef_sc_hd__decap_12
XFILLER_149_361 VPWR VGND VPWR VGND sky130_ef_sc_hd__decap_12
X_08368_ count_cycle\[38\] _04124_ count_cycle\[40\] count_cycle\[39\] VGND VGND VPWR
+ VPWR _04129_ sky130_fd_sc_hd__and4_1
X_08299_ net449 _04084_ VGND VGND VPWR VPWR _00722_ sky130_fd_sc_hd__nor2_1
X_07319_ cpuregs\[21\]\[3\] _02593_ net248 VGND VGND VPWR VPWR _00263_ sky130_fd_sc_hd__mux2_1
XFILLER_20_893 VGND VGND VPWR VPWR sky130_fd_sc_hd__decap_3
Xclkbuf_leaf_112_clk clknet_4_10_0_clk VGND VGND VPWR VPWR clknet_leaf_112_clk sky130_fd_sc_hd__clkbuf_8
XFILLER_125_729 VGND VGND VPWR VPWR sky130_fd_sc_hd__fill_1
XFILLER_124_206 VPWR VGND VPWR VGND sky130_ef_sc_hd__decap_12
XFILLER_3_503 VGND VGND VPWR VPWR sky130_fd_sc_hd__fill_1
X_10330_ clknet_leaf_136_clk _00460_ VGND VGND VPWR VPWR cpuregs\[16\]\[8\] sky130_fd_sc_hd__dfxtp_1
XTAP_TAPCELL_ROW_76_1551 VGND VPWR sky130_fd_sc_hd__tapvpwrvgnd_1
XTAP_TAPCELL_ROW_76_1540 VGND VPWR sky130_fd_sc_hd__tapvpwrvgnd_1
X_10261_ clknet_leaf_139_clk _00391_ VGND VGND VPWR VPWR cpuregs\[15\]\[3\] sky130_fd_sc_hd__dfxtp_1
XFILLER_133_762 VGND VGND VPWR VPWR sky130_fd_sc_hd__fill_2
X_10192_ clknet_leaf_33_clk _00322_ VGND VGND VPWR VPWR cpuregs\[9\]\[30\] sky130_fd_sc_hd__dfxtp_1
XFILLER_87_35 VPWR VGND VPWR VGND sky130_ef_sc_hd__decap_12
XFILLER_59_551 VGND VGND VPWR VPWR sky130_fd_sc_hd__fill_2
XFILLER_74_510 VGND VGND VPWR VPWR sky130_fd_sc_hd__decap_4
XTAP_TAPCELL_ROW_107_2050 VGND VPWR sky130_fd_sc_hd__tapvpwrvgnd_1
XFILLER_47_768 VGND VGND VPWR VPWR sky130_fd_sc_hd__fill_1
XTAP_TAPCELL_ROW_17_605 VGND VPWR sky130_fd_sc_hd__tapvpwrvgnd_1
XFILLER_36_83 VGND VGND VPWR VPWR sky130_fd_sc_hd__fill_1
XTAP_TAPCELL_ROW_120_2250 VGND VPWR sky130_fd_sc_hd__tapvpwrvgnd_1
XFILLER_30_657 VGND VGND VPWR VPWR sky130_fd_sc_hd__decap_6
Xinput25 mem_rdata[31] VGND VGND VPWR VPWR net25 sky130_fd_sc_hd__dlymetal6s2s_1
Xclkbuf_leaf_103_clk clknet_4_11_0_clk VGND VGND VPWR VPWR clknet_leaf_103_clk sky130_fd_sc_hd__clkbuf_8
Xinput14 mem_rdata[21] VGND VGND VPWR VPWR net14 sky130_fd_sc_hd__buf_2
X_10528_ clknet_leaf_95_clk _00658_ VGND VGND VPWR VPWR reg_pc\[14\] sky130_fd_sc_hd__dfxtp_1
XFILLER_7_853 VPWR VGND VPWR VGND sky130_ef_sc_hd__decap_12
XFILLER_109_781 VGND VGND VPWR VPWR sky130_fd_sc_hd__decap_3
XFILLER_7_897 VGND VGND VPWR VPWR sky130_fd_sc_hd__decap_8
XFILLER_6_363 VGND VGND VPWR VPWR sky130_fd_sc_hd__fill_1
XFILLER_143_559 VGND VGND VPWR VPWR sky130_fd_sc_hd__fill_1
X_10459_ clknet_leaf_106_clk _00589_ VGND VGND VPWR VPWR count_instr\[8\] sky130_fd_sc_hd__dfxtp_1
XFILLER_151_570 VGND VGND VPWR VPWR sky130_fd_sc_hd__decap_6
XFILLER_123_261 VPWR VGND VPWR VGND sky130_ef_sc_hd__decap_12
XFILLER_28_3 VPWR VGND VPWR VGND sky130_ef_sc_hd__decap_12
XFILLER_38_713 VGND VGND VPWR VPWR sky130_fd_sc_hd__fill_1
X_04951_ mem_state\[0\] mem_state\[1\] VGND VGND VPWR VPWR _01584_ sky130_fd_sc_hd__or2_1
XFILLER_93_841 VGND VGND VPWR VPWR sky130_fd_sc_hd__decap_6
XFILLER_77_381 VGND VGND VPWR VPWR sky130_fd_sc_hd__decap_4
X_07670_ _03585_ count_instr\[6\] count_instr\[5\] count_instr\[7\] VGND VGND VPWR
+ VPWR _03590_ sky130_fd_sc_hd__and4_1
XTAP_TAPCELL_ROW_36_903 VGND VPWR sky130_fd_sc_hd__tapvpwrvgnd_1
XFILLER_37_234 VGND VGND VPWR VPWR sky130_fd_sc_hd__decap_6
XFILLER_80_513 VGND VGND VPWR VPWR sky130_fd_sc_hd__decap_6
X_06621_ _01579_ _03047_ VGND VGND VPWR VPWR _03048_ sky130_fd_sc_hd__or2_1
XTAP_TAPCELL_ROW_36_914 VGND VPWR sky130_fd_sc_hd__tapvpwrvgnd_1
X_09340_ mem_rdata_q\[25\] _01589_ VGND VGND VPWR VPWR _04832_ sky130_fd_sc_hd__and2_1
XFILLER_80_568 VGND VGND VPWR VPWR sky130_fd_sc_hd__fill_1
X_06552_ _02951_ _02978_ VGND VGND VPWR VPWR _02981_ sky130_fd_sc_hd__and2_1
X_05503_ net185 net217 VGND VGND VPWR VPWR _02086_ sky130_fd_sc_hd__and2_1
X_09271_ net146 net108 _04206_ VGND VGND VPWR VPWR _00957_ sky130_fd_sc_hd__mux2_1
XTAP_TAPCELL_ROW_43_1016 VGND VPWR sky130_fd_sc_hd__tapvpwrvgnd_1
XTAP_TAPCELL_ROW_138_2533 VGND VPWR sky130_fd_sc_hd__tapvpwrvgnd_1
X_08222_ _04023_ _04026_ _03576_ VGND VGND VPWR VPWR _04027_ sky130_fd_sc_hd__a21oi_1
XFILLER_33_484 VGND VGND VPWR VPWR sky130_fd_sc_hd__fill_1
X_06483_ cpuregs\[12\]\[6\] cpuregs\[13\]\[6\] cpuregs\[14\]\[6\] cpuregs\[15\]\[6\]
+ net263 net259 VGND VGND VPWR VPWR _02915_ sky130_fd_sc_hd__mux4_1
XTAP_TAPCELL_ROW_43_1027 VGND VPWR sky130_fd_sc_hd__tapvpwrvgnd_1
XFILLER_147_821 VPWR VGND VPWR VGND sky130_ef_sc_hd__decap_12
XTAP_TAPCELL_ROW_138_2544 VGND VPWR sky130_fd_sc_hd__tapvpwrvgnd_1
XFILLER_119_501 VGND VGND VPWR VPWR sky130_fd_sc_hd__decap_3
X_05434_ _02017_ _02018_ VGND VGND VPWR VPWR _02020_ sky130_fd_sc_hd__nand2_1
XFILLER_147_865 VPWR VGND VPWR VGND sky130_ef_sc_hd__decap_12
X_08153_ _03962_ _03963_ net34 VGND VGND VPWR VPWR _00697_ sky130_fd_sc_hd__o21a_1
X_05365_ reg_pc\[22\] decoded_imm\[22\] _01942_ _01944_ _01955_ VGND VGND VPWR VPWR
+ _01956_ sky130_fd_sc_hd__a311o_1
XTAP_TAPCELL_ROW_151_2744 VGND VPWR sky130_fd_sc_hd__tapvpwrvgnd_1
X_07104_ cpuregs\[24\]\[29\] cpuregs\[25\]\[29\] cpuregs\[26\]\[29\] cpuregs\[27\]\[29\]
+ net266 net261 VGND VGND VPWR VPWR _03513_ sky130_fd_sc_hd__mux4_1
X_08084_ _03898_ _03899_ VGND VGND VPWR VPWR _03900_ sky130_fd_sc_hd__and2_1
XTAP_TAPCELL_ROW_151_2755 VGND VPWR sky130_fd_sc_hd__tapvpwrvgnd_1
XFILLER_134_526 VGND VGND VPWR VPWR sky130_fd_sc_hd__decap_6
X_07035_ net237 _03431_ _03446_ _03423_ VGND VGND VPWR VPWR _00095_ sky130_fd_sc_hd__a31o_1
X_05296_ count_instr\[50\] instr_rdinstrh net257 _01892_ VGND VGND VPWR VPWR _01893_
+ sky130_fd_sc_hd__a211o_1
X_08986_ _01558_ _04653_ _04652_ _01560_ VGND VGND VPWR VPWR _04661_ sky130_fd_sc_hd__o211a_1
XFILLER_87_134 VGND VGND VPWR VPWR sky130_fd_sc_hd__decap_6
XFILLER_76_808 VGND VGND VPWR VPWR sky130_fd_sc_hd__decap_4
XFILLER_130_776 VPWR VGND VPWR VGND sky130_ef_sc_hd__decap_12
XFILLER_87_178 VPWR VGND VPWR VGND sky130_ef_sc_hd__decap_12
XFILLER_87_156 VPWR VGND VPWR VGND sky130_ef_sc_hd__decap_12
XTAP_TAPCELL_ROW_71_1470 VGND VPWR sky130_fd_sc_hd__tapvpwrvgnd_1
XTAP_TAPCELL_ROW_54_1189 VGND VPWR sky130_fd_sc_hd__tapvpwrvgnd_1
X_07937_ decoded_imm_j\[6\] _03693_ VGND VGND VPWR VPWR _03764_ sky130_fd_sc_hd__nand2_1
XFILLER_113_11 VPWR VGND VPWR VGND sky130_ef_sc_hd__decap_12
XFILLER_28_201 VGND VGND VPWR VPWR sky130_fd_sc_hd__fill_1
X_07868_ reg_pc\[22\] _01624_ _01628_ _03709_ VGND VGND VPWR VPWR _00666_ sky130_fd_sc_hd__a22o_1
XFILLER_113_55 VGND VGND VPWR VPWR sky130_fd_sc_hd__fill_1
XTAP_TAPCELL_ROW_3_377 VGND VPWR sky130_fd_sc_hd__tapvpwrvgnd_1
X_07799_ count_instr\[54\] _03669_ _03671_ VGND VGND VPWR VPWR _00635_ sky130_fd_sc_hd__o21a_1
X_06819_ decoded_imm\[19\] net181 VGND VGND VPWR VPWR _03238_ sky130_fd_sc_hd__or2_1
X_09607_ _02638_ cpuregs\[3\]\[13\] _04868_ VGND VGND VPWR VPWR _01267_ sky130_fd_sc_hd__mux2_1
XFILLER_71_513 VPWR VGND VPWR VGND sky130_ef_sc_hd__decap_12
XFILLER_71_502 VGND VGND VPWR VPWR sky130_fd_sc_hd__fill_2
XFILLER_56_598 VGND VGND VPWR VPWR sky130_fd_sc_hd__decap_8
XFILLER_16_418 VGND VGND VPWR VPWR sky130_fd_sc_hd__fill_2
XFILLER_44_749 VGND VGND VPWR VPWR sky130_fd_sc_hd__decap_6
XFILLER_113_99 VGND VGND VPWR VPWR sky130_fd_sc_hd__fill_2
XFILLER_73_48 VGND VGND VPWR VPWR sky130_fd_sc_hd__decap_8
X_09538_ cpuregs\[23\]\[10\] _02624_ _04866_ VGND VGND VPWR VPWR _01200_ sky130_fd_sc_hd__mux2_1
XFILLER_24_451 VPWR VGND VPWR VGND sky130_ef_sc_hd__decap_12
XFILLER_51_281 VPWR VGND VPWR VGND sky130_ef_sc_hd__decap_12
X_09469_ cpuregs\[24\]\[7\] _02612_ net243 VGND VGND VPWR VPWR _01133_ sky130_fd_sc_hd__mux2_1
XFILLER_132_3 VPWR VGND VPWR VGND sky130_ef_sc_hd__decap_12
XFILLER_7_105 VGND VGND VPWR VPWR sky130_fd_sc_hd__decap_6
XFILLER_12_657 VGND VGND VPWR VPWR sky130_fd_sc_hd__decap_6
XFILLER_12_679 VGND VGND VPWR VPWR sky130_fd_sc_hd__decap_8
X_11431_ clknet_leaf_34_clk _01475_ VGND VGND VPWR VPWR cpuregs\[8\]\[29\] sky130_fd_sc_hd__dfxtp_1
XFILLER_22_41 VPWR VGND VPWR VGND sky130_ef_sc_hd__decap_12
XTAP_TAPCELL_ROW_22_685 VGND VPWR sky130_fd_sc_hd__tapvpwrvgnd_1
XFILLER_153_813 VGND VGND VPWR VPWR sky130_fd_sc_hd__fill_2
X_11362_ clknet_leaf_68_clk _01406_ VGND VGND VPWR VPWR cpuregs\[6\]\[24\] sky130_fd_sc_hd__dfxtp_1
XFILLER_138_41 VPWR VGND VPWR VGND sky130_ef_sc_hd__decap_12
XFILLER_7_149 VPWR VGND VPWR VGND sky130_ef_sc_hd__decap_12
XFILLER_153_846 VGND VGND VPWR VPWR sky130_fd_sc_hd__decap_4
XFILLER_152_301 VGND VGND VPWR VPWR sky130_fd_sc_hd__decap_6
X_10313_ clknet_leaf_52_clk _00443_ VGND VGND VPWR VPWR cpuregs\[26\]\[23\] sky130_fd_sc_hd__dfxtp_1
XFILLER_152_356 VGND VGND VPWR VPWR sky130_fd_sc_hd__decap_8
X_11293_ clknet_leaf_46_clk _01340_ VGND VGND VPWR VPWR cpuregs\[4\]\[22\] sky130_fd_sc_hd__dfxtp_1
XFILLER_4_867 VGND VGND VPWR VPWR sky130_fd_sc_hd__fill_1
XFILLER_152_389 VPWR VGND VPWR VGND sky130_ef_sc_hd__decap_12
XFILLER_133_570 VPWR VGND VPWR VGND sky130_ef_sc_hd__decap_12
X_10244_ clknet_leaf_53_clk _00374_ VGND VGND VPWR VPWR cpuregs\[27\]\[18\] sky130_fd_sc_hd__dfxtp_1
XFILLER_112_209 VGND VGND VPWR VPWR sky130_fd_sc_hd__decap_6
XFILLER_106_773 VGND VGND VPWR VPWR sky130_fd_sc_hd__decap_8
XFILLER_98_89 VGND VGND VPWR VPWR sky130_fd_sc_hd__fill_1
XFILLER_98_78 VGND VGND VPWR VPWR sky130_fd_sc_hd__decap_6
XFILLER_133_592 VGND VGND VPWR VPWR sky130_fd_sc_hd__decap_4
XFILLER_105_272 VGND VGND VPWR VPWR sky130_fd_sc_hd__decap_8
X_10175_ clknet_leaf_10_clk _00305_ VGND VGND VPWR VPWR cpuregs\[9\]\[13\] sky130_fd_sc_hd__dfxtp_1
XFILLER_120_264 VGND VGND VPWR VPWR sky130_fd_sc_hd__decap_3
XFILLER_120_253 VGND VGND VPWR VPWR sky130_fd_sc_hd__fill_2
XFILLER_94_605 VGND VGND VPWR VPWR sky130_fd_sc_hd__fill_2
XFILLER_66_318 VGND VGND VPWR VPWR sky130_fd_sc_hd__fill_2
XFILLER_75_841 VPWR VGND VPWR VGND sky130_ef_sc_hd__decap_12
XFILLER_19_223 VGND VGND VPWR VPWR sky130_fd_sc_hd__fill_1
XTAP_TAPCELL_ROW_105_2009 VGND VPWR sky130_fd_sc_hd__tapvpwrvgnd_1
XFILLER_90_800 VPWR VGND VPWR VGND sky130_ef_sc_hd__decap_12
XTAP_TAPCELL_ROW_89_1753 VGND VPWR sky130_fd_sc_hd__tapvpwrvgnd_1
XFILLER_19_234 VPWR VGND VPWR VGND sky130_ef_sc_hd__decap_12
XFILLER_62_513 VPWR VGND VPWR VGND sky130_ef_sc_hd__decap_12
XFILLER_19_278 VGND VGND VPWR VPWR sky130_fd_sc_hd__fill_2
XFILLER_35_727 VGND VGND VPWR VPWR sky130_fd_sc_hd__fill_1
XFILLER_90_844 VGND VGND VPWR VPWR sky130_fd_sc_hd__fill_1
XFILLER_90_888 VGND VGND VPWR VPWR sky130_fd_sc_hd__decap_8
XFILLER_43_771 VGND VGND VPWR VPWR sky130_fd_sc_hd__fill_1
XFILLER_129_821 VPWR VGND VPWR VGND sky130_ef_sc_hd__decap_12
XTAP_TAPCELL_ROW_100_1931 VGND VPWR sky130_fd_sc_hd__tapvpwrvgnd_1
XFILLER_8_65 VPWR VGND VPWR VGND sky130_ef_sc_hd__decap_12
XTAP_TAPCELL_ROW_41_983 VGND VPWR sky130_fd_sc_hd__tapvpwrvgnd_1
XTAP_TAPCELL_ROW_41_994 VGND VPWR sky130_fd_sc_hd__tapvpwrvgnd_1
XFILLER_144_813 VPWR VGND VPWR VGND sky130_ef_sc_hd__decap_12
XFILLER_129_865 VPWR VGND VPWR VGND sky130_ef_sc_hd__decap_12
X_05150_ net25 net611 VGND VGND VPWR VPWR _01758_ sky130_fd_sc_hd__nand2b_1
XTAP_TAPCELL_ROW_133_2463 VGND VPWR sky130_fd_sc_hd__tapvpwrvgnd_1
XTAP_TAPCELL_ROW_133_2452 VGND VPWR sky130_fd_sc_hd__tapvpwrvgnd_1
X_05081_ reg_pc\[2\] decoded_imm\[2\] VGND VGND VPWR VPWR _01694_ sky130_fd_sc_hd__nor2_1
X_08840_ decoded_imm\[19\] _01654_ _01586_ VGND VGND VPWR VPWR _04523_ sky130_fd_sc_hd__a21o_1
X_05983_ reg_out\[14\] reg_next_pc\[14\] net596 VGND VGND VPWR VPWR _02495_ sky130_fd_sc_hd__mux2_1
X_08771_ net209 _01585_ _04456_ _04457_ VGND VGND VPWR VPWR _00821_ sky130_fd_sc_hd__o22a_1
XFILLER_69_178 VPWR VGND VPWR VGND sky130_ef_sc_hd__decap_12
X_07722_ _03622_ _03623_ VGND VGND VPWR VPWR _00606_ sky130_fd_sc_hd__nor2_1
X_04934_ net191 VGND VGND VPWR VPWR _01567_ sky130_fd_sc_hd__inv_2
XFILLER_65_373 VGND VGND VPWR VPWR sky130_fd_sc_hd__decap_8
XTAP_TAPCELL_ROW_0_314 VGND VPWR sky130_fd_sc_hd__tapvpwrvgnd_1
XTAP_TAPCELL_ROW_0_325 VGND VPWR sky130_fd_sc_hd__tapvpwrvgnd_1
XTAP_TAPCELL_ROW_0_336 VGND VPWR sky130_fd_sc_hd__tapvpwrvgnd_1
X_07653_ cpu_state\[1\] decoder_trigger count_instr\[0\] count_instr\[1\] VGND VGND
+ VPWR VPWR _03579_ sky130_fd_sc_hd__and4_1
XFILLER_80_343 VGND VGND VPWR VPWR sky130_fd_sc_hd__fill_1
X_06604_ net172 _02725_ _03031_ VGND VGND VPWR VPWR _00079_ sky130_fd_sc_hd__a21o_1
XFILLER_25_237 VGND VGND VPWR VPWR sky130_fd_sc_hd__decap_6
X_07584_ cpuregs\[20\]\[1\] _02588_ net245 VGND VGND VPWR VPWR _00517_ sky130_fd_sc_hd__mux2_1
X_09323_ reg_sh\[1\] _02744_ _04819_ _04821_ VGND VGND VPWR VPWR _00998_ sky130_fd_sc_hd__a22o_1
XFILLER_80_387 VGND VGND VPWR VPWR sky130_fd_sc_hd__decap_6
XFILLER_21_421 VGND VGND VPWR VPWR sky130_fd_sc_hd__decap_3
X_06535_ cpuregs\[12\]\[8\] cpuregs\[13\]\[8\] cpuregs\[14\]\[8\] cpuregs\[15\]\[8\]
+ net263 net259 VGND VGND VPWR VPWR _02965_ sky130_fd_sc_hd__mux4_1
X_09254_ _01099_ _04742_ _04794_ _02514_ is_alu_reg_reg VGND VGND VPWR VPWR _00951_
+ sky130_fd_sc_hd__a32o_1
X_06466_ decoded_imm\[6\] net199 VGND VGND VPWR VPWR _02898_ sky130_fd_sc_hd__or2_1
X_08205_ decoded_imm_j\[20\] _03714_ VGND VGND VPWR VPWR _04011_ sky130_fd_sc_hd__or2_1
X_05417_ _01981_ _01991_ _01992_ _02003_ VGND VGND VPWR VPWR _02004_ sky130_fd_sc_hd__o211a_1
X_09185_ decoded_imm_j\[8\] _01122_ _02513_ VGND VGND VPWR VPWR _00890_ sky130_fd_sc_hd__mux2_1
XFILLER_153_109 VGND VGND VPWR VPWR sky130_fd_sc_hd__decap_3
XFILLER_147_673 VPWR VGND VPWR VGND sky130_ef_sc_hd__decap_12
X_08136_ _03940_ _03946_ VGND VGND VPWR VPWR _03948_ sky130_fd_sc_hd__nand2_1
X_06397_ _02824_ _02825_ _02826_ net258 VGND VGND VPWR VPWR _02832_ sky130_fd_sc_hd__a22o_1
XFILLER_119_375 VGND VGND VPWR VPWR sky130_fd_sc_hd__fill_1
XFILLER_107_537 VPWR VGND VPWR VGND sky130_ef_sc_hd__decap_12
X_05348_ cpu_state\[6\] _01860_ _01937_ cpu_state\[4\] net185 VGND VGND VPWR VPWR
+ _01941_ sky130_fd_sc_hd__a32o_1
XFILLER_150_805 VGND VGND VPWR VPWR sky130_fd_sc_hd__decap_6
XFILLER_104_7 VPWR VGND VPWR VGND sky130_ef_sc_hd__decap_12
X_05279_ reg_pc\[16\] decoded_imm\[16\] _01869_ _01876_ VGND VGND VPWR VPWR _01877_
+ sky130_fd_sc_hd__a211o_1
X_08067_ instr_jal _03883_ VGND VGND VPWR VPWR _03884_ sky130_fd_sc_hd__nand2_1
XTAP_TAPCELL_ROW_56_1229 VGND VPWR sky130_fd_sc_hd__tapvpwrvgnd_1
Xpicorv32_381 VGND VGND VPWR VPWR picorv32_381/HI trace_data[31] sky130_fd_sc_hd__conb_1
XFILLER_150_849 VPWR VGND VPWR VGND sky130_ef_sc_hd__decap_12
X_07018_ _02714_ _03427_ _03429_ VGND VGND VPWR VPWR _03430_ sky130_fd_sc_hd__nor3_1
XFILLER_68_26 VGND VGND VPWR VPWR sky130_fd_sc_hd__fill_2
Xpicorv32_370 VGND VGND VPWR VPWR picorv32_370/HI trace_data[20] sky130_fd_sc_hd__conb_1
XTAP_TAPCELL_ROW_8_458 VGND VPWR sky130_fd_sc_hd__tapvpwrvgnd_1
X_08969_ _04642_ _04644_ _04266_ _04641_ VGND VGND VPWR VPWR _04645_ sky130_fd_sc_hd__o211a_1
XFILLER_76_638 VGND VGND VPWR VPWR sky130_fd_sc_hd__decap_6
XFILLER_29_521 VGND VGND VPWR VPWR sky130_fd_sc_hd__fill_1
XFILLER_84_47 VGND VGND VPWR VPWR sky130_fd_sc_hd__fill_1
XFILLER_72_800 VGND VGND VPWR VPWR sky130_fd_sc_hd__decap_4
XFILLER_29_587 VPWR VGND VPWR VGND sky130_ef_sc_hd__decap_12
X_10931_ clknet_leaf_112_clk _00993_ VGND VGND VPWR VPWR latched_rd\[1\] sky130_fd_sc_hd__dfxtp_2
XFILLER_44_513 VGND VGND VPWR VPWR sky130_fd_sc_hd__decap_8
XFILLER_83_192 VGND VGND VPWR VPWR sky130_fd_sc_hd__fill_2
XFILLER_16_237 VPWR VGND VPWR VGND sky130_ef_sc_hd__decap_12
XFILLER_140_53 VPWR VGND VPWR VGND sky130_ef_sc_hd__decap_12
XTAP_TAPCELL_ROW_84_1672 VGND VPWR sky130_fd_sc_hd__tapvpwrvgnd_1
XTAP_TAPCELL_ROW_27_766 VGND VPWR sky130_fd_sc_hd__tapvpwrvgnd_1
X_10862_ clknet_leaf_4_clk _00924_ VGND VGND VPWR VPWR cpuregs\[1\]\[6\] sky130_fd_sc_hd__dfxtp_1
XTAP_TAPCELL_ROW_84_1683 VGND VPWR sky130_fd_sc_hd__tapvpwrvgnd_1
X_10793_ clknet_leaf_98_clk _00858_ VGND VGND VPWR VPWR instr_lhu sky130_fd_sc_hd__dfxtp_1
XFILLER_12_421 VGND VGND VPWR VPWR sky130_fd_sc_hd__decap_3
XFILLER_33_51 VGND VGND VPWR VPWR sky130_fd_sc_hd__decap_4
XFILLER_149_51 VGND VGND VPWR VPWR sky130_fd_sc_hd__decap_4
XFILLER_126_813 VPWR VGND VPWR VGND sky130_ef_sc_hd__decap_12
X_11414_ clknet_leaf_12_clk _01458_ VGND VGND VPWR VPWR cpuregs\[8\]\[12\] sky130_fd_sc_hd__dfxtp_1
XFILLER_153_643 VGND VGND VPWR VPWR sky130_fd_sc_hd__fill_1
XTAP_TAPCELL_ROW_115_2171 VGND VPWR sky130_fd_sc_hd__tapvpwrvgnd_1
X_11345_ clknet_leaf_148_clk _01389_ VGND VGND VPWR VPWR cpuregs\[6\]\[7\] sky130_fd_sc_hd__dfxtp_1
XFILLER_152_153 VPWR VGND VPWR VGND sky130_ef_sc_hd__decap_12
X_11276_ clknet_leaf_140_clk _01323_ VGND VGND VPWR VPWR cpuregs\[4\]\[5\] sky130_fd_sc_hd__dfxtp_1
XFILLER_152_197 VPWR VGND VPWR VGND sky130_ef_sc_hd__decap_12
X_10227_ clknet_leaf_116_clk _00357_ VGND VGND VPWR VPWR cpuregs\[27\]\[1\] sky130_fd_sc_hd__dfxtp_1
XFILLER_121_540 VGND VGND VPWR VPWR sky130_fd_sc_hd__decap_8
X_10158_ clknet_leaf_40_clk _00288_ VGND VGND VPWR VPWR cpuregs\[21\]\[28\] sky130_fd_sc_hd__dfxtp_1
X_10089_ clknet_leaf_42_clk _00219_ VGND VGND VPWR VPWR cpuregs\[2\]\[23\] sky130_fd_sc_hd__dfxtp_1
XFILLER_75_671 VGND VGND VPWR VPWR sky130_fd_sc_hd__fill_1
XFILLER_75_693 VGND VGND VPWR VPWR sky130_fd_sc_hd__decap_4
XFILLER_74_170 VGND VGND VPWR VPWR sky130_fd_sc_hd__fill_1
XFILLER_95_3 VGND VGND VPWR VPWR sky130_fd_sc_hd__decap_3
X_06320_ cpuregs\[28\]\[1\] cpuregs\[29\]\[1\] cpuregs\[30\]\[1\] cpuregs\[31\]\[1\]
+ net268 net262 VGND VGND VPWR VPWR _02757_ sky130_fd_sc_hd__mux4_1
XFILLER_15_281 VGND VGND VPWR VPWR sky130_fd_sc_hd__decap_8
X_06251_ reg_pc\[27\] reg_pc\[26\] _02686_ VGND VGND VPWR VPWR _02694_ sky130_fd_sc_hd__and3_1
Xclkbuf_4_4_0_clk clknet_0_clk VGND VGND VPWR VPWR clknet_4_4_0_clk sky130_fd_sc_hd__clkbuf_8
X_05202_ count_instr\[11\] instr_rdinstr count_cycle\[43\] instr_rdcycleh VGND VGND
+ VPWR VPWR _01806_ sky130_fd_sc_hd__a22o_1
X_06182_ _02638_ cpuregs\[11\]\[13\] _02582_ VGND VGND VPWR VPWR _00050_ sky130_fd_sc_hd__mux2_1
XFILLER_116_334 VGND VGND VPWR VPWR sky130_fd_sc_hd__decap_6
X_05133_ reg_pc\[6\] decoded_imm\[6\] VGND VGND VPWR VPWR _01742_ sky130_fd_sc_hd__or2_1
XFILLER_116_389 VPWR VGND VPWR VGND sky130_ef_sc_hd__decap_12
X_05064_ instr_rdcycleh count_cycle\[32\] _01675_ _01678_ VGND VGND VPWR VPWR _01679_
+ sky130_fd_sc_hd__a211o_1
X_09941_ clknet_leaf_126_clk _00071_ VGND VGND VPWR VPWR net193 sky130_fd_sc_hd__dfxtp_4
XFILLER_132_849 VPWR VGND VPWR VGND sky130_ef_sc_hd__decap_12
XFILLER_131_337 VGND VGND VPWR VPWR sky130_fd_sc_hd__fill_1
XTAP_TAPCELL_ROW_5_417 VGND VPWR sky130_fd_sc_hd__tapvpwrvgnd_1
X_09872_ cpuregs\[0\]\[2\] VGND VGND VPWR VPWR _01480_ sky130_fd_sc_hd__clkbuf_1
XTAP_TAPCELL_ROW_5_406 VGND VPWR sky130_fd_sc_hd__tapvpwrvgnd_1
XFILLER_140_893 VPWR VGND VPWR VGND sky130_ef_sc_hd__decap_12
X_08823_ _04505_ _04506_ _04266_ _04503_ VGND VGND VPWR VPWR _04507_ sky130_fd_sc_hd__o211a_1
XTAP_TAPCELL_ROW_51_1148 VGND VPWR sky130_fd_sc_hd__tapvpwrvgnd_1
XFILLER_38_29 VPWR VGND VPWR VGND sky130_ef_sc_hd__decap_12
XTAP_TAPCELL_ROW_146_2665 VGND VPWR sky130_fd_sc_hd__tapvpwrvgnd_1
XFILLER_100_757 VPWR VGND VPWR VGND sky130_ef_sc_hd__decap_12
XFILLER_73_608 VGND VGND VPWR VPWR sky130_fd_sc_hd__decap_3
X_08754_ cpuregs\[28\]\[15\] cpuregs\[29\]\[15\] cpuregs\[30\]\[15\] cpuregs\[31\]\[15\]
+ net277 net272 VGND VGND VPWR VPWR _04441_ sky130_fd_sc_hd__mux4_1
XFILLER_57_137 VGND VGND VPWR VPWR sky130_fd_sc_hd__fill_1
X_05966_ net198 _02486_ _01582_ VGND VGND VPWR VPWR net91 sky130_fd_sc_hd__mux2_1
X_07705_ count_instr\[20\] _03610_ _01549_ VGND VGND VPWR VPWR _03612_ sky130_fd_sc_hd__a21oi_1
X_04917_ instr_jalr VGND VGND VPWR VPWR _01550_ sky130_fd_sc_hd__inv_2
X_05897_ net255 _02451_ _02445_ VGND VGND VPWR VPWR alu_out\[28\] sky130_fd_sc_hd__a21o_1
Xclkbuf_leaf_92_clk clknet_4_12_0_clk VGND VGND VPWR VPWR clknet_leaf_92_clk sky130_fd_sc_hd__clkbuf_8
X_08685_ cpuregs\[4\]\[11\] cpuregs\[5\]\[11\] cpuregs\[6\]\[11\] cpuregs\[7\]\[11\]
+ net279 _00008_ VGND VGND VPWR VPWR _04376_ sky130_fd_sc_hd__mux4_1
X_07636_ _02665_ cpuregs\[17\]\[20\] _03574_ VGND VGND VPWR VPWR _00568_ sky130_fd_sc_hd__mux2_1
XFILLER_81_652 VPWR VGND VPWR VGND sky130_ef_sc_hd__decap_12
XFILLER_54_888 VGND VGND VPWR VPWR sky130_fd_sc_hd__decap_6
XFILLER_54_866 VGND VGND VPWR VPWR sky130_fd_sc_hd__fill_2
X_07567_ cpuregs\[25\]\[18\] _02657_ _03571_ VGND VGND VPWR VPWR _00502_ sky130_fd_sc_hd__mux2_1
XFILLER_110_23 VGND VGND VPWR VPWR sky130_fd_sc_hd__decap_4
XTAP_TAPCELL_ROW_66_1391 VGND VPWR sky130_fd_sc_hd__tapvpwrvgnd_1
XTAP_TAPCELL_ROW_66_1380 VGND VPWR sky130_fd_sc_hd__tapvpwrvgnd_1
XFILLER_53_398 VGND VGND VPWR VPWR sky130_fd_sc_hd__decap_8
XTAP_TAPCELL_ROW_24_714 VGND VPWR sky130_fd_sc_hd__tapvpwrvgnd_1
XFILLER_110_45 VGND VGND VPWR VPWR sky130_fd_sc_hd__fill_2
XFILLER_80_195 VGND VGND VPWR VPWR sky130_fd_sc_hd__fill_1
X_09306_ net169 _04206_ VGND VGND VPWR VPWR _04813_ sky130_fd_sc_hd__or2_1
XFILLER_22_730 VGND VGND VPWR VPWR sky130_fd_sc_hd__decap_6
X_06518_ net200 _02948_ _02724_ VGND VGND VPWR VPWR _00076_ sky130_fd_sc_hd__mux2_1
X_09237_ cpuregs\[1\]\[16\] _02649_ net244 VGND VGND VPWR VPWR _00934_ sky130_fd_sc_hd__mux2_1
X_07498_ cpuregs\[26\]\[16\] _02649_ _03568_ VGND VGND VPWR VPWR _00436_ sky130_fd_sc_hd__mux2_1
XFILLER_70_27 VGND VGND VPWR VPWR sky130_fd_sc_hd__fill_1
XFILLER_22_796 VPWR VGND VPWR VGND sky130_ef_sc_hd__decap_12
X_06449_ net199 _02720_ _02881_ _01641_ VGND VGND VPWR VPWR _02882_ sky130_fd_sc_hd__o211a_1
XFILLER_119_43 VPWR VGND VPWR VGND sky130_ef_sc_hd__decap_12
X_09168_ _04775_ _04776_ _04784_ VGND VGND VPWR VPWR _04785_ sky130_fd_sc_hd__or3_1
XFILLER_5_417 VGND VGND VPWR VPWR sky130_fd_sc_hd__decap_8
X_08119_ _03929_ _03930_ _03931_ VGND VGND VPWR VPWR _03932_ sky130_fd_sc_hd__a21o_1
X_09099_ _04746_ _04752_ VGND VGND VPWR VPWR _04753_ sky130_fd_sc_hd__and2_1
X_11130_ clknet_leaf_73_clk _01177_ VGND VGND VPWR VPWR cpuregs\[31\]\[19\] sky130_fd_sc_hd__dfxtp_1
XFILLER_122_315 VGND VGND VPWR VPWR sky130_fd_sc_hd__fill_1
XFILLER_79_47 VGND VGND VPWR VPWR sky130_fd_sc_hd__decap_8
XFILLER_1_645 VPWR VGND VPWR VGND sky130_ef_sc_hd__decap_12
X_11061_ clknet_leaf_118_clk _01118_ VGND VGND VPWR VPWR mem_rdata_q\[24\] sky130_fd_sc_hd__dfxtp_1
XTAP_TAPCELL_ROW_110_2090 VGND VPWR sky130_fd_sc_hd__tapvpwrvgnd_1
XFILLER_95_35 VPWR VGND VPWR VGND sky130_ef_sc_hd__decap_12
XFILLER_89_785 VGND VGND VPWR VPWR sky130_fd_sc_hd__decap_4
X_10012_ clknet_leaf_14_clk _00142_ VGND VGND VPWR VPWR cpuregs\[30\]\[10\] sky130_fd_sc_hd__dfxtp_1
XFILLER_91_405 VGND VGND VPWR VPWR sky130_fd_sc_hd__decap_6
XTAP_TAPCELL_ROW_86_1712 VGND VPWR sky130_fd_sc_hd__tapvpwrvgnd_1
XTAP_TAPCELL_ROW_86_1701 VGND VPWR sky130_fd_sc_hd__tapvpwrvgnd_1
XFILLER_28_73 VGND VGND VPWR VPWR sky130_fd_sc_hd__decap_8
Xclkbuf_leaf_83_clk clknet_4_14_0_clk VGND VGND VPWR VPWR clknet_leaf_83_clk sky130_fd_sc_hd__clkbuf_8
X_10914_ clknet_leaf_47_clk _00976_ VGND VGND VPWR VPWR net147 sky130_fd_sc_hd__dfxtp_1
XFILLER_72_674 VPWR VGND VPWR VGND sky130_ef_sc_hd__decap_12
XFILLER_44_343 VGND VGND VPWR VPWR sky130_fd_sc_hd__fill_1
XFILLER_60_847 VGND VGND VPWR VPWR sky130_fd_sc_hd__fill_1
X_10845_ clknet_leaf_118_clk _00910_ VGND VGND VPWR VPWR decoded_imm_j\[3\] sky130_fd_sc_hd__dfxtp_2
XFILLER_13_752 VGND VGND VPWR VPWR sky130_fd_sc_hd__decap_8
XFILLER_44_83 VGND VGND VPWR VPWR sky130_fd_sc_hd__fill_1
XTAP_TAPCELL_ROW_117_2200 VGND VPWR sky130_fd_sc_hd__tapvpwrvgnd_1
X_10776_ clknet_leaf_55_clk alu_out\[29\] VGND VGND VPWR VPWR alu_out_q\[29\] sky130_fd_sc_hd__dfxtp_1
XFILLER_12_251 VGND VGND VPWR VPWR sky130_fd_sc_hd__fill_1
XFILLER_13_785 VPWR VGND VPWR VGND sky130_ef_sc_hd__decap_12
XTAP_TAPCELL_ROW_117_2211 VGND VPWR sky130_fd_sc_hd__tapvpwrvgnd_1
XFILLER_9_767 VPWR VGND VPWR VGND sky130_ef_sc_hd__decap_12
XFILLER_126_610 VGND VGND VPWR VPWR sky130_fd_sc_hd__decap_4
XFILLER_117_109 VGND VGND VPWR VPWR sky130_fd_sc_hd__decap_3
XTAP_TAPCELL_ROW_130_2411 VGND VPWR sky130_fd_sc_hd__tapvpwrvgnd_1
XTAP_TAPCELL_ROW_97_1885 VGND VPWR sky130_fd_sc_hd__tapvpwrvgnd_1
XTAP_TAPCELL_ROW_10_485 VGND VPWR sky130_fd_sc_hd__tapvpwrvgnd_1
XFILLER_153_473 VGND VGND VPWR VPWR sky130_fd_sc_hd__decap_3
X_11328_ clknet_leaf_48_clk _01375_ VGND VGND VPWR VPWR cpuregs\[5\]\[25\] sky130_fd_sc_hd__dfxtp_1
XFILLER_113_304 VGND VGND VPWR VPWR sky130_fd_sc_hd__decap_8
XFILLER_99_505 VPWR VGND VPWR VGND sky130_ef_sc_hd__decap_12
XTAP_TAPCELL_ROW_10_496 VGND VPWR sky130_fd_sc_hd__tapvpwrvgnd_1
XFILLER_5_55 VGND VGND VPWR VPWR sky130_fd_sc_hd__fill_1
XFILLER_107_890 VGND VGND VPWR VPWR sky130_fd_sc_hd__decap_6
X_11259_ clknet_leaf_75_clk _01306_ VGND VGND VPWR VPWR cpuregs\[22\]\[20\] sky130_fd_sc_hd__dfxtp_1
XFILLER_122_893 VPWR VGND VPWR VGND sky130_ef_sc_hd__decap_12
X_05820_ _02381_ _02382_ instr_sub VGND VGND VPWR VPWR _02383_ sky130_fd_sc_hd__mux2_1
XPHY_EDGE_ROW_105_Left_259 VGND VGND VPWR VPWR sky130_fd_sc_hd__decap_3
XFILLER_10_3 VPWR VGND VPWR VGND sky130_ef_sc_hd__decap_12
XTAP_TAPCELL_ROW_128_2384 VGND VPWR sky130_fd_sc_hd__tapvpwrvgnd_1
XTAP_TAPCELL_ROW_128_2373 VGND VPWR sky130_fd_sc_hd__tapvpwrvgnd_1
XFILLER_54_118 VPWR VGND VPWR VGND sky130_ef_sc_hd__decap_12
XFILLER_36_811 VGND VGND VPWR VPWR sky130_fd_sc_hd__fill_1
Xclkbuf_leaf_74_clk clknet_4_13_0_clk VGND VGND VPWR VPWR clknet_leaf_74_clk sky130_fd_sc_hd__clkbuf_8
X_05751_ _02154_ _02238_ _02240_ _02156_ _02321_ VGND VGND VPWR VPWR _02322_ sky130_fd_sc_hd__a221o_1
XFILLER_47_181 VPWR VGND VPWR VGND sky130_ef_sc_hd__decap_12
X_05682_ _02127_ _02260_ _02261_ VGND VGND VPWR VPWR _02262_ sky130_fd_sc_hd__a21oi_1
X_08470_ net235 net129 VGND VGND VPWR VPWR _04206_ sky130_fd_sc_hd__and2b_4
XTAP_TAPCELL_ROW_141_2595 VGND VPWR sky130_fd_sc_hd__tapvpwrvgnd_1
XTAP_TAPCELL_ROW_141_2584 VGND VPWR sky130_fd_sc_hd__tapvpwrvgnd_1
XFILLER_51_825 VPWR VGND VPWR VGND sky130_ef_sc_hd__decap_12
X_07421_ cpuregs\[27\]\[5\] _02603_ _03566_ VGND VGND VPWR VPWR _00361_ sky130_fd_sc_hd__mux2_1
X_07352_ _02593_ cpuregs\[9\]\[3\] _03563_ VGND VGND VPWR VPWR _00295_ sky130_fd_sc_hd__mux2_1
XFILLER_149_724 VGND VGND VPWR VPWR sky130_fd_sc_hd__decap_4
XPHY_EDGE_ROW_114_Left_268 VGND VGND VPWR VPWR sky130_fd_sc_hd__decap_3
X_06303_ cpuregs\[28\]\[0\] cpuregs\[29\]\[0\] cpuregs\[30\]\[0\] cpuregs\[31\]\[0\]
+ net268 net262 VGND VGND VPWR VPWR _02741_ sky130_fd_sc_hd__mux4_1
XFILLER_148_267 VGND VGND VPWR VPWR sky130_fd_sc_hd__fill_2
XFILLER_148_234 VGND VGND VPWR VPWR sky130_fd_sc_hd__fill_2
X_07283_ cpuregs\[28\]\[1\] _02588_ net249 VGND VGND VPWR VPWR _00229_ sky130_fd_sc_hd__mux2_1
X_06234_ reg_pc\[23\] _02673_ reg_pc\[24\] VGND VGND VPWR VPWR _02680_ sky130_fd_sc_hd__a21oi_1
X_09022_ net269 _04693_ _01559_ VGND VGND VPWR VPWR _04695_ sky130_fd_sc_hd__a21o_1
XFILLER_40_19 VGND VGND VPWR VPWR sky130_fd_sc_hd__decap_8
X_06165_ _02624_ cpuregs\[11\]\[10\] _02582_ VGND VGND VPWR VPWR _00047_ sky130_fd_sc_hd__mux2_1
XFILLER_144_473 VGND VGND VPWR VPWR sky130_fd_sc_hd__decap_3
X_05116_ count_cycle\[4\] _01588_ net256 _01726_ VGND VGND VPWR VPWR _01727_ sky130_fd_sc_hd__o211a_1
X_06096_ _01559_ _02562_ _02566_ VGND VGND VPWR VPWR _02567_ sky130_fd_sc_hd__a21oi_1
XTAP_TAPCELL_ROW_148_2705 VGND VPWR sky130_fd_sc_hd__tapvpwrvgnd_1
X_09924_ clknet_leaf_43_clk _00059_ VGND VGND VPWR VPWR cpuregs\[11\]\[22\] sky130_fd_sc_hd__dfxtp_1
XFILLER_132_679 VPWR VGND VPWR VGND sky130_ef_sc_hd__decap_12
XFILLER_132_657 VPWR VGND VPWR VGND sky130_ef_sc_hd__decap_12
XPHY_EDGE_ROW_123_Left_277 VGND VGND VPWR VPWR sky130_fd_sc_hd__decap_3
X_05047_ is_lb_lh_lw_lbu_lhu _01602_ VGND VGND VPWR VPWR _01664_ sky130_fd_sc_hd__and2_1
X_09855_ _02704_ cpuregs\[10\]\[29\] _04876_ VGND VGND VPWR VPWR _01539_ sky130_fd_sc_hd__mux2_1
XFILLER_105_23 VPWR VGND VPWR VGND sky130_ef_sc_hd__decap_12
X_08806_ net211 _01585_ _04489_ _04490_ VGND VGND VPWR VPWR _00823_ sky130_fd_sc_hd__o22a_1
XFILLER_86_755 VGND VGND VPWR VPWR sky130_fd_sc_hd__fill_1
XFILLER_58_457 VGND VGND VPWR VPWR sky130_fd_sc_hd__fill_2
X_09786_ _02691_ cpuregs\[7\]\[26\] _04874_ VGND VGND VPWR VPWR _01440_ sky130_fd_sc_hd__mux2_1
X_06998_ cpuregs\[24\]\[25\] cpuregs\[25\]\[25\] cpuregs\[26\]\[25\] cpuregs\[27\]\[25\]
+ net267 net261 VGND VGND VPWR VPWR _03411_ sky130_fd_sc_hd__mux4_1
XFILLER_105_78 VGND VGND VPWR VPWR sky130_fd_sc_hd__decap_4
XFILLER_65_27 VPWR VGND VPWR VGND sky130_ef_sc_hd__decap_12
XFILLER_39_671 VGND VGND VPWR VPWR sky130_fd_sc_hd__fill_1
XPHY_EDGE_ROW_134_Right_134 VGND VGND VPWR VPWR sky130_fd_sc_hd__decap_3
Xclkbuf_leaf_65_clk clknet_4_13_0_clk VGND VGND VPWR VPWR clknet_leaf_65_clk sky130_fd_sc_hd__clkbuf_8
X_05949_ net126 net218 _01665_ VGND VGND VPWR VPWR net112 sky130_fd_sc_hd__mux2_1
X_08737_ cpuregs\[16\]\[14\] cpuregs\[17\]\[14\] cpuregs\[18\]\[14\] cpuregs\[19\]\[14\]
+ net277 net271 VGND VGND VPWR VPWR _04425_ sky130_fd_sc_hd__mux4_1
XTAP_TAPCELL_ROW_68_1420 VGND VPWR sky130_fd_sc_hd__tapvpwrvgnd_1
XFILLER_27_833 VGND VGND VPWR VPWR sky130_fd_sc_hd__decap_6
XFILLER_54_641 VGND VGND VPWR VPWR sky130_fd_sc_hd__decap_3
X_08668_ cpuregs\[12\]\[10\] cpuregs\[13\]\[10\] cpuregs\[14\]\[10\] cpuregs\[15\]\[10\]
+ net277 net271 VGND VGND VPWR VPWR _04360_ sky130_fd_sc_hd__mux4_1
XFILLER_26_365 VGND VGND VPWR VPWR sky130_fd_sc_hd__decap_4
XFILLER_27_877 VPWR VGND VPWR VGND sky130_ef_sc_hd__decap_12
XFILLER_81_482 VGND VGND VPWR VPWR sky130_fd_sc_hd__decap_4
X_07619_ _02593_ cpuregs\[17\]\[3\] _03574_ VGND VGND VPWR VPWR _00551_ sky130_fd_sc_hd__mux2_1
XFILLER_41_302 VGND VGND VPWR VPWR sky130_fd_sc_hd__fill_1
XPHY_EDGE_ROW_132_Left_286 VGND VGND VPWR VPWR sky130_fd_sc_hd__decap_3
X_10630_ clknet_leaf_83_clk _00760_ VGND VGND VPWR VPWR count_cycle\[53\] sky130_fd_sc_hd__dfxtp_1
XTAP_TAPCELL_ROW_81_1631 VGND VPWR sky130_fd_sc_hd__tapvpwrvgnd_1
XTAP_TAPCELL_ROW_81_1620 VGND VPWR sky130_fd_sc_hd__tapvpwrvgnd_1
XFILLER_41_357 VGND VGND VPWR VPWR sky130_fd_sc_hd__decap_3
X_08599_ net270 _04290_ _04289_ _01560_ VGND VGND VPWR VPWR _04295_ sky130_fd_sc_hd__o211a_1
XFILLER_42_858 VGND VGND VPWR VPWR sky130_fd_sc_hd__decap_8
XFILLER_42_869 VPWR VGND VPWR VGND sky130_ef_sc_hd__decap_12
XFILLER_139_223 VGND VGND VPWR VPWR sky130_fd_sc_hd__fill_1
XFILLER_14_53 VPWR VGND VPWR VGND sky130_ef_sc_hd__decap_12
X_10561_ clknet_leaf_93_clk _00691_ VGND VGND VPWR VPWR reg_next_pc\[16\] sky130_fd_sc_hd__dfxtp_1
X_10492_ clknet_leaf_104_clk _00622_ VGND VGND VPWR VPWR count_instr\[41\] sky130_fd_sc_hd__dfxtp_1
XFILLER_5_225 VPWR VGND VPWR VGND sky130_ef_sc_hd__decap_12
XFILLER_30_41 VGND VGND VPWR VPWR sky130_fd_sc_hd__decap_6
XFILLER_146_41 VPWR VGND VPWR VGND sky130_ef_sc_hd__decap_12
XTAP_TAPCELL_ROW_112_2130 VGND VPWR sky130_fd_sc_hd__tapvpwrvgnd_1
XFILLER_108_676 VGND VGND VPWR VPWR sky130_fd_sc_hd__decap_8
XTAP_TAPCELL_ROW_79_1593 VGND VPWR sky130_fd_sc_hd__tapvpwrvgnd_1
XFILLER_5_269 VGND VGND VPWR VPWR sky130_fd_sc_hd__decap_8
XFILLER_150_421 VGND VGND VPWR VPWR sky130_fd_sc_hd__decap_3
XPHY_EDGE_ROW_141_Left_295 VGND VGND VPWR VPWR sky130_fd_sc_hd__decap_3
XFILLER_135_495 VGND VGND VPWR VPWR sky130_fd_sc_hd__decap_3
XFILLER_107_197 VPWR VGND VPWR VGND sky130_ef_sc_hd__decap_12
XFILLER_30_85 VGND VGND VPWR VPWR sky130_fd_sc_hd__decap_6
XFILLER_146_85 VPWR VGND VPWR VGND sky130_ef_sc_hd__decap_12
X_11113_ clknet_leaf_120_clk _01160_ VGND VGND VPWR VPWR cpuregs\[31\]\[2\] sky130_fd_sc_hd__dfxtp_1
XFILLER_110_318 VGND VGND VPWR VPWR sky130_fd_sc_hd__decap_4
X_11044_ clknet_leaf_110_clk _01101_ VGND VGND VPWR VPWR mem_rdata_q\[7\] sky130_fd_sc_hd__dfxtp_1
XFILLER_39_61 VGND VGND VPWR VPWR sky130_fd_sc_hd__fill_1
XFILLER_39_83 VGND VGND VPWR VPWR sky130_fd_sc_hd__decap_8
XFILLER_18_811 VGND VGND VPWR VPWR sky130_fd_sc_hd__fill_1
Xclkbuf_leaf_56_clk clknet_4_6_0_clk VGND VGND VPWR VPWR clknet_leaf_56_clk sky130_fd_sc_hd__clkbuf_8
XPHY_EDGE_ROW_101_Right_101 VGND VGND VPWR VPWR sky130_fd_sc_hd__decap_3
XFILLER_92_769 VPWR VGND VPWR VGND sky130_ef_sc_hd__decap_12
XFILLER_92_747 VGND VGND VPWR VPWR sky130_fd_sc_hd__decap_8
XFILLER_91_246 VGND VGND VPWR VPWR sky130_fd_sc_hd__fill_1
XFILLER_17_332 VGND VGND VPWR VPWR sky130_fd_sc_hd__decap_4
XTAP_TAPCELL_ROW_123_2292 VGND VPWR sky130_fd_sc_hd__tapvpwrvgnd_1
X_10828_ clknet_leaf_103_clk _00893_ VGND VGND VPWR VPWR decoded_imm_j\[12\] sky130_fd_sc_hd__dfxtp_1
XFILLER_60_677 VPWR VGND VPWR VGND sky130_ef_sc_hd__decap_12
XTAP_TAPCELL_ROW_15_566 VGND VPWR sky130_fd_sc_hd__tapvpwrvgnd_1
XTAP_TAPCELL_ROW_15_577 VGND VPWR sky130_fd_sc_hd__tapvpwrvgnd_1
XTAP_TAPCELL_ROW_99_1914 VGND VPWR sky130_fd_sc_hd__tapvpwrvgnd_1
X_10759_ clknet_leaf_18_clk alu_out\[12\] VGND VGND VPWR VPWR alu_out_q\[12\] sky130_fd_sc_hd__dfxtp_1
XFILLER_146_749 VGND VGND VPWR VPWR sky130_fd_sc_hd__decap_6
XFILLER_153_281 VPWR VGND VPWR VGND sky130_ef_sc_hd__decap_12
XFILLER_114_624 VGND VGND VPWR VPWR sky130_fd_sc_hd__fill_1
XFILLER_99_357 VPWR VGND VPWR VGND sky130_ef_sc_hd__decap_12
X_07970_ _01547_ reg_next_pc\[8\] _01645_ _03695_ VGND VGND VPWR VPWR _03795_ sky130_fd_sc_hd__a22o_1
X_06921_ cpuregs\[8\]\[22\] cpuregs\[9\]\[22\] cpuregs\[10\]\[22\] cpuregs\[11\]\[22\]
+ net266 net261 VGND VGND VPWR VPWR _03337_ sky130_fd_sc_hd__mux4_1
XFILLER_95_530 VGND VGND VPWR VPWR sky130_fd_sc_hd__fill_2
XFILLER_68_755 VGND VGND VPWR VPWR sky130_fd_sc_hd__fill_1
XTAP_TAPCELL_ROW_143_2624 VGND VPWR sky130_fd_sc_hd__tapvpwrvgnd_1
XTAP_TAPCELL_ROW_143_2613 VGND VPWR sky130_fd_sc_hd__tapvpwrvgnd_1
X_06852_ decoded_imm\[20\] net183 VGND VGND VPWR VPWR _03270_ sky130_fd_sc_hd__or2_1
XFILLER_95_585 VPWR VGND VPWR VGND sky130_ef_sc_hd__decap_12
X_09640_ _02638_ cpuregs\[22\]\[13\] _04869_ VGND VGND VPWR VPWR _01299_ sky130_fd_sc_hd__mux2_1
XFILLER_28_608 VGND VGND VPWR VPWR sky130_fd_sc_hd__decap_4
X_05803_ _02104_ _02240_ _02237_ VGND VGND VPWR VPWR _02368_ sky130_fd_sc_hd__a21oi_1
X_06783_ _01579_ _03203_ VGND VGND VPWR VPWR _03204_ sky130_fd_sc_hd__or2_1
X_09571_ cpuregs\[29\]\[10\] _02624_ net239 VGND VGND VPWR VPWR _01232_ sky130_fd_sc_hd__mux2_1
Xclkbuf_leaf_47_clk clknet_4_7_0_clk VGND VGND VPWR VPWR clknet_leaf_47_clk sky130_fd_sc_hd__clkbuf_8
X_05734_ _01561_ net204 _02193_ VGND VGND VPWR VPWR _02306_ sky130_fd_sc_hd__o21ai_1
X_08522_ cpuregs\[12\]\[0\] cpuregs\[13\]\[0\] cpuregs\[14\]\[0\] cpuregs\[15\]\[0\]
+ net278 net273 VGND VGND VPWR VPWR _04224_ sky130_fd_sc_hd__mux4_1
XFILLER_35_140 VGND VGND VPWR VPWR sky130_fd_sc_hd__decap_8
X_08453_ cpuregs\[24\]\[31\] cpuregs\[25\]\[31\] net264 VGND VGND VPWR VPWR _04190_
+ sky130_fd_sc_hd__mux2_1
XFILLER_24_825 VPWR VGND VPWR VGND sky130_ef_sc_hd__decap_12
XFILLER_35_173 VGND VGND VPWR VPWR sky130_fd_sc_hd__fill_1
X_07404_ cpuregs\[14\]\[22\] _02675_ net247 VGND VGND VPWR VPWR _00346_ sky130_fd_sc_hd__mux2_1
X_05665_ _01553_ net97 _02143_ VGND VGND VPWR VPWR _02247_ sky130_fd_sc_hd__and3_1
XFILLER_23_335 VGND VGND VPWR VPWR sky130_fd_sc_hd__fill_1
XFILLER_24_869 VPWR VGND VPWR VGND sky130_ef_sc_hd__decap_12
X_08384_ count_cycle\[44\] _04134_ count_cycle\[46\] count_cycle\[45\] VGND VGND VPWR
+ VPWR _04139_ sky130_fd_sc_hd__and4_1
X_05596_ net196 net122 VGND VGND VPWR VPWR _02179_ sky130_fd_sc_hd__and2b_1
XTAP_TAPCELL_ROW_34_875 VGND VPWR sky130_fd_sc_hd__tapvpwrvgnd_1
XTAP_TAPCELL_ROW_46_1069 VGND VPWR sky130_fd_sc_hd__tapvpwrvgnd_1
XFILLER_149_554 VGND VGND VPWR VPWR sky130_fd_sc_hd__decap_6
X_07335_ cpuregs\[21\]\[19\] _02662_ _03562_ VGND VGND VPWR VPWR _00279_ sky130_fd_sc_hd__mux2_1
XFILLER_109_418 VGND VGND VPWR VPWR sky130_fd_sc_hd__decap_8
X_07266_ cpuregs\[2\]\[17\] _02654_ net250 VGND VGND VPWR VPWR _00213_ sky130_fd_sc_hd__mux2_1
XFILLER_136_226 VGND VGND VPWR VPWR sky130_fd_sc_hd__decap_3
X_06217_ reg_out\[21\] alu_out_q\[21\] net587 VGND VGND VPWR VPWR _02666_ sky130_fd_sc_hd__mux2_1
X_09005_ decoded_imm\[28\] _01654_ _01586_ VGND VGND VPWR VPWR _04679_ sky130_fd_sc_hd__a21o_1
X_07197_ cpuregs\[30\]\[15\] _02646_ net252 VGND VGND VPWR VPWR _00147_ sky130_fd_sc_hd__mux2_1
XFILLER_132_421 VPWR VGND VPWR VGND sky130_ef_sc_hd__decap_12
XFILLER_105_646 VGND VGND VPWR VPWR sky130_fd_sc_hd__decap_6
XFILLER_104_101 VGND VGND VPWR VPWR sky130_fd_sc_hd__decap_4
XFILLER_3_729 VPWR VGND VPWR VGND sky130_ef_sc_hd__decap_12
X_06148_ _02583_ _02610_ VGND VGND VPWR VPWR _02611_ sky130_fd_sc_hd__nor2_1
XFILLER_132_465 VGND VGND VPWR VPWR sky130_fd_sc_hd__decap_4
X_06079_ _01559_ _02550_ VGND VGND VPWR VPWR _02551_ sky130_fd_sc_hd__nand2_1
XFILLER_120_627 VGND VGND VPWR VPWR sky130_fd_sc_hd__decap_8
X_09907_ clknet_leaf_145_clk _00042_ VGND VGND VPWR VPWR cpuregs\[11\]\[5\] sky130_fd_sc_hd__dfxtp_1
XFILLER_101_841 VPWR VGND VPWR VGND sky130_ef_sc_hd__decap_12
X_09838_ _02633_ cpuregs\[10\]\[12\] _04876_ VGND VGND VPWR VPWR _01522_ sky130_fd_sc_hd__mux2_1
X_09769_ _02621_ cpuregs\[7\]\[9\] _04874_ VGND VGND VPWR VPWR _01423_ sky130_fd_sc_hd__mux2_1
Xclkbuf_leaf_38_clk clknet_4_5_0_clk VGND VGND VPWR VPWR clknet_leaf_38_clk sky130_fd_sc_hd__clkbuf_8
XFILLER_132_65 VPWR VGND VPWR VGND sky130_ef_sc_hd__decap_12
XFILLER_74_769 VGND VGND VPWR VPWR sky130_fd_sc_hd__decap_8
Xrebuffer70 count_cycle\[1\] VGND VGND VPWR VPWR net456 sky130_fd_sc_hd__dlygate4sd1_1
XFILLER_14_357 VGND VGND VPWR VPWR sky130_fd_sc_hd__decap_6
X_10613_ clknet_leaf_108_clk _00743_ VGND VGND VPWR VPWR count_cycle\[36\] sky130_fd_sc_hd__dfxtp_1
XTAP_TAPCELL_ROW_12_525 VGND VPWR sky130_fd_sc_hd__tapvpwrvgnd_1
X_10544_ clknet_leaf_59_clk _00674_ VGND VGND VPWR VPWR reg_pc\[30\] sky130_fd_sc_hd__dfxtp_1
XFILLER_10_585 VGND VGND VPWR VPWR sky130_fd_sc_hd__decap_3
XFILLER_108_451 VGND VGND VPWR VPWR sky130_fd_sc_hd__decap_6
X_10475_ clknet_leaf_82_clk _00605_ VGND VGND VPWR VPWR count_instr\[24\] sky130_fd_sc_hd__dfxtp_1
XTAP_TAPCELL_ROW_94_1833 VGND VPWR sky130_fd_sc_hd__tapvpwrvgnd_1
Xrebuffer182 net569 VGND VGND VPWR VPWR net568 sky130_fd_sc_hd__clkbuf_2
Xrebuffer193 net580 VGND VGND VPWR VPWR net579 sky130_fd_sc_hd__dlygate4sd1_1
XFILLER_6_589 VGND VGND VPWR VPWR sky130_fd_sc_hd__decap_3
XFILLER_151_741 VPWR VGND VPWR VGND sky130_ef_sc_hd__decap_12
XFILLER_151_785 VPWR VGND VPWR VGND sky130_ef_sc_hd__decap_12
XFILLER_1_261 VPWR VGND VPWR VGND sky130_ef_sc_hd__decap_12
XFILLER_111_649 VGND VGND VPWR VPWR sky130_fd_sc_hd__fill_1
XFILLER_104_690 VGND VGND VPWR VPWR sky130_fd_sc_hd__fill_2
X_11027_ clknet_leaf_38_clk _01089_ VGND VGND VPWR VPWR cpuregs\[19\]\[27\] sky130_fd_sc_hd__dfxtp_1
XTAP_TAPCELL_ROW_125_2332 VGND VPWR sky130_fd_sc_hd__tapvpwrvgnd_1
XFILLER_92_533 VGND VGND VPWR VPWR sky130_fd_sc_hd__decap_8
XFILLER_65_758 VGND VGND VPWR VPWR sky130_fd_sc_hd__fill_2
XFILLER_37_449 VGND VGND VPWR VPWR sky130_fd_sc_hd__decap_4
XFILLER_92_555 VPWR VGND VPWR VGND sky130_ef_sc_hd__decap_12
Xclkbuf_leaf_29_clk clknet_4_4_0_clk VGND VGND VPWR VPWR clknet_leaf_29_clk sky130_fd_sc_hd__clkbuf_8
XFILLER_65_769 VPWR VGND VPWR VGND sky130_ef_sc_hd__decap_12
XFILLER_18_630 VPWR VGND VPWR VGND sky130_ef_sc_hd__decap_12
XFILLER_80_739 VGND VGND VPWR VPWR sky130_fd_sc_hd__decap_8
XFILLER_72_290 VGND VGND VPWR VPWR sky130_fd_sc_hd__decap_4
XFILLER_33_633 VGND VGND VPWR VPWR sky130_fd_sc_hd__decap_8
XTAP_TAPCELL_ROW_103_1973 VGND VPWR sky130_fd_sc_hd__tapvpwrvgnd_1
X_05450_ count_instr\[62\] instr_rdinstrh _01587_ _02034_ VGND VGND VPWR VPWR _02035_
+ sky130_fd_sc_hd__a211o_1
X_05381_ _01969_ _01970_ VGND VGND VPWR VPWR _01971_ sky130_fd_sc_hd__nand2b_1
XANTENNA_28 net218 VGND VGND VPWR VPWR sky130_fd_sc_hd__diode_2
XTAP_TAPCELL_ROW_103_1984 VGND VPWR sky130_fd_sc_hd__tapvpwrvgnd_1
XANTENNA_17 net19 VGND VGND VPWR VPWR sky130_fd_sc_hd__diode_2
XFILLER_21_839 VGND VGND VPWR VPWR sky130_fd_sc_hd__fill_1
XANTENNA_39 net201 VGND VGND VPWR VPWR sky130_fd_sc_hd__diode_2
XTAP_TAPCELL_ROW_31_823 VGND VPWR sky130_fd_sc_hd__tapvpwrvgnd_1
XTAP_TAPCELL_ROW_31_834 VGND VPWR sky130_fd_sc_hd__tapvpwrvgnd_1
XFILLER_146_502 VGND VGND VPWR VPWR sky130_fd_sc_hd__decap_3
XFILLER_119_716 VPWR VGND VPWR VGND sky130_ef_sc_hd__decap_12
X_07120_ _03525_ _03526_ _03527_ _03502_ VGND VGND VPWR VPWR _03528_ sky130_fd_sc_hd__a211o_1
XFILLER_13_390 VGND VGND VPWR VPWR sky130_fd_sc_hd__fill_2
X_07051_ _01579_ _03461_ VGND VGND VPWR VPWR _03462_ sky130_fd_sc_hd__or2_1
Xoutput113 net113 VGND VGND VPWR VPWR mem_la_wdata[24] sky130_fd_sc_hd__buf_2
X_06002_ net186 _02504_ _01582_ VGND VGND VPWR VPWR net79 sky130_fd_sc_hd__mux2_1
Xoutput102 net102 VGND VGND VPWR VPWR mem_la_wdata[14] sky130_fd_sc_hd__buf_2
Xoutput124 net124 VGND VGND VPWR VPWR mem_la_wdata[5] sky130_fd_sc_hd__buf_2
XFILLER_114_443 VGND VGND VPWR VPWR sky130_fd_sc_hd__decap_4
Xoutput135 net135 VGND VGND VPWR VPWR mem_wdata[0] sky130_fd_sc_hd__buf_2
Xoutput168 net168 VGND VGND VPWR VPWR mem_wstrb[1] sky130_fd_sc_hd__buf_2
Xoutput146 net146 VGND VGND VPWR VPWR mem_wdata[1] sky130_fd_sc_hd__buf_2
Xoutput157 net157 VGND VGND VPWR VPWR mem_wdata[2] sky130_fd_sc_hd__buf_2
Xoutput179 net179 VGND VGND VPWR VPWR pcpi_rs1[17] sky130_fd_sc_hd__buf_2
XFILLER_102_627 VGND VGND VPWR VPWR sky130_fd_sc_hd__fill_1
XFILLER_68_541 VGND VGND VPWR VPWR sky130_fd_sc_hd__decap_6
XFILLER_68_530 VGND VGND VPWR VPWR sky130_fd_sc_hd__fill_2
X_07953_ _03774_ _03776_ _03777_ VGND VGND VPWR VPWR _03779_ sky130_fd_sc_hd__and3_1
X_06904_ decoded_imm\[22\] net185 VGND VGND VPWR VPWR _03320_ sky130_fd_sc_hd__or2_1
X_07884_ _02705_ reg_next_pc\[30\] net596 VGND VGND VPWR VPWR _03718_ sky130_fd_sc_hd__mux2_2
XFILLER_68_574 VGND VGND VPWR VPWR sky130_fd_sc_hd__decap_3
XFILLER_68_552 VGND VGND VPWR VPWR sky130_fd_sc_hd__fill_2
X_06835_ cpuregs\[12\]\[19\] cpuregs\[13\]\[19\] cpuregs\[14\]\[19\] cpuregs\[15\]\[19\]
+ net267 net261 VGND VGND VPWR VPWR _03254_ sky130_fd_sc_hd__mux4_1
X_09623_ _02704_ cpuregs\[3\]\[29\] _04868_ VGND VGND VPWR VPWR _01283_ sky130_fd_sc_hd__mux2_1
XFILLER_110_682 VGND VGND VPWR VPWR sky130_fd_sc_hd__decap_6
XFILLER_95_393 VGND VGND VPWR VPWR sky130_fd_sc_hd__fill_1
XFILLER_46_29 VPWR VGND VPWR VGND sky130_ef_sc_hd__decap_12
XFILLER_55_246 VGND VGND VPWR VPWR sky130_fd_sc_hd__decap_4
XTAP_TAPCELL_ROW_39_956 VGND VPWR sky130_fd_sc_hd__tapvpwrvgnd_1
X_09554_ cpuregs\[23\]\[26\] _02691_ _04866_ VGND VGND VPWR VPWR _01216_ sky130_fd_sc_hd__mux2_1
X_06766_ decoded_imm\[17\] net179 VGND VGND VPWR VPWR _03187_ sky130_fd_sc_hd__xnor2_1
X_09485_ cpuregs\[24\]\[23\] _02678_ net241 VGND VGND VPWR VPWR _01149_ sky130_fd_sc_hd__mux2_1
X_06697_ cpuregs\[28\]\[14\] cpuregs\[29\]\[14\] cpuregs\[30\]\[14\] cpuregs\[31\]\[14\]
+ net265 net260 VGND VGND VPWR VPWR _03121_ sky130_fd_sc_hd__mux4_1
X_05717_ _02131_ _02238_ _02240_ _02133_ _02291_ VGND VGND VPWR VPWR _02292_ sky130_fd_sc_hd__a221o_1
XFILLER_36_493 VPWR VGND VPWR VGND sky130_ef_sc_hd__decap_12
X_08505_ net34 _01612_ _04210_ VGND VGND VPWR VPWR _00802_ sky130_fd_sc_hd__and3_1
X_08436_ _03525_ _03529_ _04171_ _01621_ VGND VGND VPWR VPWR _04173_ sky130_fd_sc_hd__a31oi_1
X_05648_ _02067_ _02230_ VGND VGND VPWR VPWR _02231_ sky130_fd_sc_hd__xor2_2
XTAP_TAPCELL_ROW_61_1309 VGND VPWR sky130_fd_sc_hd__tapvpwrvgnd_1
X_08367_ _04128_ net34 _04127_ VGND VGND VPWR VPWR _00746_ sky130_fd_sc_hd__and3b_1
XFILLER_24_699 VGND VGND VPWR VPWR sky130_fd_sc_hd__fill_1
XFILLER_149_373 VGND VGND VPWR VPWR sky130_fd_sc_hd__fill_2
X_05579_ net199 net125 VGND VGND VPWR VPWR _02162_ sky130_fd_sc_hd__nand2_1
X_07318_ cpuregs\[21\]\[2\] _02590_ net248 VGND VGND VPWR VPWR _00262_ sky130_fd_sc_hd__mux2_1
XFILLER_20_861 VGND VGND VPWR VPWR sky130_fd_sc_hd__decap_6
XFILLER_149_384 VGND VGND VPWR VPWR sky130_fd_sc_hd__decap_8
X_08298_ count_cycle\[15\] _04082_ net34 VGND VGND VPWR VPWR _04084_ sky130_fd_sc_hd__o21ai_1
X_07249_ cpuregs\[2\]\[0\] _02586_ net250 VGND VGND VPWR VPWR _00196_ sky130_fd_sc_hd__mux2_1
XFILLER_124_218 VGND VGND VPWR VPWR sky130_fd_sc_hd__fill_1
XTAP_TAPCELL_ROW_76_1552 VGND VPWR sky130_fd_sc_hd__tapvpwrvgnd_1
XTAP_TAPCELL_ROW_76_1541 VGND VPWR sky130_fd_sc_hd__tapvpwrvgnd_1
X_10260_ clknet_leaf_119_clk _00390_ VGND VGND VPWR VPWR cpuregs\[15\]\[2\] sky130_fd_sc_hd__dfxtp_1
XFILLER_3_559 VGND VGND VPWR VPWR sky130_fd_sc_hd__fill_1
XFILLER_133_785 VPWR VGND VPWR VGND sky130_ef_sc_hd__decap_12
XFILLER_132_262 VPWR VGND VPWR VGND sky130_ef_sc_hd__decap_12
X_10191_ clknet_leaf_34_clk _00321_ VGND VGND VPWR VPWR cpuregs\[9\]\[29\] sky130_fd_sc_hd__dfxtp_1
XFILLER_87_47 VGND VGND VPWR VPWR sky130_fd_sc_hd__decap_8
XFILLER_132_295 VGND VGND VPWR VPWR sky130_fd_sc_hd__decap_4
XFILLER_19_405 VGND VGND VPWR VPWR sky130_fd_sc_hd__fill_2
XFILLER_46_213 VPWR VGND VPWR VGND sky130_ef_sc_hd__decap_12
XTAP_TAPCELL_ROW_107_2051 VGND VPWR sky130_fd_sc_hd__tapvpwrvgnd_1
XTAP_TAPCELL_ROW_107_2040 VGND VPWR sky130_fd_sc_hd__tapvpwrvgnd_1
XFILLER_62_728 VGND VGND VPWR VPWR sky130_fd_sc_hd__decap_3
XFILLER_55_780 VGND VGND VPWR VPWR sky130_fd_sc_hd__decap_4
XFILLER_15_611 VGND VGND VPWR VPWR sky130_fd_sc_hd__decap_4
XTAP_TAPCELL_ROW_17_606 VGND VPWR sky130_fd_sc_hd__tapvpwrvgnd_1
XFILLER_27_482 VGND VGND VPWR VPWR sky130_fd_sc_hd__decap_4
XFILLER_36_95 VGND VGND VPWR VPWR sky130_fd_sc_hd__decap_8
XTAP_TAPCELL_ROW_120_2251 VGND VPWR sky130_fd_sc_hd__tapvpwrvgnd_1
XFILLER_42_463 VGND VGND VPWR VPWR sky130_fd_sc_hd__decap_3
XFILLER_52_94 VGND VGND VPWR VPWR sky130_fd_sc_hd__decap_6
XFILLER_52_83 VGND VGND VPWR VPWR sky130_fd_sc_hd__fill_1
Xinput26 mem_rdata[3] VGND VGND VPWR VPWR net26 sky130_fd_sc_hd__buf_1
Xinput15 mem_rdata[22] VGND VGND VPWR VPWR net15 sky130_fd_sc_hd__buf_2
XFILLER_7_821 VPWR VGND VPWR VGND sky130_ef_sc_hd__decap_12
XFILLER_143_505 VGND VGND VPWR VPWR sky130_fd_sc_hd__decap_8
X_10527_ clknet_leaf_96_clk _00657_ VGND VGND VPWR VPWR reg_pc\[13\] sky130_fd_sc_hd__dfxtp_1
XFILLER_7_865 VPWR VGND VPWR VGND sky130_ef_sc_hd__decap_12
X_10458_ clknet_leaf_106_clk _00588_ VGND VGND VPWR VPWR count_instr\[7\] sky130_fd_sc_hd__dfxtp_1
XFILLER_6_397 VGND VGND VPWR VPWR sky130_fd_sc_hd__fill_1
X_10389_ clknet_leaf_124_clk _00519_ VGND VGND VPWR VPWR cpuregs\[20\]\[3\] sky130_fd_sc_hd__dfxtp_1
XFILLER_123_273 VGND VGND VPWR VPWR sky130_fd_sc_hd__decap_6
XFILLER_97_636 VPWR VGND VPWR VGND sky130_ef_sc_hd__decap_12
XFILLER_2_581 VGND VGND VPWR VPWR sky130_fd_sc_hd__decap_6
X_04950_ mem_state\[0\] mem_state\[1\] VGND VGND VPWR VPWR _01583_ sky130_fd_sc_hd__nor2_1
XFILLER_77_393 VGND VGND VPWR VPWR sky130_fd_sc_hd__fill_2
XFILLER_65_511 VGND VGND VPWR VPWR sky130_fd_sc_hd__decap_8
XFILLER_65_555 VGND VGND VPWR VPWR sky130_fd_sc_hd__decap_4
XFILLER_65_544 VGND VGND VPWR VPWR sky130_fd_sc_hd__decap_4
XFILLER_53_706 VGND VGND VPWR VPWR sky130_fd_sc_hd__decap_4
X_06620_ cpuregs\[12\]\[11\] cpuregs\[13\]\[11\] cpuregs\[14\]\[11\] cpuregs\[15\]\[11\]
+ net268 net259 VGND VGND VPWR VPWR _03047_ sky130_fd_sc_hd__mux4_1
XTAP_TAPCELL_ROW_36_904 VGND VPWR sky130_fd_sc_hd__tapvpwrvgnd_1
XTAP_TAPCELL_ROW_36_915 VGND VPWR sky130_fd_sc_hd__tapvpwrvgnd_1
X_06551_ _02952_ _02955_ _02978_ _02951_ VGND VGND VPWR VPWR _02980_ sky130_fd_sc_hd__a211o_1
XFILLER_52_227 VGND VGND VPWR VPWR sky130_fd_sc_hd__fill_2
XFILLER_33_430 VPWR VGND VPWR VGND sky130_ef_sc_hd__decap_12
X_05502_ _02082_ _02083_ VGND VGND VPWR VPWR _02085_ sky130_fd_sc_hd__nor2_1
X_09270_ net135 net97 _04206_ VGND VGND VPWR VPWR _00956_ sky130_fd_sc_hd__mux2_1
X_06482_ cpuregs\[0\]\[6\] cpuregs\[1\]\[6\] cpuregs\[2\]\[6\] cpuregs\[3\]\[6\] net263
+ net259 VGND VGND VPWR VPWR _02914_ sky130_fd_sc_hd__mux4_1
X_08221_ instr_jal _04024_ _04025_ VGND VGND VPWR VPWR _04026_ sky130_fd_sc_hd__or3_1
X_05433_ _02017_ _02018_ VGND VGND VPWR VPWR _02019_ sky130_fd_sc_hd__or2_1
XFILLER_21_625 VGND VGND VPWR VPWR sky130_fd_sc_hd__decap_3
XTAP_TAPCELL_ROW_43_1017 VGND VPWR sky130_fd_sc_hd__tapvpwrvgnd_1
XTAP_TAPCELL_ROW_138_2545 VGND VPWR sky130_fd_sc_hd__tapvpwrvgnd_1
XTAP_TAPCELL_ROW_138_2534 VGND VPWR sky130_fd_sc_hd__tapvpwrvgnd_1
XFILLER_147_833 VGND VGND VPWR VPWR sky130_fd_sc_hd__decap_6
X_08152_ _01547_ reg_next_pc\[22\] _01645_ _03709_ VGND VGND VPWR VPWR _03963_ sky130_fd_sc_hd__a22o_1
X_05364_ _01922_ _01924_ _01953_ VGND VGND VPWR VPWR _01955_ sky130_fd_sc_hd__a21oi_1
XTAP_TAPCELL_ROW_151_2745 VGND VPWR sky130_fd_sc_hd__tapvpwrvgnd_1
XFILLER_147_877 VPWR VGND VPWR VGND sky130_ef_sc_hd__decap_12
XFILLER_146_365 VGND VGND VPWR VPWR sky130_fd_sc_hd__decap_3
X_07103_ _01579_ _03511_ VGND VGND VPWR VPWR _03512_ sky130_fd_sc_hd__or2_1
X_08083_ decoded_imm_j\[17\] _03704_ VGND VGND VPWR VPWR _03899_ sky130_fd_sc_hd__xor2_1
X_05295_ count_instr\[18\] instr_rdinstr count_cycle\[50\] instr_rdcycleh VGND VGND
+ VPWR VPWR _01892_ sky130_fd_sc_hd__a22o_1
Xclkbuf_leaf_9_clk clknet_4_1_0_clk VGND VGND VPWR VPWR clknet_leaf_9_clk sky130_fd_sc_hd__clkbuf_8
X_07034_ reg_pc\[26\] _02751_ _03445_ _02715_ VGND VGND VPWR VPWR _03446_ sky130_fd_sc_hd__a211o_1
XTAP_TAPCELL_ROW_58_1260 VGND VPWR sky130_fd_sc_hd__tapvpwrvgnd_1
XFILLER_115_785 VGND VGND VPWR VPWR sky130_fd_sc_hd__decap_6
XFILLER_114_251 VGND VGND VPWR VPWR sky130_fd_sc_hd__fill_1
X_08985_ _04649_ _04650_ _01558_ VGND VGND VPWR VPWR _04660_ sky130_fd_sc_hd__mux2_1
XFILLER_88_636 VGND VGND VPWR VPWR sky130_fd_sc_hd__decap_8
XFILLER_130_788 VPWR VGND VPWR VGND sky130_ef_sc_hd__decap_12
XFILLER_130_766 VGND VGND VPWR VPWR sky130_fd_sc_hd__fill_1
XTAP_TAPCELL_ROW_71_1471 VGND VPWR sky130_fd_sc_hd__tapvpwrvgnd_1
XTAP_TAPCELL_ROW_71_1460 VGND VPWR sky130_fd_sc_hd__tapvpwrvgnd_1
X_07936_ decoded_imm_j\[6\] _03693_ VGND VGND VPWR VPWR _03763_ sky130_fd_sc_hd__and2_1
XFILLER_96_691 VGND VGND VPWR VPWR sky130_fd_sc_hd__decap_8
XFILLER_84_831 VPWR VGND VPWR VGND sky130_ef_sc_hd__decap_12
X_07867_ _02671_ reg_next_pc\[22\] net597 VGND VGND VPWR VPWR _03709_ sky130_fd_sc_hd__mux2_2
XFILLER_113_23 VPWR VGND VPWR VGND sky130_ef_sc_hd__decap_12
XFILLER_84_875 VGND VGND VPWR VPWR sky130_fd_sc_hd__fill_2
XFILLER_56_533 VPWR VGND VPWR VGND sky130_ef_sc_hd__decap_12
XTAP_TAPCELL_ROW_3_378 VGND VPWR sky130_fd_sc_hd__tapvpwrvgnd_1
X_06818_ _01564_ net237 VGND VGND VPWR VPWR _03237_ sky130_fd_sc_hd__nor2_1
X_07798_ count_instr\[54\] _03669_ _01549_ VGND VGND VPWR VPWR _03671_ sky130_fd_sc_hd__a21oi_1
XFILLER_71_525 VPWR VGND VPWR VGND sky130_ef_sc_hd__decap_12
X_09606_ _02633_ cpuregs\[3\]\[12\] _04868_ VGND VGND VPWR VPWR _01266_ sky130_fd_sc_hd__mux2_1
X_06749_ cpuregs\[20\]\[16\] cpuregs\[21\]\[16\] cpuregs\[22\]\[16\] cpuregs\[23\]\[16\]
+ net265 net260 VGND VGND VPWR VPWR _03171_ sky130_fd_sc_hd__mux4_1
XFILLER_71_558 VGND VGND VPWR VPWR sky130_fd_sc_hd__fill_2
X_09537_ cpuregs\[23\]\[9\] _02621_ _04866_ VGND VGND VPWR VPWR _01199_ sky130_fd_sc_hd__mux2_1
XFILLER_43_238 VGND VGND VPWR VPWR sky130_fd_sc_hd__fill_1
XFILLER_24_463 VPWR VGND VPWR VGND sky130_ef_sc_hd__decap_12
XFILLER_11_113 VGND VGND VPWR VPWR sky130_fd_sc_hd__fill_2
X_09468_ cpuregs\[24\]\[6\] _02607_ net242 VGND VGND VPWR VPWR _01132_ sky130_fd_sc_hd__mux2_1
XFILLER_138_811 VGND VGND VPWR VPWR sky130_fd_sc_hd__fill_1
X_08419_ count_cycle\[59\] _04159_ VGND VGND VPWR VPWR _04161_ sky130_fd_sc_hd__and2_1
XFILLER_51_293 VPWR VGND VPWR VGND sky130_ef_sc_hd__decap_12
XFILLER_11_135 VPWR VGND VPWR VGND sky130_ef_sc_hd__decap_12
X_09399_ _02593_ cpuregs\[18\]\[3\] _04862_ VGND VGND VPWR VPWR _01033_ sky130_fd_sc_hd__mux2_1
XFILLER_149_181 VPWR VGND VPWR VGND sky130_ef_sc_hd__decap_12
X_11430_ clknet_leaf_40_clk _01474_ VGND VGND VPWR VPWR cpuregs\[8\]\[28\] sky130_fd_sc_hd__dfxtp_1
XTAP_TAPCELL_ROW_22_686 VGND VPWR sky130_fd_sc_hd__tapvpwrvgnd_1
XFILLER_125_3 VPWR VGND VPWR VGND sky130_ef_sc_hd__decap_12
X_11361_ clknet_leaf_42_clk _01405_ VGND VGND VPWR VPWR cpuregs\[6\]\[23\] sky130_fd_sc_hd__dfxtp_1
XFILLER_22_53 VPWR VGND VPWR VGND sky130_ef_sc_hd__decap_12
XFILLER_153_825 VGND VGND VPWR VPWR sky130_fd_sc_hd__decap_4
XFILLER_138_53 VPWR VGND VPWR VGND sky130_ef_sc_hd__decap_12
X_10312_ clknet_leaf_51_clk _00442_ VGND VGND VPWR VPWR cpuregs\[26\]\[22\] sky130_fd_sc_hd__dfxtp_1
XFILLER_98_35 VGND VGND VPWR VPWR sky130_fd_sc_hd__decap_6
XFILLER_4_813 VPWR VGND VPWR VGND sky130_ef_sc_hd__decap_12
XFILLER_153_869 VGND VGND VPWR VPWR sky130_fd_sc_hd__fill_2
X_11292_ clknet_leaf_75_clk _01339_ VGND VGND VPWR VPWR cpuregs\[4\]\[21\] sky130_fd_sc_hd__dfxtp_1
X_10243_ clknet_leaf_21_clk _00373_ VGND VGND VPWR VPWR cpuregs\[27\]\[17\] sky130_fd_sc_hd__dfxtp_1
XFILLER_133_582 VGND VGND VPWR VPWR sky130_fd_sc_hd__fill_1
X_10174_ clknet_leaf_12_clk _00304_ VGND VGND VPWR VPWR cpuregs\[9\]\[12\] sky130_fd_sc_hd__dfxtp_1
XTAP_TAPCELL_ROW_89_1754 VGND VPWR sky130_fd_sc_hd__tapvpwrvgnd_1
XFILLER_75_853 VGND VGND VPWR VPWR sky130_fd_sc_hd__fill_2
XFILLER_19_246 VPWR VGND VPWR VGND sky130_ef_sc_hd__decap_12
XFILLER_35_706 VGND VGND VPWR VPWR sky130_fd_sc_hd__decap_4
XFILLER_75_897 VGND VGND VPWR VPWR sky130_fd_sc_hd__decap_8
XFILLER_74_363 VGND VGND VPWR VPWR sky130_fd_sc_hd__fill_1
XFILLER_62_525 VGND VGND VPWR VPWR sky130_fd_sc_hd__decap_6
XFILLER_62_558 VGND VGND VPWR VPWR sky130_fd_sc_hd__decap_8
XFILLER_43_750 VGND VGND VPWR VPWR sky130_fd_sc_hd__fill_1
XFILLER_43_794 VGND VGND VPWR VPWR sky130_fd_sc_hd__fill_2
XTAP_TAPCELL_ROW_100_1932 VGND VPWR sky130_fd_sc_hd__tapvpwrvgnd_1
XFILLER_129_833 VGND VGND VPWR VPWR sky130_fd_sc_hd__decap_6
XTAP_TAPCELL_ROW_41_984 VGND VPWR sky130_fd_sc_hd__tapvpwrvgnd_1
XTAP_TAPCELL_ROW_41_995 VGND VPWR sky130_fd_sc_hd__tapvpwrvgnd_1
XFILLER_129_877 VPWR VGND VPWR VGND sky130_ef_sc_hd__decap_12
XFILLER_8_77 VGND VGND VPWR VPWR sky130_fd_sc_hd__decap_6
XFILLER_144_825 VPWR VGND VPWR VGND sky130_ef_sc_hd__decap_12
XTAP_TAPCELL_ROW_133_2453 VGND VPWR sky130_fd_sc_hd__tapvpwrvgnd_1
XFILLER_128_376 VGND VGND VPWR VPWR sky130_fd_sc_hd__decap_8
XFILLER_128_365 VGND VGND VPWR VPWR sky130_fd_sc_hd__fill_2
XFILLER_7_673 VGND VGND VPWR VPWR sky130_fd_sc_hd__decap_6
XFILLER_144_869 VPWR VGND VPWR VGND sky130_ef_sc_hd__decap_12
XTAP_TAPCELL_ROW_133_2464 VGND VPWR sky130_fd_sc_hd__tapvpwrvgnd_1
XFILLER_7_695 VGND VGND VPWR VPWR sky130_fd_sc_hd__decap_6
X_05080_ reg_pc\[2\] decoded_imm\[2\] VGND VGND VPWR VPWR _01693_ sky130_fd_sc_hd__nand2_1
XFILLER_143_368 VGND VGND VPWR VPWR sky130_fd_sc_hd__decap_8
XFILLER_69_102 VGND VGND VPWR VPWR sky130_fd_sc_hd__decap_8
XFILLER_112_755 VGND VGND VPWR VPWR sky130_fd_sc_hd__fill_1
XFILLER_97_466 VPWR VGND VPWR VGND sky130_ef_sc_hd__decap_12
XFILLER_85_617 VGND VGND VPWR VPWR sky130_fd_sc_hd__fill_2
XFILLER_58_809 VGND VGND VPWR VPWR sky130_fd_sc_hd__decap_3
XFILLER_57_308 VGND VGND VPWR VPWR sky130_fd_sc_hd__fill_1
X_05982_ net175 _02494_ _01582_ VGND VGND VPWR VPWR net69 sky130_fd_sc_hd__mux2_2
X_08770_ decoded_imm\[15\] _01654_ _01586_ VGND VGND VPWR VPWR _04457_ sky130_fd_sc_hd__a21o_1
XFILLER_38_511 VGND VGND VPWR VPWR sky130_fd_sc_hd__fill_2
X_04933_ net188 VGND VGND VPWR VPWR _01566_ sky130_fd_sc_hd__inv_2
X_07721_ count_instr\[25\] _03620_ net34 VGND VGND VPWR VPWR _03623_ sky130_fd_sc_hd__o21ai_1
XFILLER_66_853 VGND VGND VPWR VPWR sky130_fd_sc_hd__fill_1
XFILLER_65_330 VGND VGND VPWR VPWR sky130_fd_sc_hd__fill_1
XFILLER_38_533 VGND VGND VPWR VPWR sky130_fd_sc_hd__decap_4
XFILLER_38_555 VPWR VGND VPWR VGND sky130_ef_sc_hd__decap_12
XFILLER_81_823 VGND VGND VPWR VPWR sky130_fd_sc_hd__fill_1
X_07652_ _03577_ _03578_ VGND VGND VPWR VPWR _00581_ sky130_fd_sc_hd__nor2_1
XTAP_TAPCELL_ROW_0_315 VGND VPWR sky130_fd_sc_hd__tapvpwrvgnd_1
XTAP_TAPCELL_ROW_0_326 VGND VPWR sky130_fd_sc_hd__tapvpwrvgnd_1
XTAP_TAPCELL_ROW_0_337 VGND VPWR sky130_fd_sc_hd__tapvpwrvgnd_1
XFILLER_38_577 VGND VGND VPWR VPWR sky130_fd_sc_hd__decap_8
XFILLER_81_867 VGND VGND VPWR VPWR sky130_fd_sc_hd__fill_2
XFILLER_65_396 VGND VGND VPWR VPWR sky130_fd_sc_hd__decap_8
X_06603_ _03011_ _03015_ _03030_ net236 VGND VGND VPWR VPWR _03031_ sky130_fd_sc_hd__o211a_1
X_07583_ cpuregs\[20\]\[0\] _02586_ net245 VGND VGND VPWR VPWR _00516_ sky130_fd_sc_hd__mux2_1
XFILLER_22_901 VGND VGND VPWR VPWR sky130_fd_sc_hd__fill_1
X_06534_ cpuregs\[0\]\[8\] cpuregs\[1\]\[8\] cpuregs\[2\]\[8\] cpuregs\[3\]\[8\] net263
+ net259 VGND VGND VPWR VPWR _02964_ sky130_fd_sc_hd__mux4_1
X_09322_ is_slli_srli_srai decoded_imm_j\[1\] _04820_ cpu_state\[4\] VGND VGND VPWR
+ VPWR _04821_ sky130_fd_sc_hd__a211o_1
XFILLER_43_19 VPWR VGND VPWR VGND sky130_ef_sc_hd__decap_12
XFILLER_61_591 VGND VGND VPWR VPWR sky130_fd_sc_hd__fill_2
X_09253_ _04741_ _04742_ _04794_ _02514_ is_alu_reg_imm VGND VGND VPWR VPWR _00950_
+ sky130_fd_sc_hd__a32o_1
X_06465_ _02872_ _02876_ _02877_ VGND VGND VPWR VPWR _02897_ sky130_fd_sc_hd__and3_1
X_08204_ decoded_imm_j\[20\] _03714_ VGND VGND VPWR VPWR _04010_ sky130_fd_sc_hd__nand2_1
X_05416_ _01982_ _01993_ _02002_ VGND VGND VPWR VPWR _02003_ sky130_fd_sc_hd__or3_1
X_09184_ mem_rdata_q\[28\] net21 _01609_ VGND VGND VPWR VPWR _01122_ sky130_fd_sc_hd__mux2_1
X_06396_ cpuregs\[4\]\[3\] cpuregs\[5\]\[3\] cpuregs\[6\]\[3\] cpuregs\[7\]\[3\] net268
+ net262 VGND VGND VPWR VPWR _02831_ sky130_fd_sc_hd__mux4_1
XFILLER_147_641 VPWR VGND VPWR VGND sky130_ef_sc_hd__decap_12
X_08135_ _03940_ _03946_ VGND VGND VPWR VPWR _03947_ sky130_fd_sc_hd__or2_1
X_05347_ count_cycle\[22\] _01588_ _01674_ _01939_ VGND VGND VPWR VPWR _01940_ sky130_fd_sc_hd__o211a_1
XFILLER_147_685 VGND VGND VPWR VPWR sky130_fd_sc_hd__decap_6
XFILLER_4_109 VPWR VGND VPWR VGND sky130_ef_sc_hd__decap_12
XFILLER_146_195 VGND VGND VPWR VPWR sky130_fd_sc_hd__fill_1
XFILLER_134_335 VGND VGND VPWR VPWR sky130_fd_sc_hd__fill_1
XFILLER_108_23 VGND VGND VPWR VPWR sky130_fd_sc_hd__decap_4
XFILLER_107_549 VGND VGND VPWR VPWR sky130_fd_sc_hd__decap_8
X_05278_ reg_pc\[17\] decoded_imm\[17\] VGND VGND VPWR VPWR _01876_ sky130_fd_sc_hd__xor2_2
X_08066_ _03881_ _03882_ VGND VGND VPWR VPWR _03883_ sky130_fd_sc_hd__xnor2_1
XTAP_TAPCELL_ROW_73_1500 VGND VPWR sky130_fd_sc_hd__tapvpwrvgnd_1
Xpicorv32_360 VGND VGND VPWR VPWR picorv32_360/HI trace_data[10] sky130_fd_sc_hd__conb_1
Xpicorv32_371 VGND VGND VPWR VPWR picorv32_371/HI trace_data[21] sky130_fd_sc_hd__conb_1
XFILLER_103_700 VGND VGND VPWR VPWR sky130_fd_sc_hd__fill_1
X_07017_ net185 _02721_ _02744_ _03428_ VGND VGND VPWR VPWR _03429_ sky130_fd_sc_hd__o211a_1
XFILLER_68_49 VGND VGND VPWR VPWR sky130_fd_sc_hd__fill_1
XTAP_TAPCELL_ROW_8_459 VGND VPWR sky130_fd_sc_hd__tapvpwrvgnd_1
XFILLER_0_337 VGND VGND VPWR VPWR sky130_fd_sc_hd__fill_2
Xpicorv32_382 VGND VGND VPWR VPWR picorv32_382/HI trace_data[32] sky130_fd_sc_hd__conb_1
XFILLER_88_477 VPWR VGND VPWR VGND sky130_ef_sc_hd__decap_12
X_08968_ net269 _04643_ _01559_ VGND VGND VPWR VPWR _04644_ sky130_fd_sc_hd__a21o_1
X_08899_ cpuregs\[28\]\[23\] cpuregs\[29\]\[23\] cpuregs\[30\]\[23\] cpuregs\[31\]\[23\]
+ net276 net272 VGND VGND VPWR VPWR _04578_ sky130_fd_sc_hd__mux4_1
X_07919_ _03745_ _03746_ _03747_ instr_jal VGND VGND VPWR VPWR _03748_ sky130_fd_sc_hd__o22a_1
XFILLER_57_897 VGND VGND VPWR VPWR sky130_fd_sc_hd__fill_2
XFILLER_56_363 VGND VGND VPWR VPWR sky130_fd_sc_hd__fill_1
X_10930_ clknet_leaf_112_clk _00992_ VGND VGND VPWR VPWR latched_rd\[0\] sky130_fd_sc_hd__dfxtp_4
XFILLER_29_599 VPWR VGND VPWR VGND sky130_ef_sc_hd__decap_12
XFILLER_44_536 VPWR VGND VPWR VGND sky130_ef_sc_hd__decap_12
XFILLER_140_65 VPWR VGND VPWR VGND sky130_ef_sc_hd__decap_12
X_10861_ clknet_leaf_142_clk _00923_ VGND VGND VPWR VPWR cpuregs\[1\]\[5\] sky130_fd_sc_hd__dfxtp_1
XFILLER_16_249 VGND VGND VPWR VPWR sky130_fd_sc_hd__decap_3
XTAP_TAPCELL_ROW_27_756 VGND VPWR sky130_fd_sc_hd__tapvpwrvgnd_1
XTAP_TAPCELL_ROW_27_767 VGND VPWR sky130_fd_sc_hd__tapvpwrvgnd_1
XFILLER_31_208 VPWR VGND VPWR VGND sky130_ef_sc_hd__decap_12
XTAP_TAPCELL_ROW_84_1673 VGND VPWR sky130_fd_sc_hd__tapvpwrvgnd_1
XFILLER_71_399 VGND VGND VPWR VPWR sky130_fd_sc_hd__fill_2
X_10792_ clknet_leaf_98_clk _00857_ VGND VGND VPWR VPWR instr_lbu sky130_fd_sc_hd__dfxtp_1
XFILLER_8_437 VGND VGND VPWR VPWR sky130_fd_sc_hd__fill_1
XFILLER_8_415 VGND VGND VPWR VPWR sky130_fd_sc_hd__decap_4
XFILLER_33_63 VGND VGND VPWR VPWR sky130_fd_sc_hd__fill_1
X_11413_ clknet_leaf_147_clk _01457_ VGND VGND VPWR VPWR cpuregs\[8\]\[11\] sky130_fd_sc_hd__dfxtp_1
XFILLER_126_825 VPWR VGND VPWR VGND sky130_ef_sc_hd__decap_12
XFILLER_152_121 VPWR VGND VPWR VGND sky130_ef_sc_hd__decap_12
XFILLER_126_869 VPWR VGND VPWR VGND sky130_ef_sc_hd__decap_12
XTAP_TAPCELL_ROW_115_2172 VGND VPWR sky130_fd_sc_hd__tapvpwrvgnd_1
XFILLER_4_643 VGND VGND VPWR VPWR sky130_fd_sc_hd__fill_1
X_11344_ clknet_leaf_4_clk _01388_ VGND VGND VPWR VPWR cpuregs\[6\]\[6\] sky130_fd_sc_hd__dfxtp_1
XFILLER_152_165 VPWR VGND VPWR VGND sky130_ef_sc_hd__decap_12
XFILLER_141_839 VGND VGND VPWR VPWR sky130_fd_sc_hd__fill_1
X_11275_ clknet_leaf_137_clk _01322_ VGND VGND VPWR VPWR cpuregs\[4\]\[4\] sky130_fd_sc_hd__dfxtp_1
XPHY_EDGE_ROW_148_Right_148 VGND VGND VPWR VPWR sky130_fd_sc_hd__decap_3
XFILLER_106_582 VGND VGND VPWR VPWR sky130_fd_sc_hd__decap_6
XPHY_EDGE_ROW_18_Left_172 VGND VGND VPWR VPWR sky130_fd_sc_hd__decap_3
X_10226_ clknet_leaf_118_clk _00356_ VGND VGND VPWR VPWR cpuregs\[27\]\[0\] sky130_fd_sc_hd__dfxtp_1
X_10157_ clknet_leaf_34_clk _00287_ VGND VGND VPWR VPWR cpuregs\[21\]\[27\] sky130_fd_sc_hd__dfxtp_1
XFILLER_58_82 VGND VGND VPWR VPWR sky130_fd_sc_hd__fill_2
XFILLER_0_860 VGND VGND VPWR VPWR sky130_fd_sc_hd__decap_4
X_10088_ clknet_leaf_46_clk _00218_ VGND VGND VPWR VPWR cpuregs\[2\]\[22\] sky130_fd_sc_hd__dfxtp_1
XFILLER_35_503 VGND VGND VPWR VPWR sky130_fd_sc_hd__fill_1
XFILLER_74_81 VGND VGND VPWR VPWR sky130_fd_sc_hd__decap_3
XFILLER_62_355 VGND VGND VPWR VPWR sky130_fd_sc_hd__fill_2
XPHY_EDGE_ROW_27_Left_181 VGND VGND VPWR VPWR sky130_fd_sc_hd__decap_3
XFILLER_35_569 VGND VGND VPWR VPWR sky130_fd_sc_hd__decap_4
XFILLER_148_449 VGND VGND VPWR VPWR sky130_fd_sc_hd__decap_6
X_06250_ reg_pc\[26\] _02686_ reg_pc\[27\] VGND VGND VPWR VPWR _02693_ sky130_fd_sc_hd__a21oi_1
XFILLER_88_3 VGND VGND VPWR VPWR sky130_fd_sc_hd__decap_3
X_05201_ _01771_ _01804_ cpu_state\[6\] VGND VGND VPWR VPWR _01805_ sky130_fd_sc_hd__o21a_1
XFILLER_30_274 VGND VGND VPWR VPWR sky130_fd_sc_hd__decap_6
X_06181_ _02583_ _02634_ _02637_ VGND VGND VPWR VPWR _02638_ sky130_fd_sc_hd__a21bo_4
X_05132_ reg_pc\[6\] decoded_imm\[6\] VGND VGND VPWR VPWR _01741_ sky130_fd_sc_hd__nand2_1
XFILLER_132_806 VGND VGND VPWR VPWR sky130_fd_sc_hd__decap_6
X_05063_ count_instr\[32\] instr_rdinstrh instr_rdinstr count_instr\[0\] VGND VGND
+ VPWR VPWR _01678_ sky130_fd_sc_hd__a22o_1
XPHY_EDGE_ROW_36_Left_190 VGND VGND VPWR VPWR sky130_fd_sc_hd__decap_3
X_09940_ clknet_leaf_127_clk _00070_ VGND VGND VPWR VPWR net182 sky130_fd_sc_hd__dfxtp_4
XPHY_EDGE_ROW_115_Right_115 VGND VGND VPWR VPWR sky130_fd_sc_hd__decap_3
XFILLER_98_720 VGND VGND VPWR VPWR sky130_fd_sc_hd__decap_4
XFILLER_140_861 VGND VGND VPWR VPWR sky130_fd_sc_hd__decap_6
X_09871_ cpuregs\[0\]\[1\] VGND VGND VPWR VPWR _01479_ sky130_fd_sc_hd__clkbuf_1
XTAP_TAPCELL_ROW_5_418 VGND VPWR sky130_fd_sc_hd__tapvpwrvgnd_1
XTAP_TAPCELL_ROW_5_407 VGND VPWR sky130_fd_sc_hd__tapvpwrvgnd_1
X_08822_ net269 _04504_ _01559_ VGND VGND VPWR VPWR _04506_ sky130_fd_sc_hd__a21o_1
XFILLER_58_628 VGND VGND VPWR VPWR sky130_fd_sc_hd__fill_1
XTAP_TAPCELL_ROW_51_1149 VGND VPWR sky130_fd_sc_hd__tapvpwrvgnd_1
XTAP_TAPCELL_ROW_146_2666 VGND VPWR sky130_fd_sc_hd__tapvpwrvgnd_1
XFILLER_100_769 VGND VGND VPWR VPWR sky130_fd_sc_hd__decap_8
X_08753_ cpuregs\[24\]\[15\] cpuregs\[25\]\[15\] cpuregs\[26\]\[15\] cpuregs\[27\]\[15\]
+ net277 net272 VGND VGND VPWR VPWR _04440_ sky130_fd_sc_hd__mux4_1
X_05965_ reg_out\[5\] reg_next_pc\[5\] net597 VGND VGND VPWR VPWR _02486_ sky130_fd_sc_hd__mux2_1
X_04916_ net34 VGND VGND VPWR VPWR _01549_ sky130_fd_sc_hd__inv_16
X_07704_ _03610_ _03611_ VGND VGND VPWR VPWR _00600_ sky130_fd_sc_hd__nor2_1
XFILLER_39_897 VGND VGND VPWR VPWR sky130_fd_sc_hd__decap_4
X_05896_ _02078_ _02450_ VGND VGND VPWR VPWR _02451_ sky130_fd_sc_hd__xnor2_1
XFILLER_81_642 VGND VGND VPWR VPWR sky130_fd_sc_hd__decap_4
X_08684_ net270 _04374_ VGND VGND VPWR VPWR _04375_ sky130_fd_sc_hd__or2_1
X_07635_ _02662_ cpuregs\[17\]\[19\] _03574_ VGND VGND VPWR VPWR _00567_ sky130_fd_sc_hd__mux2_1
XFILLER_81_664 VGND VGND VPWR VPWR sky130_fd_sc_hd__fill_2
XFILLER_80_130 VGND VGND VPWR VPWR sky130_fd_sc_hd__fill_1
X_07566_ cpuregs\[25\]\[17\] _02654_ _03571_ VGND VGND VPWR VPWR _00501_ sky130_fd_sc_hd__mux2_1
XTAP_TAPCELL_ROW_66_1381 VGND VPWR sky130_fd_sc_hd__tapvpwrvgnd_1
XTAP_TAPCELL_ROW_24_715 VGND VPWR sky130_fd_sc_hd__tapvpwrvgnd_1
XFILLER_41_517 VGND VGND VPWR VPWR sky130_fd_sc_hd__fill_2
X_09305_ net131 _04208_ _04812_ _04207_ VGND VGND VPWR VPWR _00989_ sky130_fd_sc_hd__o211a_1
XTAP_TAPCELL_ROW_66_1392 VGND VPWR sky130_fd_sc_hd__tapvpwrvgnd_1
X_06517_ _02714_ _02930_ _02932_ _02947_ VGND VGND VPWR VPWR _02948_ sky130_fd_sc_hd__o31a_1
XFILLER_139_449 VGND VGND VPWR VPWR sky130_fd_sc_hd__decap_3
X_09236_ cpuregs\[1\]\[15\] _02646_ net244 VGND VGND VPWR VPWR _00933_ sky130_fd_sc_hd__mux2_1
X_07497_ cpuregs\[26\]\[15\] _02646_ _03568_ VGND VGND VPWR VPWR _00435_ sky130_fd_sc_hd__mux2_1
XPHY_EDGE_ROW_17_Right_17 VGND VGND VPWR VPWR sky130_fd_sc_hd__decap_3
X_06448_ net197 _02721_ VGND VGND VPWR VPWR _02881_ sky130_fd_sc_hd__or2_1
XFILLER_119_151 VGND VGND VPWR VPWR sky130_fd_sc_hd__decap_8
X_09167_ mem_rdata_q\[26\] mem_rdata_q\[25\] mem_rdata_q\[24\] mem_rdata_q\[27\] VGND
+ VGND VPWR VPWR _04784_ sky130_fd_sc_hd__or4b_1
X_06379_ cpuregs\[28\]\[3\] cpuregs\[29\]\[3\] cpuregs\[30\]\[3\] cpuregs\[31\]\[3\]
+ net268 net262 VGND VGND VPWR VPWR _02814_ sky130_fd_sc_hd__mux4_1
XFILLER_119_55 VGND VGND VPWR VPWR sky130_fd_sc_hd__fill_1
XFILLER_108_858 VGND VGND VPWR VPWR sky130_fd_sc_hd__decap_3
X_08118_ _03929_ _03930_ instr_jal VGND VGND VPWR VPWR _03931_ sky130_fd_sc_hd__o21ai_1
X_09098_ mem_rdata_q\[14\] _04751_ VGND VGND VPWR VPWR _04752_ sky130_fd_sc_hd__nor2_1
X_08049_ decoded_imm_j\[15\] _03702_ VGND VGND VPWR VPWR _03867_ sky130_fd_sc_hd__nor2_1
XFILLER_123_839 VGND VGND VPWR VPWR sky130_fd_sc_hd__fill_1
XFILLER_1_613 VGND VGND VPWR VPWR sky130_fd_sc_hd__decap_3
X_11060_ clknet_leaf_111_clk _01117_ VGND VGND VPWR VPWR mem_rdata_q\[23\] sky130_fd_sc_hd__dfxtp_1
XFILLER_49_606 VGND VGND VPWR VPWR sky130_fd_sc_hd__decap_8
XFILLER_1_657 VPWR VGND VPWR VGND sky130_ef_sc_hd__decap_12
X_10011_ clknet_leaf_147_clk _00141_ VGND VGND VPWR VPWR cpuregs\[30\]\[9\] sky130_fd_sc_hd__dfxtp_1
XTAP_TAPCELL_ROW_110_2091 VGND VPWR sky130_fd_sc_hd__tapvpwrvgnd_1
XFILLER_95_47 VGND VGND VPWR VPWR sky130_fd_sc_hd__decap_8
XPHY_EDGE_ROW_26_Right_26 VGND VGND VPWR VPWR sky130_fd_sc_hd__decap_3
XFILLER_28_41 VPWR VGND VPWR VGND sky130_ef_sc_hd__decap_12
XTAP_TAPCELL_ROW_86_1713 VGND VPWR sky130_fd_sc_hd__tapvpwrvgnd_1
XTAP_TAPCELL_ROW_86_1702 VGND VPWR sky130_fd_sc_hd__tapvpwrvgnd_1
X_10913_ clknet_leaf_45_clk _00975_ VGND VGND VPWR VPWR net145 sky130_fd_sc_hd__dfxtp_1
XFILLER_32_506 VGND VGND VPWR VPWR sky130_fd_sc_hd__fill_1
XFILLER_72_686 VPWR VGND VPWR VGND sky130_ef_sc_hd__decap_12
X_10844_ clknet_leaf_128_clk _00909_ VGND VGND VPWR VPWR decoded_imm_j\[2\] sky130_fd_sc_hd__dfxtp_2
X_10775_ clknet_leaf_50_clk alu_out\[28\] VGND VGND VPWR VPWR alu_out_q\[28\] sky130_fd_sc_hd__dfxtp_1
XPHY_EDGE_ROW_35_Right_35 VGND VGND VPWR VPWR sky130_fd_sc_hd__decap_3
XTAP_TAPCELL_ROW_117_2201 VGND VPWR sky130_fd_sc_hd__tapvpwrvgnd_1
XFILLER_13_797 VPWR VGND VPWR VGND sky130_ef_sc_hd__decap_12
XFILLER_138_471 VGND VGND VPWR VPWR sky130_fd_sc_hd__decap_4
XFILLER_9_779 VGND VGND VPWR VPWR sky130_fd_sc_hd__decap_4
XTAP_TAPCELL_ROW_97_1886 VGND VPWR sky130_fd_sc_hd__tapvpwrvgnd_1
XTAP_TAPCELL_ROW_10_486 VGND VPWR sky130_fd_sc_hd__tapvpwrvgnd_1
XFILLER_153_441 VGND VGND VPWR VPWR sky130_fd_sc_hd__decap_3
XFILLER_141_614 VGND VGND VPWR VPWR sky130_fd_sc_hd__fill_2
X_11327_ clknet_leaf_67_clk _01374_ VGND VGND VPWR VPWR cpuregs\[5\]\[24\] sky130_fd_sc_hd__dfxtp_1
XTAP_TAPCELL_ROW_130_2412 VGND VPWR sky130_fd_sc_hd__tapvpwrvgnd_1
XFILLER_126_677 VGND VGND VPWR VPWR sky130_fd_sc_hd__decap_6
XFILLER_125_165 VGND VGND VPWR VPWR sky130_fd_sc_hd__decap_3
XFILLER_99_517 VPWR VGND VPWR VGND sky130_ef_sc_hd__decap_12
XTAP_TAPCELL_ROW_10_497 VGND VPWR sky130_fd_sc_hd__tapvpwrvgnd_1
X_11258_ clknet_leaf_72_clk _01305_ VGND VGND VPWR VPWR cpuregs\[22\]\[19\] sky130_fd_sc_hd__dfxtp_1
XFILLER_122_861 VGND VGND VPWR VPWR sky130_fd_sc_hd__decap_6
XPHY_EDGE_ROW_44_Right_44 VGND VGND VPWR VPWR sky130_fd_sc_hd__decap_3
X_11189_ clknet_leaf_24_clk _01236_ VGND VGND VPWR VPWR cpuregs\[29\]\[14\] sky130_fd_sc_hd__dfxtp_1
X_10209_ clknet_leaf_11_clk _00339_ VGND VGND VPWR VPWR cpuregs\[14\]\[15\] sky130_fd_sc_hd__dfxtp_1
XFILLER_121_393 VGND VGND VPWR VPWR sky130_fd_sc_hd__fill_1
XTAP_TAPCELL_ROW_128_2385 VGND VPWR sky130_fd_sc_hd__tapvpwrvgnd_1
XTAP_TAPCELL_ROW_128_2374 VGND VPWR sky130_fd_sc_hd__tapvpwrvgnd_1
XFILLER_95_778 VGND VGND VPWR VPWR sky130_fd_sc_hd__decap_6
XFILLER_94_266 VPWR VGND VPWR VGND sky130_ef_sc_hd__decap_12
X_05750_ _02155_ _02237_ VGND VGND VPWR VPWR _02321_ sky130_fd_sc_hd__and2b_1
XFILLER_82_439 VPWR VGND VPWR VGND sky130_ef_sc_hd__decap_12
XFILLER_35_300 VGND VGND VPWR VPWR sky130_fd_sc_hd__decap_8
X_05681_ _02127_ _02260_ _02241_ VGND VGND VPWR VPWR _02261_ sky130_fd_sc_hd__o21ai_1
XFILLER_36_867 VGND VGND VPWR VPWR sky130_fd_sc_hd__fill_1
XFILLER_47_193 VGND VGND VPWR VPWR sky130_fd_sc_hd__fill_2
XTAP_TAPCELL_ROW_141_2585 VGND VPWR sky130_fd_sc_hd__tapvpwrvgnd_1
XFILLER_51_837 VGND VGND VPWR VPWR sky130_fd_sc_hd__decap_3
X_07420_ cpuregs\[27\]\[4\] _02598_ _03566_ VGND VGND VPWR VPWR _00360_ sky130_fd_sc_hd__mux2_1
XPHY_EDGE_ROW_53_Right_53 VGND VGND VPWR VPWR sky130_fd_sc_hd__decap_3
X_07351_ _02590_ cpuregs\[9\]\[2\] _03563_ VGND VGND VPWR VPWR _00294_ sky130_fd_sc_hd__mux2_1
X_06302_ cpuregs\[24\]\[0\] cpuregs\[25\]\[0\] cpuregs\[26\]\[0\] cpuregs\[27\]\[0\]
+ net268 net262 VGND VGND VPWR VPWR _02740_ sky130_fd_sc_hd__mux4_1
X_07282_ cpuregs\[28\]\[0\] _02586_ net249 VGND VGND VPWR VPWR _00228_ sky130_fd_sc_hd__mux2_1
XFILLER_136_408 VGND VGND VPWR VPWR sky130_fd_sc_hd__decap_3
X_06233_ reg_out\[24\] alu_out_q\[24\] net587 VGND VGND VPWR VPWR _02679_ sky130_fd_sc_hd__mux2_1
X_09021_ net270 _04689_ _04688_ _01560_ VGND VGND VPWR VPWR _04694_ sky130_fd_sc_hd__o211a_1
XFILLER_117_633 VGND VGND VPWR VPWR sky130_fd_sc_hd__fill_1
XFILLER_116_110 VPWR VGND VPWR VGND sky130_ef_sc_hd__decap_12
X_06164_ _02622_ _02623_ _02584_ VGND VGND VPWR VPWR _02624_ sky130_fd_sc_hd__mux2_8
X_05115_ instr_rdcycleh count_cycle\[36\] net257 _01725_ VGND VGND VPWR VPWR _01726_
+ sky130_fd_sc_hd__a211o_1
XFILLER_131_113 VPWR VGND VPWR VGND sky130_ef_sc_hd__decap_12
XPHY_EDGE_ROW_62_Right_62 VGND VGND VPWR VPWR sky130_fd_sc_hd__decap_3
X_06095_ _00010_ _02565_ _00011_ VGND VGND VPWR VPWR _02566_ sky130_fd_sc_hd__a21o_1
XTAP_TAPCELL_ROW_148_2706 VGND VPWR sky130_fd_sc_hd__tapvpwrvgnd_1
XFILLER_132_669 VGND VGND VPWR VPWR sky130_fd_sc_hd__fill_1
X_09923_ clknet_leaf_74_clk _00058_ VGND VGND VPWR VPWR cpuregs\[11\]\[21\] sky130_fd_sc_hd__dfxtp_1
XFILLER_120_809 VGND VGND VPWR VPWR sky130_fd_sc_hd__decap_3
XFILLER_113_861 VGND VGND VPWR VPWR sky130_fd_sc_hd__fill_1
X_05046_ is_sb_sh_sw _01649_ _01653_ _01656_ _01663_ VGND VGND VPWR VPWR _00022_ sky130_fd_sc_hd__a41o_1
X_09854_ _02699_ cpuregs\[10\]\[28\] _04876_ VGND VGND VPWR VPWR _01538_ sky130_fd_sc_hd__mux2_1
XFILLER_112_371 VGND VGND VPWR VPWR sky130_fd_sc_hd__decap_6
XFILLER_98_583 VGND VGND VPWR VPWR sky130_fd_sc_hd__decap_4
XFILLER_86_701 VGND VGND VPWR VPWR sky130_fd_sc_hd__fill_1
XFILLER_58_403 VGND VGND VPWR VPWR sky130_fd_sc_hd__fill_2
XFILLER_112_382 VGND VGND VPWR VPWR sky130_fd_sc_hd__fill_2
XFILLER_105_57 VGND VGND VPWR VPWR sky130_fd_sc_hd__decap_4
XFILLER_105_35 VPWR VGND VPWR VGND sky130_ef_sc_hd__decap_12
X_08805_ decoded_imm\[17\] _01654_ _01586_ VGND VGND VPWR VPWR _04490_ sky130_fd_sc_hd__a21o_1
X_09785_ _02688_ cpuregs\[7\]\[25\] _04874_ VGND VGND VPWR VPWR _01439_ sky130_fd_sc_hd__mux2_1
X_06997_ _01579_ _03409_ VGND VGND VPWR VPWR _03410_ sky130_fd_sc_hd__or2_1
XFILLER_85_266 VPWR VGND VPWR VGND sky130_ef_sc_hd__decap_12
XFILLER_65_39 VPWR VGND VPWR VGND sky130_ef_sc_hd__decap_12
X_05948_ net125 net217 _01665_ VGND VGND VPWR VPWR net111 sky130_fd_sc_hd__mux2_1
X_08736_ cpuregs\[20\]\[14\] cpuregs\[21\]\[14\] cpuregs\[22\]\[14\] cpuregs\[23\]\[14\]
+ net277 net271 VGND VGND VPWR VPWR _04424_ sky130_fd_sc_hd__mux4_1
XTAP_TAPCELL_ROW_68_1421 VGND VPWR sky130_fd_sc_hd__tapvpwrvgnd_1
XFILLER_66_491 VGND VGND VPWR VPWR sky130_fd_sc_hd__decap_4
XFILLER_38_182 VGND VGND VPWR VPWR sky130_fd_sc_hd__fill_2
X_05879_ _02054_ _02240_ _02237_ VGND VGND VPWR VPWR _02436_ sky130_fd_sc_hd__a21oi_1
XFILLER_53_141 VGND VGND VPWR VPWR sky130_fd_sc_hd__decap_6
X_08667_ cpuregs\[0\]\[10\] cpuregs\[1\]\[10\] cpuregs\[2\]\[10\] cpuregs\[3\]\[10\]
+ net278 net273 VGND VGND VPWR VPWR _04359_ sky130_fd_sc_hd__mux4_1
XPHY_EDGE_ROW_71_Right_71 VGND VGND VPWR VPWR sky130_fd_sc_hd__decap_3
XFILLER_14_528 VGND VGND VPWR VPWR sky130_fd_sc_hd__decap_4
X_07618_ _02590_ cpuregs\[17\]\[2\] _03574_ VGND VGND VPWR VPWR _00550_ sky130_fd_sc_hd__mux2_1
XFILLER_27_889 VGND VGND VPWR VPWR sky130_fd_sc_hd__decap_6
XTAP_TAPCELL_ROW_81_1632 VGND VPWR sky130_fd_sc_hd__tapvpwrvgnd_1
XTAP_TAPCELL_ROW_81_1621 VGND VPWR sky130_fd_sc_hd__tapvpwrvgnd_1
X_08598_ _04284_ _04285_ _01558_ VGND VGND VPWR VPWR _04294_ sky130_fd_sc_hd__mux2_1
XFILLER_139_202 VGND VGND VPWR VPWR sky130_fd_sc_hd__fill_1
XFILLER_10_701 VGND VGND VPWR VPWR sky130_fd_sc_hd__fill_2
X_07549_ cpuregs\[25\]\[0\] _02586_ _03571_ VGND VGND VPWR VPWR _00484_ sky130_fd_sc_hd__mux2_1
X_10560_ clknet_leaf_93_clk _00690_ VGND VGND VPWR VPWR reg_next_pc\[15\] sky130_fd_sc_hd__dfxtp_1
XFILLER_14_65 VPWR VGND VPWR VGND sky130_ef_sc_hd__decap_12
X_09219_ is_beq_bne_blt_bge_bltu_bgeu net34 _02514_ _04744_ _04794_ VGND VGND VPWR
+ VPWR _00917_ sky130_fd_sc_hd__a32o_1
X_10491_ clknet_leaf_106_clk _00621_ VGND VGND VPWR VPWR count_instr\[40\] sky130_fd_sc_hd__dfxtp_1
XFILLER_108_633 VGND VGND VPWR VPWR sky130_fd_sc_hd__decap_4
XFILLER_107_121 VGND VGND VPWR VPWR sky130_fd_sc_hd__fill_1
XFILLER_5_237 VPWR VGND VPWR VGND sky130_ef_sc_hd__decap_12
XTAP_TAPCELL_ROW_112_2120 VGND VPWR sky130_fd_sc_hd__tapvpwrvgnd_1
XPHY_EDGE_ROW_80_Right_80 VGND VGND VPWR VPWR sky130_fd_sc_hd__decap_3
XTAP_TAPCELL_ROW_79_1594 VGND VPWR sky130_fd_sc_hd__tapvpwrvgnd_1
XFILLER_146_53 VPWR VGND VPWR VGND sky130_ef_sc_hd__decap_12
XTAP_TAPCELL_ROW_112_2131 VGND VPWR sky130_fd_sc_hd__tapvpwrvgnd_1
XFILLER_146_97 VPWR VGND VPWR VGND sky130_ef_sc_hd__decap_12
X_11112_ clknet_leaf_120_clk _01159_ VGND VGND VPWR VPWR cpuregs\[31\]\[1\] sky130_fd_sc_hd__dfxtp_1
XFILLER_150_477 VPWR VGND VPWR VGND sky130_ef_sc_hd__decap_12
XFILLER_89_561 VGND VGND VPWR VPWR sky130_fd_sc_hd__decap_4
X_11043_ clknet_leaf_104_clk _01100_ VGND VGND VPWR VPWR mem_rdata_q\[6\] sky130_fd_sc_hd__dfxtp_1
XFILLER_77_756 VGND VGND VPWR VPWR sky130_fd_sc_hd__decap_4
XFILLER_76_222 VPWR VGND VPWR VGND sky130_ef_sc_hd__decap_12
XFILLER_49_447 VGND VGND VPWR VPWR sky130_fd_sc_hd__fill_1
Xclkbuf_4_3_0_clk clknet_0_clk VGND VGND VPWR VPWR clknet_4_3_0_clk sky130_fd_sc_hd__clkbuf_8
XFILLER_36_119 VPWR VGND VPWR VGND sky130_ef_sc_hd__decap_12
XFILLER_18_867 VGND VGND VPWR VPWR sky130_fd_sc_hd__fill_1
XFILLER_33_804 VPWR VGND VPWR VGND sky130_ef_sc_hd__decap_12
XFILLER_44_130 VGND VGND VPWR VPWR sky130_fd_sc_hd__decap_8
XTAP_TAPCELL_ROW_123_2293 VGND VPWR sky130_fd_sc_hd__tapvpwrvgnd_1
XFILLER_60_612 VGND VGND VPWR VPWR sky130_fd_sc_hd__fill_1
XFILLER_60_645 VPWR VGND VPWR VGND sky130_ef_sc_hd__decap_12
X_10827_ clknet_leaf_97_clk _00892_ VGND VGND VPWR VPWR decoded_imm_j\[10\] sky130_fd_sc_hd__dfxtp_1
XFILLER_60_689 VGND VGND VPWR VPWR sky130_fd_sc_hd__decap_4
XTAP_TAPCELL_ROW_15_567 VGND VPWR sky130_fd_sc_hd__tapvpwrvgnd_1
XTAP_TAPCELL_ROW_15_578 VGND VPWR sky130_fd_sc_hd__tapvpwrvgnd_1
XTAP_TAPCELL_ROW_99_1915 VGND VPWR sky130_fd_sc_hd__tapvpwrvgnd_1
X_10758_ clknet_leaf_132_clk alu_out\[11\] VGND VGND VPWR VPWR alu_out_q\[11\] sky130_fd_sc_hd__dfxtp_1
XFILLER_145_205 VGND VGND VPWR VPWR sky130_fd_sc_hd__decap_8
XFILLER_71_93 VPWR VGND VPWR VGND sky130_ef_sc_hd__decap_12
X_10689_ clknet_leaf_83_clk _00787_ VGND VGND VPWR VPWR net42 sky130_fd_sc_hd__dfxtp_1
XFILLER_126_474 VGND VGND VPWR VPWR sky130_fd_sc_hd__fill_2
XFILLER_99_314 VGND VGND VPWR VPWR sky130_fd_sc_hd__decap_8
XFILLER_153_293 VPWR VGND VPWR VGND sky130_ef_sc_hd__decap_12
XFILLER_114_669 VGND VGND VPWR VPWR sky130_fd_sc_hd__decap_8
XFILLER_113_124 VGND VGND VPWR VPWR sky130_fd_sc_hd__decap_4
XFILLER_99_369 VGND VGND VPWR VPWR sky130_fd_sc_hd__decap_8
XFILLER_141_488 VPWR VGND VPWR VGND sky130_ef_sc_hd__decap_12
X_06920_ cpuregs\[12\]\[22\] cpuregs\[13\]\[22\] cpuregs\[14\]\[22\] cpuregs\[15\]\[22\]
+ net266 net261 VGND VGND VPWR VPWR _03336_ sky130_fd_sc_hd__mux4_1
XFILLER_113_179 VGND VGND VPWR VPWR sky130_fd_sc_hd__decap_3
XFILLER_67_222 VGND VGND VPWR VPWR sky130_fd_sc_hd__fill_2
XTAP_TAPCELL_ROW_143_2625 VGND VPWR sky130_fd_sc_hd__tapvpwrvgnd_1
XTAP_TAPCELL_ROW_143_2614 VGND VPWR sky130_fd_sc_hd__tapvpwrvgnd_1
X_06851_ _03188_ _03264_ _03266_ VGND VGND VPWR VPWR _03269_ sky130_fd_sc_hd__a21o_1
X_05802_ _02106_ _02366_ VGND VGND VPWR VPWR _02367_ sky130_fd_sc_hd__xnor2_1
X_06782_ cpuregs\[12\]\[17\] cpuregs\[13\]\[17\] cpuregs\[14\]\[17\] cpuregs\[15\]\[17\]
+ net265 net260 VGND VGND VPWR VPWR _03203_ sky130_fd_sc_hd__mux4_1
XFILLER_67_277 VGND VGND VPWR VPWR sky130_fd_sc_hd__decap_3
X_09570_ cpuregs\[29\]\[9\] _02621_ net239 VGND VGND VPWR VPWR _01231_ sky130_fd_sc_hd__mux2_1
XFILLER_82_269 VGND VGND VPWR VPWR sky130_fd_sc_hd__fill_1
X_05733_ _02121_ _02238_ _02303_ _02305_ VGND VGND VPWR VPWR alu_out\[10\] sky130_fd_sc_hd__a211o_1
X_08521_ _00009_ _04222_ _01559_ VGND VGND VPWR VPWR _04223_ sky130_fd_sc_hd__o21a_1
X_08452_ cpuregs\[28\]\[31\] cpuregs\[29\]\[31\] cpuregs\[30\]\[31\] cpuregs\[31\]\[31\]
+ net264 net260 VGND VGND VPWR VPWR _04189_ sky130_fd_sc_hd__mux4_1
XFILLER_24_837 VPWR VGND VPWR VGND sky130_ef_sc_hd__decap_12
X_07403_ cpuregs\[14\]\[21\] _02670_ _03564_ VGND VGND VPWR VPWR _00345_ sky130_fd_sc_hd__mux2_1
X_05664_ _02142_ _02237_ _02240_ _02143_ _02245_ VGND VGND VPWR VPWR _02246_ sky130_fd_sc_hd__a221o_1
X_08383_ _04138_ net34 _04137_ VGND VGND VPWR VPWR _00752_ sky130_fd_sc_hd__and3b_1
XTAP_TAPCELL_ROW_63_1340 VGND VPWR sky130_fd_sc_hd__tapvpwrvgnd_1
X_05595_ net122 net196 VGND VGND VPWR VPWR _02178_ sky130_fd_sc_hd__nand2b_1
XTAP_TAPCELL_ROW_34_876 VGND VPWR sky130_fd_sc_hd__tapvpwrvgnd_1
X_07334_ cpuregs\[21\]\[18\] _02657_ net248 VGND VGND VPWR VPWR _00278_ sky130_fd_sc_hd__mux2_1
XFILLER_51_19 VPWR VGND VPWR VGND sky130_ef_sc_hd__decap_12
XFILLER_32_881 VPWR VGND VPWR VGND sky130_ef_sc_hd__decap_12
XFILLER_149_588 VGND VGND VPWR VPWR sky130_fd_sc_hd__decap_6
X_07265_ cpuregs\[2\]\[16\] _02649_ net250 VGND VGND VPWR VPWR _00212_ sky130_fd_sc_hd__mux2_1
XFILLER_31_391 VGND VGND VPWR VPWR sky130_fd_sc_hd__fill_1
X_06216_ _02665_ cpuregs\[11\]\[20\] _02582_ VGND VGND VPWR VPWR _00057_ sky130_fd_sc_hd__mux2_1
X_09004_ net269 _04674_ _04677_ _04266_ VGND VGND VPWR VPWR _04678_ sky130_fd_sc_hd__o211a_1
XFILLER_136_238 VPWR VGND VPWR VGND sky130_ef_sc_hd__decap_12
X_07196_ cpuregs\[30\]\[14\] _02641_ net252 VGND VGND VPWR VPWR _00146_ sky130_fd_sc_hd__mux2_1
XFILLER_145_783 VGND VGND VPWR VPWR sky130_fd_sc_hd__fill_1
X_06147_ reg_pc\[7\] reg_pc\[6\] _02601_ VGND VGND VPWR VPWR _02610_ sky130_fd_sc_hd__and3_1
XFILLER_132_433 VGND VGND VPWR VPWR sky130_fd_sc_hd__decap_4
X_06078_ _02548_ _02549_ _01558_ VGND VGND VPWR VPWR _02550_ sky130_fd_sc_hd__mux2_1
X_05029_ _01549_ _01650_ _01651_ VGND VGND VPWR VPWR _00018_ sky130_fd_sc_hd__or3b_1
X_09906_ clknet_leaf_136_clk _00041_ VGND VGND VPWR VPWR cpuregs\[11\]\[4\] sky130_fd_sc_hd__dfxtp_1
XFILLER_132_499 VGND VGND VPWR VPWR sky130_fd_sc_hd__fill_1
XFILLER_86_531 VGND VGND VPWR VPWR sky130_fd_sc_hd__fill_1
XFILLER_76_38 VGND VGND VPWR VPWR sky130_fd_sc_hd__fill_2
XFILLER_101_853 VGND VGND VPWR VPWR sky130_fd_sc_hd__decap_8
XFILLER_59_767 VPWR VGND VPWR VGND sky130_ef_sc_hd__decap_12
X_09837_ _02630_ cpuregs\[10\]\[11\] _04876_ VGND VGND VPWR VPWR _01521_ sky130_fd_sc_hd__mux2_1
XFILLER_101_897 VGND VGND VPWR VPWR sky130_fd_sc_hd__decap_3
XFILLER_100_396 VGND VGND VPWR VPWR sky130_fd_sc_hd__fill_2
X_09768_ _02616_ cpuregs\[7\]\[8\] _04874_ VGND VGND VPWR VPWR _01422_ sky130_fd_sc_hd__mux2_1
XFILLER_46_428 VGND VGND VPWR VPWR sky130_fd_sc_hd__fill_1
XFILLER_132_77 VGND VGND VPWR VPWR sky130_fd_sc_hd__decap_6
X_08719_ cpuregs\[8\]\[13\] cpuregs\[9\]\[13\] cpuregs\[10\]\[13\] cpuregs\[11\]\[13\]
+ net275 net271 VGND VGND VPWR VPWR _04408_ sky130_fd_sc_hd__mux4_1
Xrebuffer60 net450 VGND VGND VPWR VPWR net446 sky130_fd_sc_hd__dlygate4sd1_1
X_09699_ _02603_ cpuregs\[5\]\[5\] _04872_ VGND VGND VPWR VPWR _01355_ sky130_fd_sc_hd__mux2_1
XFILLER_26_141 VGND VGND VPWR VPWR sky130_fd_sc_hd__decap_6
XFILLER_54_494 VPWR VGND VPWR VGND sky130_ef_sc_hd__decap_12
XFILLER_14_336 VGND VGND VPWR VPWR sky130_fd_sc_hd__decap_4
XFILLER_26_174 VPWR VGND VPWR VGND sky130_ef_sc_hd__decap_12
XFILLER_42_645 VGND VGND VPWR VPWR sky130_fd_sc_hd__decap_8
X_10612_ clknet_leaf_108_clk _00742_ VGND VGND VPWR VPWR count_cycle\[35\] sky130_fd_sc_hd__dfxtp_1
XTAP_TAPCELL_ROW_12_526 VGND VPWR sky130_fd_sc_hd__tapvpwrvgnd_1
XFILLER_127_205 VPWR VGND VPWR VGND sky130_ef_sc_hd__decap_12
X_10543_ clknet_leaf_62_clk _00673_ VGND VGND VPWR VPWR reg_pc\[29\] sky130_fd_sc_hd__dfxtp_2
XFILLER_10_531 VGND VGND VPWR VPWR sky130_fd_sc_hd__fill_1
XFILLER_142_208 VGND VGND VPWR VPWR sky130_fd_sc_hd__decap_4
X_10474_ clknet_leaf_83_clk _00604_ VGND VGND VPWR VPWR count_instr\[23\] sky130_fd_sc_hd__dfxtp_1
Xrebuffer183 net570 VGND VGND VPWR VPWR net569 sky130_fd_sc_hd__clkbuf_2
XFILLER_10_597 VGND VGND VPWR VPWR sky130_fd_sc_hd__fill_2
XFILLER_136_794 VPWR VGND VPWR VGND sky130_ef_sc_hd__decap_12
XTAP_TAPCELL_ROW_94_1834 VGND VPWR sky130_fd_sc_hd__tapvpwrvgnd_1
Xrebuffer194 net581 VGND VGND VPWR VPWR net580 sky130_fd_sc_hd__dlygate4sd1_1
XFILLER_151_753 VPWR VGND VPWR VGND sky130_ef_sc_hd__decap_12
XFILLER_151_797 VPWR VGND VPWR VGND sky130_ef_sc_hd__decap_12
XFILLER_150_241 VGND VGND VPWR VPWR sky130_fd_sc_hd__fill_2
XFILLER_111_617 VGND VGND VPWR VPWR sky130_fd_sc_hd__decap_8
XFILLER_110_138 VGND VGND VPWR VPWR sky130_fd_sc_hd__fill_2
XFILLER_1_273 VGND VGND VPWR VPWR sky130_fd_sc_hd__decap_6
X_11026_ clknet_leaf_45_clk _01088_ VGND VGND VPWR VPWR cpuregs\[19\]\[26\] sky130_fd_sc_hd__dfxtp_1
XTAP_TAPCELL_ROW_125_2333 VGND VPWR sky130_fd_sc_hd__tapvpwrvgnd_1
XFILLER_92_567 VPWR VGND VPWR VGND sky130_ef_sc_hd__decap_12
XFILLER_18_642 VGND VGND VPWR VPWR sky130_fd_sc_hd__fill_2
XFILLER_45_461 VPWR VGND VPWR VGND sky130_ef_sc_hd__decap_12
X_05380_ reg_pc\[25\] decoded_imm\[25\] VGND VGND VPWR VPWR _01970_ sky130_fd_sc_hd__nand2_1
XTAP_TAPCELL_ROW_103_1985 VGND VPWR sky130_fd_sc_hd__tapvpwrvgnd_1
XTAP_TAPCELL_ROW_103_1974 VGND VPWR sky130_fd_sc_hd__tapvpwrvgnd_1
XANTENNA_29 net220 VGND VGND VPWR VPWR sky130_fd_sc_hd__diode_2
XANTENNA_18 net123 VGND VGND VPWR VPWR sky130_fd_sc_hd__diode_2
XFILLER_14_881 VPWR VGND VPWR VGND sky130_ef_sc_hd__decap_12
XTAP_TAPCELL_ROW_31_824 VGND VPWR sky130_fd_sc_hd__tapvpwrvgnd_1
XTAP_TAPCELL_ROW_31_835 VGND VPWR sky130_fd_sc_hd__tapvpwrvgnd_1
XFILLER_146_514 VPWR VGND VPWR VGND sky130_ef_sc_hd__decap_12
XFILLER_119_706 VGND VGND VPWR VPWR sky130_fd_sc_hd__fill_1
X_07050_ cpuregs\[28\]\[27\] cpuregs\[29\]\[27\] cpuregs\[30\]\[27\] cpuregs\[31\]\[27\]
+ net266 net261 VGND VGND VPWR VPWR _03461_ sky130_fd_sc_hd__mux4_1
XFILLER_70_3 VGND VGND VPWR VPWR sky130_fd_sc_hd__decap_3
X_06001_ reg_out\[23\] reg_next_pc\[23\] net596 VGND VGND VPWR VPWR _02504_ sky130_fd_sc_hd__mux2_1
XFILLER_133_219 VGND VGND VPWR VPWR sky130_fd_sc_hd__decap_4
XFILLER_127_783 VGND VGND VPWR VPWR sky130_fd_sc_hd__fill_1
Xoutput114 net114 VGND VGND VPWR VPWR mem_la_wdata[25] sky130_fd_sc_hd__buf_2
XFILLER_99_111 VGND VGND VPWR VPWR sky130_fd_sc_hd__fill_1
Xoutput103 net103 VGND VGND VPWR VPWR mem_la_wdata[15] sky130_fd_sc_hd__buf_2
Xoutput125 net125 VGND VGND VPWR VPWR mem_la_wdata[6] sky130_fd_sc_hd__buf_2
Xoutput147 net147 VGND VGND VPWR VPWR mem_wdata[20] sky130_fd_sc_hd__buf_2
Xoutput158 net158 VGND VGND VPWR VPWR mem_wdata[30] sky130_fd_sc_hd__buf_2
Xoutput136 net136 VGND VGND VPWR VPWR mem_wdata[10] sky130_fd_sc_hd__buf_2
XFILLER_141_241 VGND VGND VPWR VPWR sky130_fd_sc_hd__fill_1
XFILLER_99_177 VGND VGND VPWR VPWR sky130_fd_sc_hd__fill_1
Xoutput169 net169 VGND VGND VPWR VPWR mem_wstrb[2] sky130_fd_sc_hd__buf_2
X_07952_ _03774_ _03776_ _03777_ VGND VGND VPWR VPWR _03778_ sky130_fd_sc_hd__a21oi_1
X_07883_ reg_pc\[29\] _01624_ _01628_ _03717_ VGND VGND VPWR VPWR _00673_ sky130_fd_sc_hd__a22o_1
X_06903_ decoded_imm\[22\] net185 VGND VGND VPWR VPWR _03319_ sky130_fd_sc_hd__nand2_1
X_06834_ cpuregs\[0\]\[19\] cpuregs\[1\]\[19\] cpuregs\[2\]\[19\] cpuregs\[3\]\[19\]
+ _00012_ _00013_ VGND VGND VPWR VPWR _03253_ sky130_fd_sc_hd__mux4_1
X_09622_ _02699_ cpuregs\[3\]\[28\] _04868_ VGND VGND VPWR VPWR _01282_ sky130_fd_sc_hd__mux2_1
XFILLER_68_586 VGND VGND VPWR VPWR sky130_fd_sc_hd__fill_2
X_09553_ cpuregs\[23\]\[25\] _02688_ _04866_ VGND VGND VPWR VPWR _01215_ sky130_fd_sc_hd__mux2_1
XTAP_TAPCELL_ROW_39_957 VGND VPWR sky130_fd_sc_hd__tapvpwrvgnd_1
X_06765_ decoded_imm\[17\] net179 VGND VGND VPWR VPWR _03186_ sky130_fd_sc_hd__xor2_1
XFILLER_71_729 VGND VGND VPWR VPWR sky130_fd_sc_hd__decap_6
XFILLER_24_601 VGND VGND VPWR VPWR sky130_fd_sc_hd__decap_3
X_08504_ _01550_ mem_do_prefetch _01652_ VGND VGND VPWR VPWR _04210_ sky130_fd_sc_hd__mux2_1
X_09484_ cpuregs\[24\]\[22\] _02675_ net241 VGND VGND VPWR VPWR _01148_ sky130_fd_sc_hd__mux2_1
X_06696_ cpuregs\[16\]\[14\] cpuregs\[17\]\[14\] cpuregs\[18\]\[14\] cpuregs\[19\]\[14\]
+ net265 net260 VGND VGND VPWR VPWR _03120_ sky130_fd_sc_hd__mux4_1
X_05716_ _02132_ _02237_ VGND VGND VPWR VPWR _02291_ sky130_fd_sc_hd__and2b_1
XFILLER_51_420 VPWR VGND VPWR VGND sky130_ef_sc_hd__decap_12
X_05647_ _02067_ _02226_ _02228_ _02229_ VGND VGND VPWR VPWR _02230_ sky130_fd_sc_hd__o211a_2
X_08435_ _03525_ _03529_ _04171_ VGND VGND VPWR VPWR _04172_ sky130_fd_sc_hd__a21o_1
XFILLER_62_29 VPWR VGND VPWR VGND sky130_ef_sc_hd__decap_12
X_08366_ count_cycle\[38\] count_cycle\[39\] _04124_ VGND VGND VPWR VPWR _04128_ sky130_fd_sc_hd__and3_1
X_05578_ net199 net125 VGND VGND VPWR VPWR _02161_ sky130_fd_sc_hd__and2_1
X_07317_ cpuregs\[21\]\[1\] _02588_ _03562_ VGND VGND VPWR VPWR _00261_ sky130_fd_sc_hd__mux2_1
XFILLER_109_238 VGND VGND VPWR VPWR sky130_fd_sc_hd__fill_1
X_08297_ count_cycle\[13\] _04078_ count_cycle\[15\] count_cycle\[14\] VGND VGND VPWR
+ VPWR _04083_ sky130_fd_sc_hd__and4_1
X_07248_ _03549_ _03554_ VGND VGND VPWR VPWR _03559_ sky130_fd_sc_hd__nor2_8
XTAP_TAPCELL_ROW_76_1542 VGND VPWR sky130_fd_sc_hd__tapvpwrvgnd_1
XFILLER_11_55 VGND VGND VPWR VPWR sky130_fd_sc_hd__fill_1
XFILLER_3_505 VPWR VGND VPWR VGND sky130_ef_sc_hd__decap_12
X_07179_ _02580_ _03553_ VGND VGND VPWR VPWR _03554_ sky130_fd_sc_hd__nand2_8
X_10190_ clknet_leaf_40_clk _00320_ VGND VGND VPWR VPWR cpuregs\[9\]\[28\] sky130_fd_sc_hd__dfxtp_1
XFILLER_127_55 VGND VGND VPWR VPWR sky130_fd_sc_hd__fill_1
XTAP_TAPCELL_ROW_76_1553 VGND VPWR sky130_fd_sc_hd__tapvpwrvgnd_1
XFILLER_133_797 VPWR VGND VPWR VGND sky130_ef_sc_hd__decap_12
XFILLER_120_403 VPWR VGND VPWR VGND sky130_ef_sc_hd__decap_12
XFILLER_79_818 VGND VGND VPWR VPWR sky130_fd_sc_hd__decap_8
XFILLER_78_339 VGND VGND VPWR VPWR sky130_fd_sc_hd__decap_8
XFILLER_101_650 VGND VGND VPWR VPWR sky130_fd_sc_hd__decap_8
XFILLER_86_361 VGND VGND VPWR VPWR sky130_fd_sc_hd__decap_3
XTAP_TAPCELL_ROW_107_2041 VGND VPWR sky130_fd_sc_hd__tapvpwrvgnd_1
XFILLER_46_225 VPWR VGND VPWR VGND sky130_ef_sc_hd__decap_12
XTAP_TAPCELL_ROW_17_607 VGND VPWR sky130_fd_sc_hd__tapvpwrvgnd_1
XFILLER_36_41 VPWR VGND VPWR VGND sky130_ef_sc_hd__decap_12
XFILLER_36_85 VGND VGND VPWR VPWR sky130_fd_sc_hd__fill_1
XTAP_TAPCELL_ROW_120_2252 VGND VPWR sky130_fd_sc_hd__tapvpwrvgnd_1
XFILLER_70_751 VGND VGND VPWR VPWR sky130_fd_sc_hd__decap_4
XFILLER_30_604 VPWR VGND VPWR VGND sky130_ef_sc_hd__decap_12
XFILLER_128_514 VPWR VGND VPWR VGND sky130_ef_sc_hd__decap_12
Xinput27 mem_rdata[4] VGND VGND VPWR VPWR net27 sky130_fd_sc_hd__buf_1
XFILLER_7_833 VGND VGND VPWR VPWR sky130_fd_sc_hd__decap_6
XFILLER_11_895 VGND VGND VPWR VPWR sky130_fd_sc_hd__fill_1
Xinput16 mem_rdata[23] VGND VGND VPWR VPWR net16 sky130_fd_sc_hd__buf_2
X_10526_ clknet_leaf_132_clk _00656_ VGND VGND VPWR VPWR reg_pc\[12\] sky130_fd_sc_hd__dfxtp_1
XFILLER_7_877 VPWR VGND VPWR VGND sky130_ef_sc_hd__decap_12
XFILLER_6_321 VPWR VGND VPWR VGND sky130_ef_sc_hd__decap_12
X_10457_ clknet_leaf_108_clk _00587_ VGND VGND VPWR VPWR count_instr\[6\] sky130_fd_sc_hd__dfxtp_1
XFILLER_124_731 VPWR VGND VPWR VGND sky130_ef_sc_hd__decap_12
XFILLER_151_550 VGND VGND VPWR VPWR sky130_fd_sc_hd__decap_8
X_10388_ clknet_leaf_121_clk _00518_ VGND VGND VPWR VPWR cpuregs\[20\]\[2\] sky130_fd_sc_hd__dfxtp_1
XFILLER_97_648 VPWR VGND VPWR VGND sky130_ef_sc_hd__decap_12
XFILLER_111_447 VGND VGND VPWR VPWR sky130_fd_sc_hd__fill_1
X_11009_ clknet_leaf_151_clk _01071_ VGND VGND VPWR VPWR cpuregs\[19\]\[9\] sky130_fd_sc_hd__dfxtp_1
XFILLER_93_854 VGND VGND VPWR VPWR sky130_fd_sc_hd__fill_1
XFILLER_80_504 VGND VGND VPWR VPWR sky130_fd_sc_hd__fill_2
XFILLER_18_450 VPWR VGND VPWR VGND sky130_ef_sc_hd__decap_12
XTAP_TAPCELL_ROW_36_905 VGND VPWR sky130_fd_sc_hd__tapvpwrvgnd_1
X_06550_ _02953_ _02954_ _02978_ _02952_ VGND VGND VPWR VPWR _02979_ sky130_fd_sc_hd__o211ai_2
XFILLER_18_472 VGND VGND VPWR VPWR sky130_fd_sc_hd__decap_4
X_05501_ net186 net218 VGND VGND VPWR VPWR _02084_ sky130_fd_sc_hd__or2_1
XFILLER_33_442 VGND VGND VPWR VPWR sky130_fd_sc_hd__decap_6
X_06481_ cpuregs\[4\]\[6\] cpuregs\[5\]\[6\] cpuregs\[6\]\[6\] cpuregs\[7\]\[6\] net263
+ net259 VGND VGND VPWR VPWR _02913_ sky130_fd_sc_hd__mux4_1
X_08220_ _03716_ _04007_ VGND VGND VPWR VPWR _04025_ sky130_fd_sc_hd__nor2_1
X_05432_ _02005_ _02008_ _02007_ VGND VGND VPWR VPWR _02018_ sky130_fd_sc_hd__o21ai_1
XFILLER_21_615 VGND VGND VPWR VPWR sky130_fd_sc_hd__fill_1
XFILLER_21_637 VPWR VGND VPWR VGND sky130_ef_sc_hd__decap_12
XTAP_TAPCELL_ROW_43_1018 VGND VPWR sky130_fd_sc_hd__tapvpwrvgnd_1
XTAP_TAPCELL_ROW_138_2546 VGND VPWR sky130_fd_sc_hd__tapvpwrvgnd_1
XTAP_TAPCELL_ROW_138_2535 VGND VPWR sky130_fd_sc_hd__tapvpwrvgnd_1
X_08151_ _03958_ _03961_ _03576_ VGND VGND VPWR VPWR _03962_ sky130_fd_sc_hd__a21oi_1
XFILLER_119_547 VGND VGND VPWR VPWR sky130_fd_sc_hd__fill_1
X_05363_ _01909_ _01923_ _01953_ VGND VGND VPWR VPWR _01954_ sky130_fd_sc_hd__or3_1
XFILLER_147_889 VGND VGND VPWR VPWR sky130_fd_sc_hd__decap_6
X_07102_ cpuregs\[28\]\[29\] cpuregs\[29\]\[29\] cpuregs\[30\]\[29\] cpuregs\[31\]\[29\]
+ net266 net261 VGND VGND VPWR VPWR _03511_ sky130_fd_sc_hd__mux4_1
X_08082_ _03894_ _03897_ VGND VGND VPWR VPWR _03898_ sky130_fd_sc_hd__nand2_1
X_05294_ net10 _01665_ _01856_ VGND VGND VPWR VPWR _01891_ sky130_fd_sc_hd__a21o_1
XTAP_TAPCELL_ROW_151_2746 VGND VPWR sky130_fd_sc_hd__tapvpwrvgnd_1
XFILLER_146_377 VGND VGND VPWR VPWR sky130_fd_sc_hd__fill_1
X_07033_ _00015_ _03441_ _03444_ _02735_ VGND VGND VPWR VPWR _03445_ sky130_fd_sc_hd__o211a_1
XFILLER_127_580 VGND VGND VPWR VPWR sky130_fd_sc_hd__decap_4
XTAP_TAPCELL_ROW_58_1261 VGND VPWR sky130_fd_sc_hd__tapvpwrvgnd_1
XFILLER_114_230 VGND VGND VPWR VPWR sky130_fd_sc_hd__fill_1
X_08984_ _04656_ _04657_ _04658_ net269 _00010_ VGND VGND VPWR VPWR _04659_ sky130_fd_sc_hd__a221o_1
XFILLER_102_425 VGND VGND VPWR VPWR sky130_fd_sc_hd__fill_1
XFILLER_75_309 VGND VGND VPWR VPWR sky130_fd_sc_hd__decap_6
XTAP_TAPCELL_ROW_71_1472 VGND VPWR sky130_fd_sc_hd__tapvpwrvgnd_1
XTAP_TAPCELL_ROW_71_1461 VGND VPWR sky130_fd_sc_hd__tapvpwrvgnd_1
X_07935_ decoded_imm_j\[6\] _03693_ VGND VGND VPWR VPWR _03762_ sky130_fd_sc_hd__or2_1
XFILLER_68_361 VGND VGND VPWR VPWR sky130_fd_sc_hd__decap_3
X_07866_ reg_pc\[21\] _01624_ _01628_ _03708_ VGND VGND VPWR VPWR _00665_ sky130_fd_sc_hd__a22o_1
XFILLER_113_35 VPWR VGND VPWR VGND sky130_ef_sc_hd__decap_12
XFILLER_84_843 VGND VGND VPWR VPWR sky130_fd_sc_hd__decap_4
XFILLER_68_394 VPWR VGND VPWR VGND sky130_ef_sc_hd__decap_12
XFILLER_56_545 VGND VGND VPWR VPWR sky130_fd_sc_hd__fill_1
X_09605_ _02630_ cpuregs\[3\]\[11\] _04868_ VGND VGND VPWR VPWR _01265_ sky130_fd_sc_hd__mux2_1
XFILLER_28_247 VGND VGND VPWR VPWR sky130_fd_sc_hd__decap_4
XFILLER_113_57 VPWR VGND VPWR VGND sky130_ef_sc_hd__decap_12
X_07797_ _03670_ _03669_ VGND VGND VPWR VPWR _00634_ sky130_fd_sc_hd__nor2_1
X_06817_ net180 _03236_ net237 VGND VGND VPWR VPWR _00087_ sky130_fd_sc_hd__mux2_1
XTAP_TAPCELL_ROW_3_379 VGND VPWR sky130_fd_sc_hd__tapvpwrvgnd_1
X_06748_ _01622_ _03165_ _03166_ _03168_ _03169_ VGND VGND VPWR VPWR _03170_ sky130_fd_sc_hd__a311o_1
XFILLER_71_537 VPWR VGND VPWR VGND sky130_ef_sc_hd__decap_12
X_09536_ cpuregs\[23\]\[8\] _02616_ _04866_ VGND VGND VPWR VPWR _01198_ sky130_fd_sc_hd__mux2_1
X_09467_ cpuregs\[24\]\[5\] _02603_ net243 VGND VGND VPWR VPWR _01131_ sky130_fd_sc_hd__mux2_1
X_08418_ _04160_ _04159_ VGND VGND VPWR VPWR _00765_ sky130_fd_sc_hd__nor2_1
X_06679_ _03094_ _03102_ _03103_ _01581_ _01580_ VGND VGND VPWR VPWR _03104_ sky130_fd_sc_hd__a221o_1
XFILLER_52_773 VGND VGND VPWR VPWR sky130_fd_sc_hd__decap_8
XFILLER_24_475 VGND VGND VPWR VPWR sky130_fd_sc_hd__fill_1
XFILLER_11_147 VGND VGND VPWR VPWR sky130_fd_sc_hd__decap_3
X_09398_ _02590_ cpuregs\[18\]\[2\] _04862_ VGND VGND VPWR VPWR _01032_ sky130_fd_sc_hd__mux2_1
X_08349_ count_cycle\[32\] _04114_ count_cycle\[33\] VGND VGND VPWR VPWR _04117_ sky130_fd_sc_hd__a21o_1
XTAP_TAPCELL_ROW_22_676 VGND VPWR sky130_fd_sc_hd__tapvpwrvgnd_1
XFILLER_153_804 VGND VGND VPWR VPWR sky130_fd_sc_hd__decap_4
XFILLER_149_193 VPWR VGND VPWR VGND sky130_ef_sc_hd__decap_12
X_11360_ clknet_leaf_46_clk _01404_ VGND VGND VPWR VPWR cpuregs\[6\]\[22\] sky130_fd_sc_hd__dfxtp_1
XFILLER_138_867 VGND VGND VPWR VPWR sky130_fd_sc_hd__fill_1
XFILLER_137_333 VGND VGND VPWR VPWR sky130_fd_sc_hd__decap_3
XPHY_EDGE_ROW_129_Right_129 VGND VGND VPWR VPWR sky130_fd_sc_hd__decap_3
XFILLER_22_65 VPWR VGND VPWR VGND sky130_ef_sc_hd__decap_12
XTAP_TAPCELL_ROW_22_687 VGND VPWR sky130_fd_sc_hd__tapvpwrvgnd_1
XFILLER_138_65 VPWR VGND VPWR VGND sky130_ef_sc_hd__decap_12
X_10311_ clknet_leaf_75_clk _00441_ VGND VGND VPWR VPWR cpuregs\[26\]\[21\] sky130_fd_sc_hd__dfxtp_1
XFILLER_4_825 VPWR VGND VPWR VGND sky130_ef_sc_hd__decap_12
XFILLER_22_98 VGND VGND VPWR VPWR sky130_fd_sc_hd__decap_8
X_11291_ clknet_leaf_76_clk _01338_ VGND VGND VPWR VPWR cpuregs\[4\]\[20\] sky130_fd_sc_hd__dfxtp_1
XFILLER_4_869 VPWR VGND VPWR VGND sky130_ef_sc_hd__decap_12
XFILLER_3_335 VGND VGND VPWR VPWR sky130_fd_sc_hd__fill_1
X_10242_ clknet_leaf_19_clk _00372_ VGND VGND VPWR VPWR cpuregs\[27\]\[16\] sky130_fd_sc_hd__dfxtp_1
XFILLER_79_615 VGND VGND VPWR VPWR sky130_fd_sc_hd__fill_1
XFILLER_0_3 VPWR VGND VPWR VGND sky130_ef_sc_hd__decap_12
XFILLER_79_648 VGND VGND VPWR VPWR sky130_fd_sc_hd__decap_6
X_10173_ clknet_leaf_0_clk _00303_ VGND VGND VPWR VPWR cpuregs\[9\]\[11\] sky130_fd_sc_hd__dfxtp_1
XFILLER_93_117 VGND VGND VPWR VPWR sky130_fd_sc_hd__fill_1
XFILLER_75_821 VGND VGND VPWR VPWR sky130_fd_sc_hd__decap_3
XFILLER_59_372 VGND VGND VPWR VPWR sky130_fd_sc_hd__decap_8
XTAP_TAPCELL_ROW_89_1755 VGND VPWR sky130_fd_sc_hd__tapvpwrvgnd_1
XFILLER_87_692 VGND VGND VPWR VPWR sky130_fd_sc_hd__decap_4
XFILLER_90_813 VPWR VGND VPWR VGND sky130_ef_sc_hd__decap_12
XFILLER_75_876 VGND VGND VPWR VPWR sky130_fd_sc_hd__decap_4
XFILLER_19_258 VPWR VGND VPWR VGND sky130_ef_sc_hd__decap_12
XFILLER_47_84 VGND VGND VPWR VPWR sky130_fd_sc_hd__fill_2
XFILLER_42_250 VGND VGND VPWR VPWR sky130_fd_sc_hd__fill_2
XTAP_TAPCELL_ROW_100_1933 VGND VPWR sky130_fd_sc_hd__tapvpwrvgnd_1
XFILLER_30_467 VGND VGND VPWR VPWR sky130_fd_sc_hd__decap_8
XTAP_TAPCELL_ROW_41_985 VGND VPWR sky130_fd_sc_hd__tapvpwrvgnd_1
XFILLER_11_681 VGND VGND VPWR VPWR sky130_fd_sc_hd__fill_2
XFILLER_144_837 VPWR VGND VPWR VGND sky130_ef_sc_hd__decap_12
XTAP_TAPCELL_ROW_133_2454 VGND VPWR sky130_fd_sc_hd__tapvpwrvgnd_1
XFILLER_129_889 VGND VGND VPWR VPWR sky130_fd_sc_hd__decap_6
X_10509_ clknet_leaf_82_clk _00639_ VGND VGND VPWR VPWR count_instr\[58\] sky130_fd_sc_hd__dfxtp_1
XTAP_TAPCELL_ROW_133_2465 VGND VPWR sky130_fd_sc_hd__tapvpwrvgnd_1
X_11489_ clknet_leaf_51_clk _01533_ VGND VGND VPWR VPWR cpuregs\[10\]\[23\] sky130_fd_sc_hd__dfxtp_1
XFILLER_109_591 VPWR VGND VPWR VGND sky130_ef_sc_hd__decap_12
XFILLER_6_195 VGND VGND VPWR VPWR sky130_fd_sc_hd__fill_1
XFILLER_152_881 VPWR VGND VPWR VGND sky130_ef_sc_hd__decap_12
XFILLER_33_3 VPWR VGND VPWR VGND sky130_ef_sc_hd__decap_12
X_07720_ count_instr\[25\] count_instr\[24\] _03618_ VGND VGND VPWR VPWR _03622_ sky130_fd_sc_hd__and3_1
XFILLER_97_478 VGND VGND VPWR VPWR sky130_fd_sc_hd__decap_3
XFILLER_84_106 VGND VGND VPWR VPWR sky130_fd_sc_hd__decap_3
X_05981_ reg_out\[13\] reg_next_pc\[13\] net596 VGND VGND VPWR VPWR _02494_ sky130_fd_sc_hd__mux2_1
XTAP_TAPCELL_ROW_53_1180 VGND VPWR sky130_fd_sc_hd__tapvpwrvgnd_1
X_04932_ net186 VGND VGND VPWR VPWR _01565_ sky130_fd_sc_hd__inv_2
XFILLER_93_673 VPWR VGND VPWR VGND sky130_ef_sc_hd__decap_12
XFILLER_93_662 VGND VGND VPWR VPWR sky130_fd_sc_hd__decap_8
X_07651_ count_instr\[0\] _03575_ net34 VGND VGND VPWR VPWR _03578_ sky130_fd_sc_hd__o21ai_1
XTAP_TAPCELL_ROW_0_316 VGND VPWR sky130_fd_sc_hd__tapvpwrvgnd_1
XTAP_TAPCELL_ROW_0_327 VGND VPWR sky130_fd_sc_hd__tapvpwrvgnd_1
XFILLER_38_567 VGND VGND VPWR VPWR sky130_fd_sc_hd__decap_3
XFILLER_38_589 VPWR VGND VPWR VGND sky130_ef_sc_hd__decap_12
XFILLER_92_194 VGND VGND VPWR VPWR sky130_fd_sc_hd__fill_2
X_06602_ reg_pc\[10\] _02751_ _03029_ _02715_ VGND VGND VPWR VPWR _03030_ sky130_fd_sc_hd__a211o_1
XTAP_TAPCELL_ROW_0_338 VGND VPWR sky130_fd_sc_hd__tapvpwrvgnd_1
X_07582_ _03550_ _03561_ VGND VGND VPWR VPWR _03573_ sky130_fd_sc_hd__nor2_4
XFILLER_53_559 VGND VGND VPWR VPWR sky130_fd_sc_hd__fill_1
X_06533_ cpuregs\[4\]\[8\] cpuregs\[5\]\[8\] cpuregs\[6\]\[8\] cpuregs\[7\]\[8\] net263
+ net259 VGND VGND VPWR VPWR _02963_ sky130_fd_sc_hd__mux4_1
X_09321_ is_slli_srli_srai _04254_ VGND VGND VPWR VPWR _04820_ sky130_fd_sc_hd__nor2_1
XFILLER_33_250 VPWR VGND VPWR VGND sky130_ef_sc_hd__decap_12
X_09252_ cpuregs\[1\]\[31\] _02712_ net244 VGND VGND VPWR VPWR _00949_ sky130_fd_sc_hd__mux2_1
X_06464_ net198 _02896_ net236 VGND VGND VPWR VPWR _00074_ sky130_fd_sc_hd__mux2_1
X_08203_ _04007_ _04008_ VGND VGND VPWR VPWR _04009_ sky130_fd_sc_hd__nor2_1
X_05415_ _01959_ _01969_ _01970_ VGND VGND VPWR VPWR _02002_ sky130_fd_sc_hd__o21a_1
X_09183_ decoded_imm_j\[7\] _01121_ _02513_ VGND VGND VPWR VPWR _00889_ sky130_fd_sc_hd__mux2_1
X_06395_ net262 _02827_ _01579_ VGND VGND VPWR VPWR _02830_ sky130_fd_sc_hd__o21a_1
XFILLER_147_653 VPWR VGND VPWR VGND sky130_ef_sc_hd__decap_12
X_08134_ _03943_ _03945_ VGND VGND VPWR VPWR _03946_ sky130_fd_sc_hd__or2_1
X_05346_ count_instr\[54\] instr_rdinstrh _01587_ _01938_ VGND VGND VPWR VPWR _01939_
+ sky130_fd_sc_hd__a211o_1
XFILLER_146_141 VPWR VGND VPWR VGND sky130_ef_sc_hd__decap_12
XFILLER_107_517 VPWR VGND VPWR VGND sky130_ef_sc_hd__decap_12
X_05277_ _01543_ _01868_ _01869_ _01875_ VGND VGND VPWR VPWR _04885_ sky130_fd_sc_hd__o31ai_1
X_08065_ _03867_ _03871_ _03868_ VGND VGND VPWR VPWR _03882_ sky130_fd_sc_hd__o21ai_1
Xpicorv32_372 VGND VGND VPWR VPWR picorv32_372/HI trace_data[22] sky130_fd_sc_hd__conb_1
Xpicorv32_350 VGND VGND VPWR VPWR picorv32_350/HI trace_data[0] sky130_fd_sc_hd__conb_1
X_07016_ net194 net254 VGND VGND VPWR VPWR _03428_ sky130_fd_sc_hd__or2_1
XTAP_TAPCELL_ROW_73_1501 VGND VPWR sky130_fd_sc_hd__tapvpwrvgnd_1
Xpicorv32_361 VGND VGND VPWR VPWR picorv32_361/HI trace_data[11] sky130_fd_sc_hd__conb_1
XFILLER_0_305 VGND VGND VPWR VPWR sky130_fd_sc_hd__decap_3
Xpicorv32_383 VGND VGND VPWR VPWR picorv32_383/HI trace_data[33] sky130_fd_sc_hd__conb_1
XFILLER_1_839 VGND VGND VPWR VPWR sky130_fd_sc_hd__fill_1
X_08967_ _04629_ _04630_ net270 VGND VGND VPWR VPWR _04643_ sky130_fd_sc_hd__mux2_1
XFILLER_102_288 VGND VGND VPWR VPWR sky130_fd_sc_hd__decap_8
XFILLER_88_489 VGND VGND VPWR VPWR sky130_fd_sc_hd__fill_1
X_08898_ net270 _04576_ VGND VGND VPWR VPWR _04577_ sky130_fd_sc_hd__or2_1
XFILLER_84_27 VGND VGND VPWR VPWR sky130_fd_sc_hd__fill_1
X_07918_ _03691_ _03738_ VGND VGND VPWR VPWR _03747_ sky130_fd_sc_hd__xnor2_1
XTAP_TAPCELL_ROW_104_2000 VGND VPWR sky130_fd_sc_hd__tapvpwrvgnd_1
X_07849_ _02634_ reg_next_pc\[13\] _02482_ VGND VGND VPWR VPWR _03700_ sky130_fd_sc_hd__mux2_2
XFILLER_57_865 VGND VGND VPWR VPWR sky130_fd_sc_hd__fill_1
XFILLER_56_342 VGND VGND VPWR VPWR sky130_fd_sc_hd__decap_6
XFILLER_71_334 VGND VGND VPWR VPWR sky130_fd_sc_hd__fill_2
XFILLER_71_312 VGND VGND VPWR VPWR sky130_fd_sc_hd__fill_2
X_10860_ clknet_leaf_136_clk _00922_ VGND VGND VPWR VPWR cpuregs\[1\]\[4\] sky130_fd_sc_hd__dfxtp_1
XFILLER_44_548 VGND VGND VPWR VPWR sky130_fd_sc_hd__fill_1
X_09519_ cpuregs\[31\]\[24\] _02683_ _04865_ VGND VGND VPWR VPWR _01182_ sky130_fd_sc_hd__mux2_1
XTAP_TAPCELL_ROW_27_757 VGND VPWR sky130_fd_sc_hd__tapvpwrvgnd_1
XTAP_TAPCELL_ROW_27_768 VGND VPWR sky130_fd_sc_hd__tapvpwrvgnd_1
XFILLER_140_77 VGND VGND VPWR VPWR sky130_fd_sc_hd__decap_6
XTAP_TAPCELL_ROW_84_1674 VGND VPWR sky130_fd_sc_hd__tapvpwrvgnd_1
X_10791_ clknet_leaf_103_clk _00856_ VGND VGND VPWR VPWR instr_lw sky130_fd_sc_hd__dfxtp_1
XFILLER_52_570 VGND VGND VPWR VPWR sky130_fd_sc_hd__fill_1
XFILLER_12_412 VGND VGND VPWR VPWR sky130_fd_sc_hd__decap_8
XFILLER_138_642 VGND VGND VPWR VPWR sky130_fd_sc_hd__fill_2
X_11412_ clknet_leaf_13_clk _01456_ VGND VGND VPWR VPWR cpuregs\[8\]\[10\] sky130_fd_sc_hd__dfxtp_1
XFILLER_40_798 VGND VGND VPWR VPWR sky130_fd_sc_hd__decap_8
XFILLER_138_697 VGND VGND VPWR VPWR sky130_fd_sc_hd__decap_3
XFILLER_126_837 VPWR VGND VPWR VGND sky130_ef_sc_hd__decap_12
XFILLER_152_133 VGND VGND VPWR VPWR sky130_fd_sc_hd__decap_6
XTAP_TAPCELL_ROW_115_2173 VGND VPWR sky130_fd_sc_hd__tapvpwrvgnd_1
X_11343_ clknet_leaf_145_clk _01387_ VGND VGND VPWR VPWR cpuregs\[6\]\[5\] sky130_fd_sc_hd__dfxtp_1
X_11274_ clknet_leaf_124_clk _01321_ VGND VGND VPWR VPWR cpuregs\[4\]\[3\] sky130_fd_sc_hd__dfxtp_1
XFILLER_152_177 VPWR VGND VPWR VGND sky130_ef_sc_hd__decap_12
XFILLER_140_328 VGND VGND VPWR VPWR sky130_fd_sc_hd__decap_6
XFILLER_140_317 VGND VGND VPWR VPWR sky130_fd_sc_hd__fill_2
XFILLER_134_881 VPWR VGND VPWR VGND sky130_ef_sc_hd__decap_12
XFILLER_106_572 VGND VGND VPWR VPWR sky130_fd_sc_hd__decap_6
X_10225_ clknet_leaf_14_clk _00355_ VGND VGND VPWR VPWR cpuregs\[14\]\[31\] sky130_fd_sc_hd__dfxtp_1
XFILLER_4_699 VGND VGND VPWR VPWR sky130_fd_sc_hd__fill_1
X_10156_ clknet_leaf_44_clk _00286_ VGND VGND VPWR VPWR cpuregs\[21\]\[26\] sky130_fd_sc_hd__dfxtp_1
X_10087_ clknet_leaf_75_clk _00217_ VGND VGND VPWR VPWR cpuregs\[2\]\[21\] sky130_fd_sc_hd__dfxtp_1
XFILLER_75_673 VGND VGND VPWR VPWR sky130_fd_sc_hd__decap_4
XFILLER_48_876 VPWR VGND VPWR VGND sky130_ef_sc_hd__decap_12
XFILLER_62_345 VGND VGND VPWR VPWR sky130_fd_sc_hd__fill_2
XFILLER_35_559 VGND VGND VPWR VPWR sky130_fd_sc_hd__fill_1
X_10989_ clknet_leaf_75_clk _01051_ VGND VGND VPWR VPWR cpuregs\[18\]\[21\] sky130_fd_sc_hd__dfxtp_1
XFILLER_30_231 VGND VGND VPWR VPWR sky130_fd_sc_hd__decap_3
X_05200_ net3 _01666_ _01667_ net20 _01772_ VGND VGND VPWR VPWR _01804_ sky130_fd_sc_hd__o221a_1
XFILLER_30_297 VGND VGND VPWR VPWR sky130_fd_sc_hd__fill_2
XFILLER_128_163 VGND VGND VPWR VPWR sky130_fd_sc_hd__fill_1
X_06180_ _02583_ _02635_ _02636_ VGND VGND VPWR VPWR _02637_ sky130_fd_sc_hd__or3_1
XFILLER_144_645 VGND VGND VPWR VPWR sky130_fd_sc_hd__fill_1
X_05131_ _01732_ _01735_ _01740_ cpu_state\[3\] VGND VGND VPWR VPWR _04905_ sky130_fd_sc_hd__a22o_1
X_05062_ cpu_state\[6\] _01673_ _01676_ VGND VGND VPWR VPWR _01677_ sky130_fd_sc_hd__a21oi_1
X_09870_ cpuregs\[0\]\[0\] VGND VGND VPWR VPWR _01478_ sky130_fd_sc_hd__clkbuf_1
X_08821_ net270 _04500_ _04499_ _01560_ VGND VGND VPWR VPWR _04505_ sky130_fd_sc_hd__o211a_1
XTAP_TAPCELL_ROW_5_419 VGND VPWR sky130_fd_sc_hd__tapvpwrvgnd_1
XTAP_TAPCELL_ROW_5_408 VGND VPWR sky130_fd_sc_hd__tapvpwrvgnd_1
XTAP_TAPCELL_ROW_146_2667 VGND VPWR sky130_fd_sc_hd__tapvpwrvgnd_1
XFILLER_112_597 VGND VGND VPWR VPWR sky130_fd_sc_hd__fill_1
X_08752_ net208 _01585_ _04438_ _04439_ VGND VGND VPWR VPWR _00820_ sky130_fd_sc_hd__o22a_1
X_05964_ net197 _02485_ _01582_ VGND VGND VPWR VPWR net90 sky130_fd_sc_hd__mux2_1
XFILLER_38_320 VGND VGND VPWR VPWR sky130_fd_sc_hd__decap_4
X_07703_ count_instr\[19\] _03609_ net34 VGND VGND VPWR VPWR _03611_ sky130_fd_sc_hd__o21ai_1
XFILLER_54_813 VGND VGND VPWR VPWR sky130_fd_sc_hd__decap_6
X_08683_ cpuregs\[24\]\[11\] cpuregs\[25\]\[11\] cpuregs\[26\]\[11\] cpuregs\[27\]\[11\]
+ net279 _00008_ VGND VGND VPWR VPWR _04374_ sky130_fd_sc_hd__mux4_1
XFILLER_38_353 VGND VGND VPWR VPWR sky130_fd_sc_hd__decap_8
X_04915_ reg_pc\[2\] VGND VGND VPWR VPWR _01548_ sky130_fd_sc_hd__inv_2
X_07634_ _02657_ cpuregs\[17\]\[18\] _03574_ VGND VGND VPWR VPWR _00566_ sky130_fd_sc_hd__mux2_1
X_05895_ _02447_ _02449_ instr_sub VGND VGND VPWR VPWR _02450_ sky130_fd_sc_hd__mux2_1
XFILLER_54_19 VGND VGND VPWR VPWR sky130_fd_sc_hd__decap_8
XFILLER_26_526 VGND VGND VPWR VPWR sky130_fd_sc_hd__decap_6
X_07565_ cpuregs\[25\]\[16\] _02649_ _03571_ VGND VGND VPWR VPWR _00500_ sky130_fd_sc_hd__mux2_1
XTAP_TAPCELL_ROW_66_1382 VGND VPWR sky130_fd_sc_hd__tapvpwrvgnd_1
XFILLER_53_378 VGND VGND VPWR VPWR sky130_fd_sc_hd__fill_1
XTAP_TAPCELL_ROW_24_716 VGND VPWR sky130_fd_sc_hd__tapvpwrvgnd_1
X_07496_ cpuregs\[26\]\[14\] _02641_ _03568_ VGND VGND VPWR VPWR _00434_ sky130_fd_sc_hd__mux2_1
X_09304_ net168 _04206_ VGND VGND VPWR VPWR _04812_ sky130_fd_sc_hd__or2_1
XTAP_TAPCELL_ROW_66_1393 VGND VPWR sky130_fd_sc_hd__tapvpwrvgnd_1
X_06516_ reg_pc\[7\] _02751_ _02946_ _02715_ VGND VGND VPWR VPWR _02947_ sky130_fd_sc_hd__a211o_1
X_09235_ cpuregs\[1\]\[14\] _02641_ net244 VGND VGND VPWR VPWR _00932_ sky130_fd_sc_hd__mux2_1
XFILLER_70_29 VPWR VGND VPWR VGND sky130_ef_sc_hd__decap_12
XFILLER_10_905 VGND VGND VPWR VPWR sky130_fd_sc_hd__decap_4
X_06447_ net606 _02721_ _02744_ _02879_ VGND VGND VPWR VPWR _02880_ sky130_fd_sc_hd__o211a_1
XFILLER_21_286 VGND VGND VPWR VPWR sky130_fd_sc_hd__decap_8
XFILLER_135_612 VGND VGND VPWR VPWR sky130_fd_sc_hd__decap_4
X_09166_ _04778_ _04783_ instr_rdcycle _04747_ VGND VGND VPWR VPWR _00881_ sky130_fd_sc_hd__a2bb2o_1
X_06378_ net262 _02810_ _01579_ VGND VGND VPWR VPWR _02813_ sky130_fd_sc_hd__o21a_1
X_05329_ _01921_ _01922_ VGND VGND VPWR VPWR _01923_ sky130_fd_sc_hd__nand2_1
X_08117_ _03919_ _03921_ _03917_ VGND VGND VPWR VPWR _03930_ sky130_fd_sc_hd__a21o_1
X_09097_ mem_rdata_q\[13\] _01557_ VGND VGND VPWR VPWR _04751_ sky130_fd_sc_hd__or2_2
XFILLER_135_667 VGND VGND VPWR VPWR sky130_fd_sc_hd__decap_4
XFILLER_107_347 VGND VGND VPWR VPWR sky130_fd_sc_hd__decap_8
X_08048_ _03865_ _03866_ net34 VGND VGND VPWR VPWR _00689_ sky130_fd_sc_hd__o21a_1
XFILLER_122_339 VGND VGND VPWR VPWR sky130_fd_sc_hd__fill_1
XFILLER_116_881 VPWR VGND VPWR VGND sky130_ef_sc_hd__decap_12
XFILLER_135_55 VGND VGND VPWR VPWR sky130_fd_sc_hd__fill_1
XFILLER_0_113 VPWR VGND VPWR VGND sky130_ef_sc_hd__decap_12
XFILLER_1_669 VGND VGND VPWR VPWR sky130_fd_sc_hd__decap_3
X_10010_ clknet_leaf_136_clk _00140_ VGND VGND VPWR VPWR cpuregs\[30\]\[8\] sky130_fd_sc_hd__dfxtp_1
XFILLER_135_77 VGND VGND VPWR VPWR sky130_fd_sc_hd__decap_3
XFILLER_131_895 VGND VGND VPWR VPWR sky130_fd_sc_hd__fill_1
XFILLER_130_361 VGND VGND VPWR VPWR sky130_fd_sc_hd__decap_3
XTAP_TAPCELL_ROW_110_2092 VGND VPWR sky130_fd_sc_hd__tapvpwrvgnd_1
X_09999_ clknet_leaf_33_clk _00129_ VGND VGND VPWR VPWR cpuregs\[12\]\[29\] sky130_fd_sc_hd__dfxtp_1
XFILLER_88_286 VGND VGND VPWR VPWR sky130_fd_sc_hd__decap_4
XTAP_TAPCELL_ROW_86_1714 VGND VPWR sky130_fd_sc_hd__tapvpwrvgnd_1
XTAP_TAPCELL_ROW_86_1703 VGND VPWR sky130_fd_sc_hd__tapvpwrvgnd_1
XFILLER_28_53 VGND VGND VPWR VPWR sky130_fd_sc_hd__decap_8
X_10912_ clknet_leaf_31_clk _00974_ VGND VGND VPWR VPWR net144 sky130_fd_sc_hd__dfxtp_1
XFILLER_84_481 VGND VGND VPWR VPWR sky130_fd_sc_hd__fill_1
XFILLER_72_698 VGND VGND VPWR VPWR sky130_fd_sc_hd__fill_2
XFILLER_71_175 VGND VGND VPWR VPWR sky130_fd_sc_hd__fill_1
X_10843_ clknet_leaf_111_clk _00908_ VGND VGND VPWR VPWR decoded_imm_j\[1\] sky130_fd_sc_hd__dfxtp_2
XFILLER_44_41 VGND VGND VPWR VPWR sky130_fd_sc_hd__decap_4
X_10774_ clknet_leaf_50_clk alu_out\[27\] VGND VGND VPWR VPWR alu_out_q\[27\] sky130_fd_sc_hd__dfxtp_1
XFILLER_13_776 VGND VGND VPWR VPWR sky130_fd_sc_hd__decap_8
XFILLER_40_562 VGND VGND VPWR VPWR sky130_fd_sc_hd__fill_1
XTAP_TAPCELL_ROW_117_2202 VGND VPWR sky130_fd_sc_hd__tapvpwrvgnd_1
XFILLER_8_246 VGND VGND VPWR VPWR sky130_fd_sc_hd__decap_6
XFILLER_8_213 VPWR VGND VPWR VGND sky130_ef_sc_hd__decap_12
XFILLER_145_409 VGND VGND VPWR VPWR sky130_fd_sc_hd__decap_8
XFILLER_138_494 VGND VGND VPWR VPWR sky130_fd_sc_hd__fill_2
XFILLER_126_645 VGND VGND VPWR VPWR sky130_fd_sc_hd__decap_4
XFILLER_126_634 VGND VGND VPWR VPWR sky130_fd_sc_hd__decap_8
XFILLER_125_111 VGND VGND VPWR VPWR sky130_fd_sc_hd__fill_1
XTAP_TAPCELL_ROW_97_1876 VGND VPWR sky130_fd_sc_hd__tapvpwrvgnd_1
XFILLER_60_95 VGND VGND VPWR VPWR sky130_fd_sc_hd__decap_4
XTAP_TAPCELL_ROW_130_2413 VGND VPWR sky130_fd_sc_hd__tapvpwrvgnd_1
X_11326_ clknet_leaf_42_clk _01373_ VGND VGND VPWR VPWR cpuregs\[5\]\[23\] sky130_fd_sc_hd__dfxtp_1
XTAP_TAPCELL_ROW_97_1887 VGND VPWR sky130_fd_sc_hd__tapvpwrvgnd_1
XTAP_TAPCELL_ROW_10_498 VGND VPWR sky130_fd_sc_hd__tapvpwrvgnd_1
XTAP_TAPCELL_ROW_10_487 VGND VPWR sky130_fd_sc_hd__tapvpwrvgnd_1
XFILLER_99_529 VPWR VGND VPWR VGND sky130_ef_sc_hd__decap_12
XFILLER_5_57 VPWR VGND VPWR VGND sky130_ef_sc_hd__decap_12
X_11257_ clknet_leaf_34_clk _01304_ VGND VGND VPWR VPWR cpuregs\[22\]\[18\] sky130_fd_sc_hd__dfxtp_1
XFILLER_106_380 VGND VGND VPWR VPWR sky130_fd_sc_hd__fill_1
XFILLER_79_231 VGND VGND VPWR VPWR sky130_fd_sc_hd__fill_1
XFILLER_79_220 VGND VGND VPWR VPWR sky130_fd_sc_hd__decap_4
X_10208_ clknet_leaf_27_clk _00338_ VGND VGND VPWR VPWR cpuregs\[14\]\[14\] sky130_fd_sc_hd__dfxtp_1
XFILLER_79_253 VGND VGND VPWR VPWR sky130_fd_sc_hd__fill_2
X_11188_ clknet_leaf_11_clk _01235_ VGND VGND VPWR VPWR cpuregs\[29\]\[13\] sky130_fd_sc_hd__dfxtp_1
XFILLER_94_223 VGND VGND VPWR VPWR sky130_fd_sc_hd__decap_4
X_10139_ clknet_leaf_0_clk _00269_ VGND VGND VPWR VPWR cpuregs\[21\]\[9\] sky130_fd_sc_hd__dfxtp_1
XTAP_TAPCELL_ROW_128_2386 VGND VPWR sky130_fd_sc_hd__tapvpwrvgnd_1
XTAP_TAPCELL_ROW_128_2375 VGND VPWR sky130_fd_sc_hd__tapvpwrvgnd_1
XFILLER_94_278 VGND VGND VPWR VPWR sky130_fd_sc_hd__fill_2
XFILLER_36_813 VPWR VGND VPWR VGND sky130_ef_sc_hd__decap_12
XFILLER_82_429 VGND VGND VPWR VPWR sky130_fd_sc_hd__fill_2
X_05680_ _02259_ _02183_ instr_sub VGND VGND VPWR VPWR _02260_ sky130_fd_sc_hd__mux2_1
XTAP_TAPCELL_ROW_141_2586 VGND VPWR sky130_fd_sc_hd__tapvpwrvgnd_1
X_07350_ _02588_ cpuregs\[9\]\[1\] _03563_ VGND VGND VPWR VPWR _00293_ sky130_fd_sc_hd__mux2_1
X_06301_ _01579_ _02738_ _01580_ VGND VGND VPWR VPWR _02739_ sky130_fd_sc_hd__o21a_1
X_09020_ _04683_ _04684_ _01558_ VGND VGND VPWR VPWR _04693_ sky130_fd_sc_hd__mux2_1
XFILLER_31_573 VGND VGND VPWR VPWR sky130_fd_sc_hd__fill_1
X_07281_ _03550_ _03555_ VGND VGND VPWR VPWR _03560_ sky130_fd_sc_hd__nor2_4
Xclkbuf_leaf_151_clk clknet_4_0_0_clk VGND VGND VPWR VPWR clknet_leaf_151_clk sky130_fd_sc_hd__clkbuf_8
XFILLER_129_461 VGND VGND VPWR VPWR sky130_fd_sc_hd__decap_4
X_06232_ _02678_ cpuregs\[11\]\[23\] _02582_ VGND VGND VPWR VPWR _00060_ sky130_fd_sc_hd__mux2_1
XFILLER_116_122 VGND VGND VPWR VPWR sky130_fd_sc_hd__decap_6
X_06163_ reg_pc\[10\] _02619_ VGND VGND VPWR VPWR _02623_ sky130_fd_sc_hd__xor2_1
X_05114_ count_instr\[36\] instr_rdinstrh instr_rdinstr count_instr\[4\] VGND VGND
+ VPWR VPWR _01725_ sky130_fd_sc_hd__a22o_1
XFILLER_49_19 VPWR VGND VPWR VGND sky130_ef_sc_hd__decap_12
X_06094_ _02563_ _02564_ _01558_ VGND VGND VPWR VPWR _02565_ sky130_fd_sc_hd__mux2_1
XTAP_TAPCELL_ROW_148_2707 VGND VPWR sky130_fd_sc_hd__tapvpwrvgnd_1
X_09922_ clknet_leaf_72_clk _00057_ VGND VGND VPWR VPWR cpuregs\[11\]\[20\] sky130_fd_sc_hd__dfxtp_1
XFILLER_131_125 VGND VGND VPWR VPWR sky130_fd_sc_hd__decap_3
X_05045_ cpu_state\[5\] _01633_ _01648_ VGND VGND VPWR VPWR _01663_ sky130_fd_sc_hd__and3_1
X_09853_ _02696_ cpuregs\[10\]\[27\] _04876_ VGND VGND VPWR VPWR _01537_ sky130_fd_sc_hd__mux2_1
XFILLER_98_573 VGND VGND VPWR VPWR sky130_fd_sc_hd__fill_2
X_09784_ _02683_ cpuregs\[7\]\[24\] _04874_ VGND VGND VPWR VPWR _01438_ sky130_fd_sc_hd__mux2_1
XFILLER_140_692 VGND VGND VPWR VPWR sky130_fd_sc_hd__decap_8
XFILLER_113_895 VGND VGND VPWR VPWR sky130_fd_sc_hd__fill_1
XFILLER_105_47 VGND VGND VPWR VPWR sky130_fd_sc_hd__decap_8
X_08804_ net269 _04485_ _04488_ _04266_ VGND VGND VPWR VPWR _04489_ sky130_fd_sc_hd__o211a_1
XFILLER_86_757 VGND VGND VPWR VPWR sky130_fd_sc_hd__decap_6
X_06996_ cpuregs\[28\]\[25\] cpuregs\[29\]\[25\] cpuregs\[30\]\[25\] cpuregs\[31\]\[25\]
+ net267 net261 VGND VGND VPWR VPWR _03409_ sky130_fd_sc_hd__mux4_1
X_08735_ cpuregs\[28\]\[14\] cpuregs\[29\]\[14\] cpuregs\[30\]\[14\] cpuregs\[31\]\[14\]
+ net275 net271 VGND VGND VPWR VPWR _04423_ sky130_fd_sc_hd__mux4_1
XFILLER_86_779 VGND VGND VPWR VPWR sky130_fd_sc_hd__decap_4
XPHY_EDGE_ROW_0_Left_154 VGND VGND VPWR VPWR sky130_fd_sc_hd__decap_3
X_05947_ net124 net216 _01665_ VGND VGND VPWR VPWR net110 sky130_fd_sc_hd__mux2_2
XFILLER_100_589 VPWR VGND VPWR VGND sky130_ef_sc_hd__decap_12
XFILLER_85_278 VGND VGND VPWR VPWR sky130_fd_sc_hd__fill_2
XTAP_TAPCELL_ROW_68_1422 VGND VPWR sky130_fd_sc_hd__tapvpwrvgnd_1
X_05878_ _02056_ _02434_ VGND VGND VPWR VPWR _02435_ sky130_fd_sc_hd__xnor2_1
X_08666_ cpuregs\[4\]\[10\] cpuregs\[5\]\[10\] cpuregs\[6\]\[10\] cpuregs\[7\]\[10\]
+ net278 net273 VGND VGND VPWR VPWR _04358_ sky130_fd_sc_hd__mux4_1
XFILLER_121_57 VGND VGND VPWR VPWR sky130_fd_sc_hd__decap_8
X_07617_ _02588_ cpuregs\[17\]\[1\] _03574_ VGND VGND VPWR VPWR _00549_ sky130_fd_sc_hd__mux2_1
X_08597_ _04282_ _04291_ _04292_ _01560_ _00010_ VGND VGND VPWR VPWR _04293_ sky130_fd_sc_hd__a221o_1
XTAP_TAPCELL_ROW_81_1633 VGND VPWR sky130_fd_sc_hd__tapvpwrvgnd_1
XTAP_TAPCELL_ROW_81_1622 VGND VPWR sky130_fd_sc_hd__tapvpwrvgnd_1
X_07548_ latched_rd\[1\] latched_rd\[0\] _03565_ VGND VGND VPWR VPWR _03571_ sky130_fd_sc_hd__and3b_4
XFILLER_41_337 VGND VGND VPWR VPWR sky130_fd_sc_hd__decap_4
XFILLER_139_225 VGND VGND VPWR VPWR sky130_fd_sc_hd__decap_8
X_07479_ cpuregs\[15\]\[30\] _02709_ net246 VGND VGND VPWR VPWR _00418_ sky130_fd_sc_hd__mux2_1
Xclkbuf_leaf_142_clk clknet_4_2_0_clk VGND VGND VPWR VPWR clknet_leaf_142_clk sky130_fd_sc_hd__clkbuf_8
XFILLER_14_77 VGND VGND VPWR VPWR sky130_fd_sc_hd__decap_6
X_10490_ clknet_leaf_106_clk _00620_ VGND VGND VPWR VPWR count_instr\[39\] sky130_fd_sc_hd__dfxtp_1
X_09218_ is_sll_srl_sra _04747_ _04797_ is_alu_reg_reg VGND VGND VPWR VPWR _00916_
+ sky130_fd_sc_hd__a22o_1
XFILLER_10_757 VPWR VGND VPWR VGND sky130_ef_sc_hd__decap_12
XFILLER_108_645 VPWR VGND VPWR VGND sky130_ef_sc_hd__decap_12
X_09149_ instr_slt _04748_ _04761_ _04772_ VGND VGND VPWR VPWR _00873_ sky130_fd_sc_hd__a22o_1
XFILLER_5_205 VPWR VGND VPWR VGND sky130_ef_sc_hd__decap_12
XFILLER_135_464 VGND VGND VPWR VPWR sky130_fd_sc_hd__fill_1
XTAP_TAPCELL_ROW_112_2121 VGND VPWR sky130_fd_sc_hd__tapvpwrvgnd_1
XTAP_TAPCELL_ROW_79_1595 VGND VPWR sky130_fd_sc_hd__tapvpwrvgnd_1
XFILLER_5_249 VGND VGND VPWR VPWR sky130_fd_sc_hd__decap_4
XFILLER_146_65 VPWR VGND VPWR VGND sky130_ef_sc_hd__decap_12
X_11111_ clknet_leaf_119_clk _01158_ VGND VGND VPWR VPWR cpuregs\[31\]\[0\] sky130_fd_sc_hd__dfxtp_1
XFILLER_122_136 VGND VGND VPWR VPWR sky130_fd_sc_hd__decap_4
XFILLER_150_489 VPWR VGND VPWR VGND sky130_ef_sc_hd__decap_12
X_11042_ clknet_leaf_104_clk _01099_ VGND VGND VPWR VPWR mem_rdata_q\[5\] sky130_fd_sc_hd__dfxtp_1
XFILLER_76_234 VGND VGND VPWR VPWR sky130_fd_sc_hd__fill_2
XFILLER_64_407 VPWR VGND VPWR VGND sky130_ef_sc_hd__decap_12
XFILLER_18_813 VPWR VGND VPWR VGND sky130_ef_sc_hd__decap_12
XFILLER_72_473 VGND VGND VPWR VPWR sky130_fd_sc_hd__decap_3
XFILLER_33_816 VPWR VGND VPWR VGND sky130_ef_sc_hd__decap_12
XTAP_TAPCELL_ROW_123_2294 VGND VPWR sky130_fd_sc_hd__tapvpwrvgnd_1
X_10826_ clknet_leaf_97_clk _00891_ VGND VGND VPWR VPWR decoded_imm_j\[9\] sky130_fd_sc_hd__dfxtp_1
XFILLER_60_657 VGND VGND VPWR VPWR sky130_fd_sc_hd__decap_6
XFILLER_32_337 VGND VGND VPWR VPWR sky130_fd_sc_hd__decap_4
XFILLER_9_500 VGND VGND VPWR VPWR sky130_fd_sc_hd__decap_4
XTAP_TAPCELL_ROW_15_568 VGND VPWR sky130_fd_sc_hd__tapvpwrvgnd_1
XFILLER_41_860 VPWR VGND VPWR VGND sky130_ef_sc_hd__decap_12
XTAP_TAPCELL_ROW_99_1916 VGND VPWR sky130_fd_sc_hd__tapvpwrvgnd_1
XFILLER_71_83 VGND VGND VPWR VPWR sky130_fd_sc_hd__fill_1
X_10757_ clknet_leaf_132_clk alu_out\[10\] VGND VGND VPWR VPWR alu_out_q\[10\] sky130_fd_sc_hd__dfxtp_1
Xclkbuf_leaf_133_clk clknet_4_3_0_clk VGND VGND VPWR VPWR clknet_leaf_133_clk sky130_fd_sc_hd__clkbuf_8
XTAP_TAPCELL_ROW_15_579 VGND VPWR sky130_fd_sc_hd__tapvpwrvgnd_1
X_10688_ clknet_leaf_84_clk _00786_ VGND VGND VPWR VPWR net41 sky130_fd_sc_hd__dfxtp_1
XFILLER_9_555 VGND VGND VPWR VPWR sky130_fd_sc_hd__decap_4
XFILLER_126_486 VPWR VGND VPWR VGND sky130_ef_sc_hd__decap_12
XFILLER_5_783 VGND VGND VPWR VPWR sky130_fd_sc_hd__fill_1
XFILLER_99_337 VGND VGND VPWR VPWR sky130_fd_sc_hd__decap_4
X_11309_ clknet_leaf_151_clk _01356_ VGND VGND VPWR VPWR cpuregs\[5\]\[6\] sky130_fd_sc_hd__dfxtp_1
XFILLER_113_169 VGND VGND VPWR VPWR sky130_fd_sc_hd__fill_1
X_06850_ _03157_ _03187_ _03264_ VGND VGND VPWR VPWR _03268_ sky130_fd_sc_hd__or3b_1
XFILLER_95_521 VGND VGND VPWR VPWR sky130_fd_sc_hd__fill_1
XFILLER_67_234 VGND VGND VPWR VPWR sky130_fd_sc_hd__decap_4
XTAP_TAPCELL_ROW_143_2615 VGND VPWR sky130_fd_sc_hd__tapvpwrvgnd_1
X_05801_ _02364_ _02365_ instr_sub VGND VGND VPWR VPWR _02366_ sky130_fd_sc_hd__mux2_1
XTAP_TAPCELL_ROW_143_2626 VGND VPWR sky130_fd_sc_hd__tapvpwrvgnd_1
X_06781_ cpuregs\[0\]\[17\] cpuregs\[1\]\[17\] cpuregs\[2\]\[17\] cpuregs\[3\]\[17\]
+ net265 net260 VGND VGND VPWR VPWR _03202_ sky130_fd_sc_hd__mux4_1
XFILLER_83_727 VGND VGND VPWR VPWR sky130_fd_sc_hd__fill_1
X_05732_ _02123_ _02304_ VGND VGND VPWR VPWR _02305_ sky130_fd_sc_hd__nor2_1
XFILLER_63_440 VGND VGND VPWR VPWR sky130_fd_sc_hd__fill_1
X_08520_ cpuregs\[0\]\[0\] cpuregs\[1\]\[0\] cpuregs\[2\]\[0\] cpuregs\[3\]\[0\] net279
+ _00008_ VGND VGND VPWR VPWR _04222_ sky130_fd_sc_hd__mux4_1
X_08451_ _04181_ _04187_ _01580_ VGND VGND VPWR VPWR _04188_ sky130_fd_sc_hd__mux2_1
X_05663_ net606 net108 _02238_ VGND VGND VPWR VPWR _02245_ sky130_fd_sc_hd__and3_1
XFILLER_51_613 VGND VGND VPWR VPWR sky130_fd_sc_hd__decap_3
X_07402_ cpuregs\[14\]\[20\] _02665_ _03564_ VGND VGND VPWR VPWR _00344_ sky130_fd_sc_hd__mux2_1
XFILLER_51_646 VGND VGND VPWR VPWR sky130_fd_sc_hd__fill_1
XFILLER_50_123 VPWR VGND VPWR VGND sky130_ef_sc_hd__decap_12
XFILLER_23_337 VGND VGND VPWR VPWR sky130_fd_sc_hd__decap_8
XFILLER_24_849 VPWR VGND VPWR VGND sky130_ef_sc_hd__decap_12
XFILLER_149_501 VGND VGND VPWR VPWR sky130_fd_sc_hd__decap_3
X_08382_ count_cycle\[44\] count_cycle\[45\] _04134_ VGND VGND VPWR VPWR _04138_ sky130_fd_sc_hd__and3_1
XTAP_TAPCELL_ROW_63_1341 VGND VPWR sky130_fd_sc_hd__tapvpwrvgnd_1
X_05594_ net125 net199 VGND VGND VPWR VPWR _02177_ sky130_fd_sc_hd__and2b_1
XTAP_TAPCELL_ROW_34_877 VGND VPWR sky130_fd_sc_hd__tapvpwrvgnd_1
X_07333_ cpuregs\[21\]\[17\] _02654_ net248 VGND VGND VPWR VPWR _00277_ sky130_fd_sc_hd__mux2_1
Xclkbuf_leaf_124_clk clknet_4_8_0_clk VGND VGND VPWR VPWR clknet_leaf_124_clk sky130_fd_sc_hd__clkbuf_8
XFILLER_32_893 VGND VGND VPWR VPWR sky130_fd_sc_hd__decap_3
XFILLER_136_206 VPWR VGND VPWR VGND sky130_ef_sc_hd__decap_12
X_07264_ cpuregs\[2\]\[15\] _02646_ net250 VGND VGND VPWR VPWR _00211_ sky130_fd_sc_hd__mux2_1
X_09003_ _04673_ _04675_ _04676_ _00010_ _01560_ VGND VGND VPWR VPWR _04677_ sky130_fd_sc_hd__a221o_1
X_06215_ _02663_ _02664_ _02584_ VGND VGND VPWR VPWR _02665_ sky130_fd_sc_hd__mux2_8
X_07195_ cpuregs\[30\]\[13\] _02638_ net252 VGND VGND VPWR VPWR _00145_ sky130_fd_sc_hd__mux2_1
XFILLER_3_709 VPWR VGND VPWR VGND sky130_ef_sc_hd__decap_12
XFILLER_105_604 VPWR VGND VPWR VGND sky130_ef_sc_hd__decap_12
X_06146_ reg_pc\[6\] reg_pc\[5\] _02595_ reg_pc\[7\] VGND VGND VPWR VPWR _02609_ sky130_fd_sc_hd__a31o_1
X_06077_ cpuregs\[16\]\[3\] cpuregs\[17\]\[3\] cpuregs\[18\]\[3\] cpuregs\[19\]\[3\]
+ net279 _00008_ VGND VGND VPWR VPWR _02549_ sky130_fd_sc_hd__mux4_1
XFILLER_99_871 VGND VGND VPWR VPWR sky130_fd_sc_hd__decap_4
X_05028_ _01634_ _01636_ _01647_ _01607_ VGND VGND VPWR VPWR _01651_ sky130_fd_sc_hd__a31o_1
X_09905_ clknet_leaf_139_clk _00040_ VGND VGND VPWR VPWR cpuregs\[11\]\[3\] sky130_fd_sc_hd__dfxtp_1
XFILLER_76_17 VGND VGND VPWR VPWR sky130_fd_sc_hd__decap_8
XFILLER_58_212 VGND VGND VPWR VPWR sky130_fd_sc_hd__decap_6
XFILLER_59_779 VGND VGND VPWR VPWR sky130_fd_sc_hd__decap_4
XFILLER_58_234 VGND VGND VPWR VPWR sky130_fd_sc_hd__fill_1
X_09836_ _02624_ cpuregs\[10\]\[10\] _04876_ VGND VGND VPWR VPWR _01520_ sky130_fd_sc_hd__mux2_1
XFILLER_46_407 VGND VGND VPWR VPWR sky130_fd_sc_hd__fill_1
X_06979_ _03384_ _03391_ _03392_ _01581_ _01580_ VGND VGND VPWR VPWR _03393_ sky130_fd_sc_hd__a221o_1
X_09767_ _02612_ cpuregs\[7\]\[7\] _04874_ VGND VGND VPWR VPWR _01421_ sky130_fd_sc_hd__mux2_1
XFILLER_92_27 VGND VGND VPWR VPWR sky130_fd_sc_hd__fill_1
X_08718_ cpuregs\[24\]\[13\] cpuregs\[25\]\[13\] cpuregs\[26\]\[13\] cpuregs\[27\]\[13\]
+ net275 net271 VGND VGND VPWR VPWR _04407_ sky130_fd_sc_hd__mux4_1
X_09698_ _02598_ cpuregs\[5\]\[4\] _04872_ VGND VGND VPWR VPWR _01354_ sky130_fd_sc_hd__mux2_1
Xrebuffer61 net450 VGND VGND VPWR VPWR net447 sky130_fd_sc_hd__dlygate4sd1_1
Xrebuffer50 net437 VGND VGND VPWR VPWR net436 sky130_fd_sc_hd__dlygate4sd1_1
XFILLER_26_164 VGND VGND VPWR VPWR sky130_fd_sc_hd__fill_1
X_08649_ cpuregs\[12\]\[9\] cpuregs\[13\]\[9\] cpuregs\[14\]\[9\] cpuregs\[15\]\[9\]
+ net278 net273 VGND VGND VPWR VPWR _04342_ sky130_fd_sc_hd__mux4_1
XFILLER_81_281 VGND VGND VPWR VPWR sky130_fd_sc_hd__fill_2
XFILLER_26_186 VGND VGND VPWR VPWR sky130_fd_sc_hd__decap_8
XFILLER_148_3 VPWR VGND VPWR VGND sky130_ef_sc_hd__decap_12
XPHY_EDGE_ROW_54_Left_208 VGND VGND VPWR VPWR sky130_fd_sc_hd__decap_3
XFILLER_25_76 VGND VGND VPWR VPWR sky130_fd_sc_hd__decap_3
X_10611_ clknet_leaf_109_clk _00741_ VGND VGND VPWR VPWR count_cycle\[34\] sky130_fd_sc_hd__dfxtp_1
Xclkbuf_leaf_115_clk clknet_4_10_0_clk VGND VGND VPWR VPWR clknet_leaf_115_clk sky130_fd_sc_hd__clkbuf_8
XTAP_TAPCELL_ROW_12_516 VGND VPWR sky130_fd_sc_hd__tapvpwrvgnd_1
XTAP_TAPCELL_ROW_12_527 VGND VPWR sky130_fd_sc_hd__tapvpwrvgnd_1
XFILLER_128_707 VPWR VGND VPWR VGND sky130_ef_sc_hd__decap_12
X_10542_ clknet_leaf_66_clk _00672_ VGND VGND VPWR VPWR reg_pc\[28\] sky130_fd_sc_hd__dfxtp_2
XFILLER_50_690 VGND VGND VPWR VPWR sky130_fd_sc_hd__decap_3
XFILLER_127_217 VGND VGND VPWR VPWR sky130_fd_sc_hd__decap_6
XFILLER_6_525 VGND VGND VPWR VPWR sky130_fd_sc_hd__decap_6
X_10473_ clknet_leaf_83_clk _00603_ VGND VGND VPWR VPWR count_instr\[22\] sky130_fd_sc_hd__dfxtp_1
XTAP_TAPCELL_ROW_94_1835 VGND VPWR sky130_fd_sc_hd__tapvpwrvgnd_1
Xrebuffer195 net582 VGND VGND VPWR VPWR net581 sky130_fd_sc_hd__dlygate4sd1_1
Xrebuffer184 net571 VGND VGND VPWR VPWR net570 sky130_fd_sc_hd__clkbuf_2
XFILLER_108_497 VGND VGND VPWR VPWR sky130_fd_sc_hd__fill_2
XFILLER_151_765 VPWR VGND VPWR VGND sky130_ef_sc_hd__decap_12
XFILLER_150_253 VPWR VGND VPWR VGND sky130_ef_sc_hd__decap_12
XFILLER_97_819 VPWR VGND VPWR VGND sky130_ef_sc_hd__decap_12
XPHY_EDGE_ROW_63_Left_217 VGND VGND VPWR VPWR sky130_fd_sc_hd__decap_3
X_11025_ clknet_leaf_47_clk _01087_ VGND VGND VPWR VPWR cpuregs\[19\]\[25\] sky130_fd_sc_hd__dfxtp_1
XFILLER_77_532 VGND VGND VPWR VPWR sky130_fd_sc_hd__decap_6
XFILLER_49_212 VGND VGND VPWR VPWR sky130_fd_sc_hd__decap_3
XFILLER_77_554 VGND VGND VPWR VPWR sky130_fd_sc_hd__decap_6
XTAP_TAPCELL_ROW_125_2334 VGND VPWR sky130_fd_sc_hd__tapvpwrvgnd_1
XFILLER_77_598 VPWR VGND VPWR VGND sky130_ef_sc_hd__decap_12
XFILLER_65_727 VGND VGND VPWR VPWR sky130_fd_sc_hd__fill_1
XFILLER_66_83 VGND VGND VPWR VPWR sky130_fd_sc_hd__fill_1
XFILLER_18_654 VGND VGND VPWR VPWR sky130_fd_sc_hd__decap_3
XFILLER_92_579 VGND VGND VPWR VPWR sky130_fd_sc_hd__decap_3
XFILLER_33_613 VGND VGND VPWR VPWR sky130_fd_sc_hd__decap_3
XPHY_EDGE_ROW_72_Left_226 VGND VGND VPWR VPWR sky130_fd_sc_hd__decap_3
XFILLER_60_465 VGND VGND VPWR VPWR sky130_fd_sc_hd__fill_2
XTAP_TAPCELL_ROW_103_1986 VGND VPWR sky130_fd_sc_hd__tapvpwrvgnd_1
XTAP_TAPCELL_ROW_103_1975 VGND VPWR sky130_fd_sc_hd__tapvpwrvgnd_1
X_10809_ clknet_leaf_103_clk _00874_ VGND VGND VPWR VPWR instr_sltu sky130_fd_sc_hd__dfxtp_1
Xclkbuf_leaf_106_clk clknet_4_11_0_clk VGND VGND VPWR VPWR clknet_leaf_106_clk sky130_fd_sc_hd__clkbuf_8
XANTENNA_19 net123 VGND VGND VPWR VPWR sky130_fd_sc_hd__diode_2
XFILLER_14_893 VPWR VGND VPWR VGND sky130_ef_sc_hd__decap_12
XTAP_TAPCELL_ROW_31_825 VGND VPWR sky130_fd_sc_hd__tapvpwrvgnd_1
XFILLER_119_729 VPWR VGND VPWR VGND sky130_ef_sc_hd__decap_12
XFILLER_146_526 VGND VGND VPWR VPWR sky130_fd_sc_hd__decap_6
XFILLER_118_228 VPWR VGND VPWR VGND sky130_ef_sc_hd__decap_12
X_06000_ net185 _02503_ _01582_ VGND VGND VPWR VPWR net78 sky130_fd_sc_hd__mux2_1
XFILLER_63_3 VGND VGND VPWR VPWR sky130_fd_sc_hd__fill_1
Xoutput104 net104 VGND VGND VPWR VPWR mem_la_wdata[16] sky130_fd_sc_hd__buf_2
Xoutput115 net115 VGND VGND VPWR VPWR mem_la_wdata[26] sky130_fd_sc_hd__buf_2
Xoutput148 net148 VGND VGND VPWR VPWR mem_wdata[21] sky130_fd_sc_hd__buf_2
Xoutput159 net159 VGND VGND VPWR VPWR mem_wdata[31] sky130_fd_sc_hd__buf_2
XPHY_EDGE_ROW_81_Left_235 VGND VGND VPWR VPWR sky130_fd_sc_hd__decap_3
Xoutput137 net137 VGND VGND VPWR VPWR mem_wdata[11] sky130_fd_sc_hd__buf_2
Xoutput126 net126 VGND VGND VPWR VPWR mem_la_wdata[7] sky130_fd_sc_hd__buf_2
XFILLER_130_905 VGND VGND VPWR VPWR sky130_fd_sc_hd__decap_4
XFILLER_99_167 VGND VGND VPWR VPWR sky130_fd_sc_hd__fill_1
X_07951_ _03763_ _03765_ _03762_ VGND VGND VPWR VPWR _03777_ sky130_fd_sc_hd__o21a_1
X_06902_ net184 _03318_ net237 VGND VGND VPWR VPWR _00090_ sky130_fd_sc_hd__mux2_1
X_07882_ _02700_ reg_next_pc\[29\] net596 VGND VGND VPWR VPWR _03717_ sky130_fd_sc_hd__mux2_1
X_06833_ cpuregs\[4\]\[19\] cpuregs\[5\]\[19\] cpuregs\[6\]\[19\] cpuregs\[7\]\[19\]
+ _00012_ _00013_ VGND VGND VPWR VPWR _03252_ sky130_fd_sc_hd__mux4_1
X_09621_ _02696_ cpuregs\[3\]\[27\] _04868_ VGND VGND VPWR VPWR _01281_ sky130_fd_sc_hd__mux2_1
XFILLER_83_502 VGND VGND VPWR VPWR sky130_fd_sc_hd__fill_2
X_09552_ cpuregs\[23\]\[24\] _02683_ _04866_ VGND VGND VPWR VPWR _01214_ sky130_fd_sc_hd__mux2_1
X_06764_ net236 _03170_ _03185_ _03156_ VGND VGND VPWR VPWR _00085_ sky130_fd_sc_hd__a31o_1
XTAP_TAPCELL_ROW_39_958 VGND VPWR sky130_fd_sc_hd__tapvpwrvgnd_1
X_08503_ net88 net57 _04208_ VGND VGND VPWR VPWR _00801_ sky130_fd_sc_hd__mux2_1
XPHY_EDGE_ROW_90_Left_244 VGND VGND VPWR VPWR sky130_fd_sc_hd__decap_3
XFILLER_70_218 VGND VGND VPWR VPWR sky130_fd_sc_hd__fill_2
X_05715_ _02133_ _02288_ VGND VGND VPWR VPWR _02290_ sky130_fd_sc_hd__or2_1
X_09483_ cpuregs\[24\]\[21\] _02670_ _04864_ VGND VGND VPWR VPWR _01147_ sky130_fd_sc_hd__mux2_1
X_06695_ cpuregs\[20\]\[14\] cpuregs\[21\]\[14\] cpuregs\[22\]\[14\] cpuregs\[23\]\[14\]
+ net265 net260 VGND VGND VPWR VPWR _03119_ sky130_fd_sc_hd__mux4_1
XFILLER_63_281 VGND VGND VPWR VPWR sky130_fd_sc_hd__decap_4
X_05646_ _02071_ _02227_ _02115_ _02203_ VGND VGND VPWR VPWR _02229_ sky130_fd_sc_hd__o2bb2a_1
X_08434_ decoded_imm\[31\] net195 VGND VGND VPWR VPWR _04171_ sky130_fd_sc_hd__xnor2_1
XFILLER_51_432 VPWR VGND VPWR VGND sky130_ef_sc_hd__decap_12
X_08365_ count_cycle\[38\] _04124_ count_cycle\[39\] VGND VGND VPWR VPWR _04127_ sky130_fd_sc_hd__a21o_1
X_05577_ _02158_ _02159_ VGND VGND VPWR VPWR _02160_ sky130_fd_sc_hd__nand2_1
XFILLER_23_167 VGND VGND VPWR VPWR sky130_fd_sc_hd__fill_1
X_07316_ cpuregs\[21\]\[0\] _02586_ net248 VGND VGND VPWR VPWR _00260_ sky130_fd_sc_hd__mux2_1
X_08296_ _04082_ net34 _04081_ VGND VGND VPWR VPWR _00721_ sky130_fd_sc_hd__and3b_1
X_07247_ cpuregs\[13\]\[31\] _02712_ net251 VGND VGND VPWR VPWR _00195_ sky130_fd_sc_hd__mux2_1
Xclkbuf_4_2_0_clk clknet_0_clk VGND VGND VPWR VPWR clknet_4_2_0_clk sky130_fd_sc_hd__clkbuf_8
XFILLER_105_401 VGND VGND VPWR VPWR sky130_fd_sc_hd__decap_8
XTAP_TAPCELL_ROW_76_1543 VGND VPWR sky130_fd_sc_hd__tapvpwrvgnd_1
XFILLER_3_517 VPWR VGND VPWR VGND sky130_ef_sc_hd__decap_12
X_07178_ latched_rd\[0\] latched_rd\[1\] VGND VGND VPWR VPWR _03553_ sky130_fd_sc_hd__and2b_4
XFILLER_132_220 VGND VGND VPWR VPWR sky130_fd_sc_hd__decap_8
XTAP_TAPCELL_ROW_76_1554 VGND VPWR sky130_fd_sc_hd__tapvpwrvgnd_1
X_06129_ reg_pc\[4\] reg_pc\[3\] reg_pc\[2\] VGND VGND VPWR VPWR _02595_ sky130_fd_sc_hd__and3_1
XFILLER_78_307 VGND VGND VPWR VPWR sky130_fd_sc_hd__fill_1
XFILLER_120_415 VGND VGND VPWR VPWR sky130_fd_sc_hd__decap_4
XFILLER_87_841 VGND VGND VPWR VPWR sky130_fd_sc_hd__decap_8
XFILLER_143_55 VGND VGND VPWR VPWR sky130_fd_sc_hd__fill_1
X_09819_ _02691_ cpuregs\[8\]\[26\] _04875_ VGND VGND VPWR VPWR _01472_ sky130_fd_sc_hd__mux2_1
XFILLER_74_502 VGND VGND VPWR VPWR sky130_fd_sc_hd__decap_3
XPHY_EDGE_ROW_129_Left_283 VGND VGND VPWR VPWR sky130_fd_sc_hd__decap_3
XTAP_TAPCELL_ROW_107_2042 VGND VPWR sky130_fd_sc_hd__tapvpwrvgnd_1
XFILLER_86_395 VGND VGND VPWR VPWR sky130_fd_sc_hd__fill_1
XFILLER_46_237 VGND VGND VPWR VPWR sky130_fd_sc_hd__decap_4
XFILLER_62_708 VPWR VGND VPWR VGND sky130_ef_sc_hd__decap_12
XTAP_TAPCELL_ROW_17_608 VGND VPWR sky130_fd_sc_hd__tapvpwrvgnd_1
XFILLER_36_53 VGND VGND VPWR VPWR sky130_fd_sc_hd__fill_1
XFILLER_42_421 VGND VGND VPWR VPWR sky130_fd_sc_hd__decap_6
XTAP_TAPCELL_ROW_120_2253 VGND VPWR sky130_fd_sc_hd__tapvpwrvgnd_1
XFILLER_42_443 VPWR VGND VPWR VGND sky130_ef_sc_hd__decap_12
XFILLER_52_41 VPWR VGND VPWR VGND sky130_ef_sc_hd__decap_12
XFILLER_14_189 VGND VGND VPWR VPWR sky130_fd_sc_hd__decap_6
XFILLER_30_616 VPWR VGND VPWR VGND sky130_ef_sc_hd__decap_12
XFILLER_30_638 VGND VGND VPWR VPWR sky130_fd_sc_hd__decap_6
XFILLER_11_841 VPWR VGND VPWR VGND sky130_ef_sc_hd__decap_12
XPHY_EDGE_ROW_138_Left_292 VGND VGND VPWR VPWR sky130_fd_sc_hd__decap_3
XFILLER_128_526 VGND VGND VPWR VPWR sky130_fd_sc_hd__decap_6
Xinput28 mem_rdata[5] VGND VGND VPWR VPWR net28 sky130_fd_sc_hd__buf_1
Xinput17 mem_rdata[24] VGND VGND VPWR VPWR net17 sky130_fd_sc_hd__buf_2
X_10525_ clknet_leaf_96_clk _00655_ VGND VGND VPWR VPWR reg_pc\[11\] sky130_fd_sc_hd__dfxtp_1
XFILLER_10_384 VGND VGND VPWR VPWR sky130_fd_sc_hd__fill_1
XFILLER_6_333 VPWR VGND VPWR VGND sky130_ef_sc_hd__decap_12
X_10456_ clknet_leaf_108_clk _00586_ VGND VGND VPWR VPWR count_instr\[5\] sky130_fd_sc_hd__dfxtp_1
XFILLER_7_889 VGND VGND VPWR VPWR sky130_fd_sc_hd__decap_6
XFILLER_124_743 VPWR VGND VPWR VGND sky130_ef_sc_hd__decap_12
XFILLER_108_283 VPWR VGND VPWR VGND sky130_ef_sc_hd__decap_12
X_10387_ clknet_leaf_117_clk _00517_ VGND VGND VPWR VPWR cpuregs\[20\]\[1\] sky130_fd_sc_hd__dfxtp_1
XFILLER_96_159 VGND VGND VPWR VPWR sky130_fd_sc_hd__fill_1
XFILLER_93_811 VGND VGND VPWR VPWR sky130_fd_sc_hd__decap_6
XFILLER_65_502 VGND VGND VPWR VPWR sky130_fd_sc_hd__fill_2
X_11008_ clknet_leaf_1_clk _01070_ VGND VGND VPWR VPWR cpuregs\[19\]\[8\] sky130_fd_sc_hd__dfxtp_1
XFILLER_92_321 VPWR VGND VPWR VGND sky130_ef_sc_hd__decap_12
XFILLER_18_462 VGND VGND VPWR VPWR sky130_fd_sc_hd__decap_6
XTAP_TAPCELL_ROW_36_906 VGND VPWR sky130_fd_sc_hd__tapvpwrvgnd_1
XFILLER_92_387 VGND VGND VPWR VPWR sky130_fd_sc_hd__fill_2
X_05500_ net186 net218 VGND VGND VPWR VPWR _02083_ sky130_fd_sc_hd__nor2_1
X_06480_ net258 _02911_ VGND VGND VPWR VPWR _02912_ sky130_fd_sc_hd__or2_1
X_05431_ _02015_ _02016_ VGND VGND VPWR VPWR _02017_ sky130_fd_sc_hd__nor2_1
XFILLER_61_796 VPWR VGND VPWR VGND sky130_ef_sc_hd__decap_12
XFILLER_61_785 VGND VGND VPWR VPWR sky130_fd_sc_hd__decap_3
XFILLER_33_476 VGND VGND VPWR VPWR sky130_fd_sc_hd__decap_8
XTAP_TAPCELL_ROW_43_1019 VGND VPWR sky130_fd_sc_hd__tapvpwrvgnd_1
XTAP_TAPCELL_ROW_138_2547 VGND VPWR sky130_fd_sc_hd__tapvpwrvgnd_1
XTAP_TAPCELL_ROW_138_2536 VGND VPWR sky130_fd_sc_hd__tapvpwrvgnd_1
X_08150_ instr_jal _03959_ _03960_ VGND VGND VPWR VPWR _03961_ sky130_fd_sc_hd__or3_1
XFILLER_21_649 VGND VGND VPWR VPWR sky130_fd_sc_hd__decap_8
X_05362_ _01933_ _01945_ VGND VGND VPWR VPWR _01953_ sky130_fd_sc_hd__or2_1
X_07101_ cpuregs\[16\]\[29\] cpuregs\[17\]\[29\] cpuregs\[18\]\[29\] cpuregs\[19\]\[29\]
+ net266 net261 VGND VGND VPWR VPWR _03510_ sky130_fd_sc_hd__mux4_1
XFILLER_9_160 VGND VGND VPWR VPWR sky130_fd_sc_hd__decap_8
XFILLER_119_559 VGND VGND VPWR VPWR sky130_fd_sc_hd__fill_1
X_05293_ _01888_ _01889_ VGND VGND VPWR VPWR _01890_ sky130_fd_sc_hd__xnor2_1
X_08081_ _03879_ _03896_ _03895_ _03890_ VGND VGND VPWR VPWR _03897_ sky130_fd_sc_hd__o2bb2a_1
XTAP_TAPCELL_ROW_151_2747 VGND VPWR sky130_fd_sc_hd__tapvpwrvgnd_1
X_07032_ _03438_ _03442_ _03443_ _00016_ _01580_ VGND VGND VPWR VPWR _03444_ sky130_fd_sc_hd__a221o_1
XTAP_TAPCELL_ROW_58_1262 VGND VPWR sky130_fd_sc_hd__tapvpwrvgnd_1
X_08983_ _04647_ _04648_ _01558_ VGND VGND VPWR VPWR _04658_ sky130_fd_sc_hd__mux2_1
XFILLER_102_448 VPWR VGND VPWR VGND sky130_ef_sc_hd__decap_12
XTAP_TAPCELL_ROW_71_1473 VGND VPWR sky130_fd_sc_hd__tapvpwrvgnd_1
XTAP_TAPCELL_ROW_71_1462 VGND VPWR sky130_fd_sc_hd__tapvpwrvgnd_1
XFILLER_57_19 VPWR VGND VPWR VGND sky130_ef_sc_hd__decap_12
X_07934_ _03760_ _03761_ net34 VGND VGND VPWR VPWR _00680_ sky130_fd_sc_hd__o21a_1
X_07865_ _02666_ reg_next_pc\[21\] net597 VGND VGND VPWR VPWR _03708_ sky130_fd_sc_hd__mux2_2
XFILLER_68_351 VGND VGND VPWR VPWR sky130_fd_sc_hd__fill_1
XFILLER_84_866 VGND VGND VPWR VPWR sky130_fd_sc_hd__fill_2
XFILLER_83_332 VGND VGND VPWR VPWR sky130_fd_sc_hd__decap_4
X_09604_ _02624_ cpuregs\[3\]\[10\] _04868_ VGND VGND VPWR VPWR _01264_ sky130_fd_sc_hd__mux2_1
XFILLER_28_237 VGND VGND VPWR VPWR sky130_fd_sc_hd__fill_1
XFILLER_113_69 VGND VGND VPWR VPWR sky130_fd_sc_hd__fill_1
XFILLER_113_47 VGND VGND VPWR VPWR sky130_fd_sc_hd__decap_8
X_06816_ _02714_ _03217_ _03219_ _03220_ _03235_ VGND VGND VPWR VPWR _03236_ sky130_fd_sc_hd__o41a_1
X_07796_ count_instr\[53\] _03668_ net34 VGND VGND VPWR VPWR _03670_ sky130_fd_sc_hd__o21ai_1
X_06747_ _02744_ _03090_ _03167_ _02714_ VGND VGND VPWR VPWR _03169_ sky130_fd_sc_hd__a31o_1
XFILLER_71_549 VGND VGND VPWR VPWR sky130_fd_sc_hd__decap_4
X_09535_ cpuregs\[23\]\[7\] _02612_ _04866_ VGND VGND VPWR VPWR _01197_ sky130_fd_sc_hd__mux2_1
XFILLER_24_421 VGND VGND VPWR VPWR sky130_fd_sc_hd__fill_2
XFILLER_36_270 VPWR VGND VPWR VGND sky130_ef_sc_hd__decap_12
X_06678_ _03099_ _03100_ _01579_ VGND VGND VPWR VPWR _03103_ sky130_fd_sc_hd__mux2_1
X_09466_ cpuregs\[24\]\[4\] _02598_ net243 VGND VGND VPWR VPWR _01130_ sky130_fd_sc_hd__mux2_1
X_08417_ count_cycle\[58\] _04158_ net34 VGND VGND VPWR VPWR _04160_ sky130_fd_sc_hd__o21ai_1
X_05629_ net179 _01577_ _02211_ net178 VGND VGND VPWR VPWR _02212_ sky130_fd_sc_hd__a22o_1
X_09397_ _02588_ cpuregs\[18\]\[1\] _04862_ VGND VGND VPWR VPWR _01031_ sky130_fd_sc_hd__mux2_1
XFILLER_149_161 VGND VGND VPWR VPWR sky130_fd_sc_hd__decap_6
XFILLER_138_813 VPWR VGND VPWR VGND sky130_ef_sc_hd__decap_12
X_08348_ count_cycle\[32\] _04114_ _04116_ VGND VGND VPWR VPWR _00739_ sky130_fd_sc_hd__o21a_1
XTAP_TAPCELL_ROW_22_677 VGND VPWR sky130_fd_sc_hd__tapvpwrvgnd_1
X_08279_ count_cycle\[7\] count_cycle\[8\] net452 VGND VGND VPWR VPWR _04072_ sky130_fd_sc_hd__and3_1
XTAP_TAPCELL_ROW_22_688 VGND VPWR sky130_fd_sc_hd__tapvpwrvgnd_1
X_11290_ clknet_leaf_72_clk _01337_ VGND VGND VPWR VPWR cpuregs\[4\]\[19\] sky130_fd_sc_hd__dfxtp_1
XFILLER_138_77 VGND VGND VPWR VPWR sky130_fd_sc_hd__decap_6
XFILLER_137_389 VGND VGND VPWR VPWR sky130_fd_sc_hd__decap_3
X_10310_ clknet_leaf_74_clk _00440_ VGND VGND VPWR VPWR cpuregs\[26\]\[20\] sky130_fd_sc_hd__dfxtp_1
XFILLER_98_26 VGND VGND VPWR VPWR sky130_fd_sc_hd__fill_2
XFILLER_22_77 VGND VGND VPWR VPWR sky130_fd_sc_hd__decap_6
X_10241_ clknet_leaf_15_clk _00371_ VGND VGND VPWR VPWR cpuregs\[27\]\[15\] sky130_fd_sc_hd__dfxtp_1
XFILLER_4_837 VPWR VGND VPWR VGND sky130_ef_sc_hd__decap_12
XFILLER_106_754 VGND VGND VPWR VPWR sky130_fd_sc_hd__fill_2
X_10172_ clknet_leaf_12_clk _00302_ VGND VGND VPWR VPWR cpuregs\[9\]\[10\] sky130_fd_sc_hd__dfxtp_1
XFILLER_121_779 VGND VGND VPWR VPWR sky130_fd_sc_hd__decap_4
XFILLER_47_513 VGND VGND VPWR VPWR sky130_fd_sc_hd__decap_4
XTAP_TAPCELL_ROW_89_1756 VGND VPWR sky130_fd_sc_hd__tapvpwrvgnd_1
XFILLER_62_505 VGND VGND VPWR VPWR sky130_fd_sc_hd__fill_1
XFILLER_47_568 VGND VGND VPWR VPWR sky130_fd_sc_hd__fill_2
XFILLER_15_410 VGND VGND VPWR VPWR sky130_fd_sc_hd__fill_1
XFILLER_28_782 VGND VGND VPWR VPWR sky130_fd_sc_hd__decap_3
XFILLER_34_229 VGND VGND VPWR VPWR sky130_fd_sc_hd__fill_2
XFILLER_27_281 VGND VGND VPWR VPWR sky130_fd_sc_hd__decap_4
XFILLER_31_903 VGND VGND VPWR VPWR sky130_fd_sc_hd__fill_1
XFILLER_43_785 VGND VGND VPWR VPWR sky130_fd_sc_hd__fill_1
XPHY_EDGE_ROW_146_Left_300 VGND VGND VPWR VPWR sky130_fd_sc_hd__decap_3
XTAP_TAPCELL_ROW_100_1934 VGND VPWR sky130_fd_sc_hd__tapvpwrvgnd_1
XTAP_TAPCELL_ROW_41_986 VGND VPWR sky130_fd_sc_hd__tapvpwrvgnd_1
XFILLER_144_805 VGND VGND VPWR VPWR sky130_fd_sc_hd__decap_6
XFILLER_128_334 VGND VGND VPWR VPWR sky130_fd_sc_hd__fill_1
XFILLER_116_507 VGND VGND VPWR VPWR sky130_fd_sc_hd__decap_6
X_10508_ clknet_leaf_81_clk _00638_ VGND VGND VPWR VPWR count_instr\[57\] sky130_fd_sc_hd__dfxtp_1
XFILLER_7_653 VGND VGND VPWR VPWR sky130_fd_sc_hd__decap_3
XFILLER_6_141 VPWR VGND VPWR VGND sky130_ef_sc_hd__decap_12
XFILLER_144_849 VPWR VGND VPWR VGND sky130_ef_sc_hd__decap_12
XFILLER_143_337 VGND VGND VPWR VPWR sky130_fd_sc_hd__fill_1
X_11488_ clknet_leaf_43_clk _01532_ VGND VGND VPWR VPWR cpuregs\[10\]\[22\] sky130_fd_sc_hd__dfxtp_1
XTAP_TAPCELL_ROW_133_2466 VGND VPWR sky130_fd_sc_hd__tapvpwrvgnd_1
XTAP_TAPCELL_ROW_133_2455 VGND VPWR sky130_fd_sc_hd__tapvpwrvgnd_1
X_10439_ clknet_leaf_76_clk _00569_ VGND VGND VPWR VPWR cpuregs\[17\]\[21\] sky130_fd_sc_hd__dfxtp_1
XFILLER_152_893 VGND VGND VPWR VPWR sky130_fd_sc_hd__decap_6
XFILLER_112_757 VPWR VGND VPWR VGND sky130_ef_sc_hd__decap_12
XFILLER_111_234 VGND VGND VPWR VPWR sky130_fd_sc_hd__decap_4
X_05980_ net174 _02493_ _01582_ VGND VGND VPWR VPWR net68 sky130_fd_sc_hd__mux2_2
XFILLER_69_137 VGND VGND VPWR VPWR sky130_fd_sc_hd__decap_3
X_04931_ net181 VGND VGND VPWR VPWR _01564_ sky130_fd_sc_hd__inv_2
XFILLER_78_660 VGND VGND VPWR VPWR sky130_fd_sc_hd__fill_1
XTAP_TAPCELL_ROW_53_1181 VGND VPWR sky130_fd_sc_hd__tapvpwrvgnd_1
XFILLER_26_3 VPWR VGND VPWR VGND sky130_ef_sc_hd__decap_12
XFILLER_77_181 VGND VGND VPWR VPWR sky130_fd_sc_hd__fill_1
XFILLER_65_343 VGND VGND VPWR VPWR sky130_fd_sc_hd__fill_1
XFILLER_53_505 VGND VGND VPWR VPWR sky130_fd_sc_hd__fill_2
X_07650_ cpu_state\[1\] count_instr\[0\] decoder_trigger VGND VGND VPWR VPWR _03577_
+ sky130_fd_sc_hd__and3_1
XTAP_TAPCELL_ROW_0_317 VGND VPWR sky130_fd_sc_hd__tapvpwrvgnd_1
XTAP_TAPCELL_ROW_0_328 VGND VPWR sky130_fd_sc_hd__tapvpwrvgnd_1
XFILLER_93_685 VPWR VGND VPWR VGND sky130_ef_sc_hd__decap_12
XFILLER_92_162 VPWR VGND VPWR VGND sky130_ef_sc_hd__decap_12
X_06601_ _00015_ _03025_ _03028_ _02735_ VGND VGND VPWR VPWR _03029_ sky130_fd_sc_hd__o211a_1
XFILLER_53_527 VPWR VGND VPWR VGND sky130_ef_sc_hd__decap_12
XTAP_TAPCELL_ROW_0_339 VGND VPWR sky130_fd_sc_hd__tapvpwrvgnd_1
X_07581_ latched_rd\[3\] latched_rd\[4\] _02580_ latched_rd\[2\] VGND VGND VPWR VPWR
+ _03572_ sky130_fd_sc_hd__and4b_2
XFILLER_80_335 VGND VGND VPWR VPWR sky130_fd_sc_hd__decap_8
X_06532_ _02956_ _02957_ _02961_ VGND VGND VPWR VPWR _02962_ sky130_fd_sc_hd__a21o_1
XFILLER_18_292 VGND VGND VPWR VPWR sky130_fd_sc_hd__fill_1
X_09320_ reg_sh\[1\] reg_sh\[0\] _02745_ _01661_ VGND VGND VPWR VPWR _04819_ sky130_fd_sc_hd__a31o_1
X_09251_ cpuregs\[1\]\[30\] _02709_ net244 VGND VGND VPWR VPWR _00948_ sky130_fd_sc_hd__mux2_1
XFILLER_33_262 VGND VGND VPWR VPWR sky130_fd_sc_hd__fill_2
X_08202_ _03715_ _04002_ instr_jal VGND VGND VPWR VPWR _04008_ sky130_fd_sc_hd__a21o_1
X_06463_ _02714_ _02878_ _02880_ _02882_ _02895_ VGND VGND VPWR VPWR _02896_ sky130_fd_sc_hd__o41a_1
X_05414_ _01971_ _01982_ _01993_ VGND VGND VPWR VPWR _02001_ sky130_fd_sc_hd__or3_1
X_09182_ mem_rdata_q\[27\] net20 _01609_ VGND VGND VPWR VPWR _01121_ sky130_fd_sc_hd__mux2_1
X_06394_ _01578_ _02828_ VGND VGND VPWR VPWR _02829_ sky130_fd_sc_hd__or2_1
XFILLER_146_120 VGND VGND VPWR VPWR sky130_fd_sc_hd__decap_3
X_05345_ count_instr\[22\] instr_rdinstr count_cycle\[54\] instr_rdcycleh VGND VGND
+ VPWR VPWR _01938_ sky130_fd_sc_hd__a22o_1
X_08133_ _03908_ _03920_ _03941_ _03944_ VGND VGND VPWR VPWR _03945_ sky130_fd_sc_hd__a31o_1
XFILLER_147_665 VGND VGND VPWR VPWR sky130_fd_sc_hd__decap_6
XFILLER_146_153 VPWR VGND VPWR VGND sky130_ef_sc_hd__decap_12
XFILLER_107_529 VGND VGND VPWR VPWR sky130_fd_sc_hd__fill_1
X_08064_ _03879_ _03880_ VGND VGND VPWR VPWR _03881_ sky130_fd_sc_hd__nand2_1
XFILLER_146_197 VPWR VGND VPWR VGND sky130_ef_sc_hd__decap_12
X_07015_ net188 _02721_ _03350_ _01641_ VGND VGND VPWR VPWR _03427_ sky130_fd_sc_hd__o211a_1
X_05276_ cpu_state\[6\] _01860_ _01870_ _01874_ VGND VGND VPWR VPWR _01875_ sky130_fd_sc_hd__a31oi_1
Xpicorv32_340 VGND VGND VPWR VPWR picorv32_340/HI pcpi_insn[23] sky130_fd_sc_hd__conb_1
XTAP_TAPCELL_ROW_73_1502 VGND VPWR sky130_fd_sc_hd__tapvpwrvgnd_1
Xpicorv32_362 VGND VGND VPWR VPWR picorv32_362/HI trace_data[12] sky130_fd_sc_hd__conb_1
Xpicorv32_351 VGND VGND VPWR VPWR picorv32_351/HI trace_data[1] sky130_fd_sc_hd__conb_1
Xpicorv32_384 VGND VGND VPWR VPWR picorv32_384/HI trace_data[34] sky130_fd_sc_hd__conb_1
XFILLER_68_29 VPWR VGND VPWR VGND sky130_ef_sc_hd__decap_12
Xpicorv32_373 VGND VGND VPWR VPWR picorv32_373/HI trace_data[23] sky130_fd_sc_hd__conb_1
X_08966_ net270 _04638_ _04637_ _01560_ VGND VGND VPWR VPWR _04642_ sky130_fd_sc_hd__o211a_1
XFILLER_103_779 VGND VGND VPWR VPWR sky130_fd_sc_hd__fill_1
XFILLER_102_278 VGND VGND VPWR VPWR sky130_fd_sc_hd__fill_1
XFILLER_75_107 VGND VGND VPWR VPWR sky130_fd_sc_hd__decap_4
XFILLER_69_660 VPWR VGND VPWR VGND sky130_ef_sc_hd__decap_12
XFILLER_130_598 VGND VGND VPWR VPWR sky130_fd_sc_hd__decap_8
X_08897_ cpuregs\[16\]\[23\] cpuregs\[17\]\[23\] cpuregs\[18\]\[23\] cpuregs\[19\]\[23\]
+ net276 net272 VGND VGND VPWR VPWR _04576_ sky130_fd_sc_hd__mux4_1
Xclkbuf_leaf_95_clk clknet_4_12_0_clk VGND VGND VPWR VPWR clknet_leaf_95_clk sky130_fd_sc_hd__clkbuf_8
XFILLER_57_833 VGND VGND VPWR VPWR sky130_fd_sc_hd__fill_1
X_07917_ _03742_ _03743_ _03744_ _01551_ VGND VGND VPWR VPWR _03746_ sky130_fd_sc_hd__a31o_1
XTAP_TAPCELL_ROW_104_2001 VGND VPWR sky130_fd_sc_hd__tapvpwrvgnd_1
X_07848_ reg_pc\[12\] _01624_ _01628_ _03699_ VGND VGND VPWR VPWR _00656_ sky130_fd_sc_hd__a22o_1
XFILLER_57_888 VGND VGND VPWR VPWR sky130_fd_sc_hd__fill_2
XFILLER_56_365 VPWR VGND VPWR VGND sky130_ef_sc_hd__decap_12
XFILLER_17_708 VGND VGND VPWR VPWR sky130_fd_sc_hd__decap_6
XFILLER_72_836 VGND VGND VPWR VPWR sky130_fd_sc_hd__fill_2
XFILLER_17_55 VGND VGND VPWR VPWR sky130_fd_sc_hd__fill_1
X_09518_ cpuregs\[31\]\[23\] _02678_ _04865_ VGND VGND VPWR VPWR _01181_ sky130_fd_sc_hd__mux2_1
X_07779_ _03654_ count_instr\[46\] count_instr\[45\] count_instr\[47\] VGND VGND VPWR
+ VPWR _03659_ sky130_fd_sc_hd__and4_1
XFILLER_72_869 VGND VGND VPWR VPWR sky130_fd_sc_hd__fill_2
XTAP_TAPCELL_ROW_27_758 VGND VPWR sky130_fd_sc_hd__tapvpwrvgnd_1
XTAP_TAPCELL_ROW_27_769 VGND VPWR sky130_fd_sc_hd__tapvpwrvgnd_1
XTAP_TAPCELL_ROW_84_1675 VGND VPWR sky130_fd_sc_hd__tapvpwrvgnd_1
X_10790_ clknet_leaf_99_clk _00855_ VGND VGND VPWR VPWR instr_lh sky130_fd_sc_hd__dfxtp_1
XFILLER_24_251 VGND VGND VPWR VPWR sky130_fd_sc_hd__fill_1
XFILLER_25_785 VPWR VGND VPWR VGND sky130_ef_sc_hd__decap_12
X_09449_ _02665_ cpuregs\[19\]\[20\] _04863_ VGND VGND VPWR VPWR _01082_ sky130_fd_sc_hd__mux2_1
XFILLER_40_755 VGND VGND VPWR VPWR sky130_fd_sc_hd__fill_1
XFILLER_130_3 VPWR VGND VPWR VGND sky130_ef_sc_hd__decap_12
XFILLER_40_777 VGND VGND VPWR VPWR sky130_fd_sc_hd__fill_2
XFILLER_40_788 VGND VGND VPWR VPWR sky130_fd_sc_hd__fill_1
XFILLER_138_654 VGND VGND VPWR VPWR sky130_fd_sc_hd__fill_2
X_11411_ clknet_leaf_147_clk _01455_ VGND VGND VPWR VPWR cpuregs\[8\]\[9\] sky130_fd_sc_hd__dfxtp_1
XFILLER_126_805 VGND VGND VPWR VPWR sky130_fd_sc_hd__decap_6
X_11342_ clknet_leaf_145_clk _01386_ VGND VGND VPWR VPWR cpuregs\[6\]\[4\] sky130_fd_sc_hd__dfxtp_1
XFILLER_126_849 VPWR VGND VPWR VGND sky130_ef_sc_hd__decap_12
XFILLER_4_623 VPWR VGND VPWR VGND sky130_ef_sc_hd__decap_12
XFILLER_3_111 VGND VGND VPWR VPWR sky130_fd_sc_hd__fill_1
XFILLER_140_307 VGND VGND VPWR VPWR sky130_fd_sc_hd__fill_1
XFILLER_125_348 VGND VGND VPWR VPWR sky130_fd_sc_hd__decap_6
XTAP_TAPCELL_ROW_115_2174 VGND VPWR sky130_fd_sc_hd__tapvpwrvgnd_1
XFILLER_4_645 VPWR VGND VPWR VGND sky130_ef_sc_hd__decap_12
X_11273_ clknet_leaf_120_clk _01320_ VGND VGND VPWR VPWR cpuregs\[4\]\[2\] sky130_fd_sc_hd__dfxtp_1
XFILLER_152_189 VGND VGND VPWR VPWR sky130_fd_sc_hd__decap_6
XFILLER_134_893 VPWR VGND VPWR VGND sky130_ef_sc_hd__decap_12
X_10224_ clknet_leaf_27_clk _00354_ VGND VGND VPWR VPWR cpuregs\[14\]\[30\] sky130_fd_sc_hd__dfxtp_1
X_10155_ clknet_leaf_68_clk _00285_ VGND VGND VPWR VPWR cpuregs\[21\]\[25\] sky130_fd_sc_hd__dfxtp_1
XFILLER_121_521 VGND VGND VPWR VPWR sky130_fd_sc_hd__decap_3
XTAP_TAPCELL_ROW_7_450 VGND VPWR sky130_fd_sc_hd__tapvpwrvgnd_1
XFILLER_48_811 VGND VGND VPWR VPWR sky130_fd_sc_hd__fill_1
X_10086_ clknet_leaf_76_clk _00216_ VGND VGND VPWR VPWR cpuregs\[2\]\[20\] sky130_fd_sc_hd__dfxtp_1
Xclkbuf_leaf_86_clk clknet_4_14_0_clk VGND VGND VPWR VPWR clknet_leaf_86_clk sky130_fd_sc_hd__clkbuf_8
XFILLER_63_803 VGND VGND VPWR VPWR sky130_fd_sc_hd__fill_1
XFILLER_48_888 VPWR VGND VPWR VGND sky130_ef_sc_hd__decap_12
XFILLER_35_505 VPWR VGND VPWR VGND sky130_ef_sc_hd__decap_12
XFILLER_74_61 VGND VGND VPWR VPWR sky130_fd_sc_hd__decap_3
XFILLER_74_195 VGND VGND VPWR VPWR sky130_fd_sc_hd__fill_1
XFILLER_16_741 VGND VGND VPWR VPWR sky130_fd_sc_hd__decap_4
X_10988_ clknet_leaf_76_clk _01050_ VGND VGND VPWR VPWR cpuregs\[18\]\[20\] sky130_fd_sc_hd__dfxtp_1
XFILLER_90_699 VGND VGND VPWR VPWR sky130_fd_sc_hd__fill_1
X_11609_ net123 VGND VGND VPWR VPWR net229 sky130_fd_sc_hd__clkbuf_1
XFILLER_129_687 VGND VGND VPWR VPWR sky130_fd_sc_hd__decap_4
Xclkbuf_leaf_10_clk clknet_4_1_0_clk VGND VGND VPWR VPWR clknet_leaf_10_clk sky130_fd_sc_hd__clkbuf_8
X_05130_ _01736_ _01739_ VGND VGND VPWR VPWR _01740_ sky130_fd_sc_hd__xor2_1
XFILLER_128_186 VGND VGND VPWR VPWR sky130_fd_sc_hd__fill_1
XFILLER_143_134 VGND VGND VPWR VPWR sky130_fd_sc_hd__decap_6
XTAP_TAPCELL_ROW_55_1210 VGND VPWR sky130_fd_sc_hd__tapvpwrvgnd_1
X_05061_ net171 cpu_state\[4\] decoded_imm\[0\] cpu_state\[3\] net256 VGND VGND VPWR
+ VPWR _01676_ sky130_fd_sc_hd__a221o_1
XFILLER_143_167 VGND VGND VPWR VPWR sky130_fd_sc_hd__fill_1
XFILLER_131_329 VGND VGND VPWR VPWR sky130_fd_sc_hd__decap_6
X_08820_ _04494_ _04495_ _01558_ VGND VGND VPWR VPWR _04504_ sky130_fd_sc_hd__mux2_1
XTAP_TAPCELL_ROW_5_409 VGND VPWR sky130_fd_sc_hd__tapvpwrvgnd_1
XFILLER_112_587 VGND VGND VPWR VPWR sky130_fd_sc_hd__fill_1
XFILLER_98_777 VGND VGND VPWR VPWR sky130_fd_sc_hd__fill_1
XFILLER_97_254 VPWR VGND VPWR VGND sky130_ef_sc_hd__decap_12
XFILLER_85_416 VPWR VGND VPWR VGND sky130_ef_sc_hd__decap_12
XFILLER_57_107 VGND VGND VPWR VPWR sky130_fd_sc_hd__decap_4
XTAP_TAPCELL_ROW_146_2668 VGND VPWR sky130_fd_sc_hd__tapvpwrvgnd_1
Xclkbuf_leaf_77_clk clknet_4_15_0_clk VGND VGND VPWR VPWR clknet_leaf_77_clk sky130_fd_sc_hd__clkbuf_8
X_08751_ decoded_imm\[14\] _01654_ _01586_ VGND VGND VPWR VPWR _04439_ sky130_fd_sc_hd__a21o_1
XFILLER_57_129 VGND VGND VPWR VPWR sky130_fd_sc_hd__decap_8
X_05963_ reg_out\[4\] reg_next_pc\[4\] net596 VGND VGND VPWR VPWR _02485_ sky130_fd_sc_hd__mux2_1
X_05894_ _02448_ VGND VGND VPWR VPWR _02449_ sky130_fd_sc_hd__inv_2
X_07702_ _03605_ count_instr\[18\] count_instr\[17\] count_instr\[19\] VGND VGND VPWR
+ VPWR _03610_ sky130_fd_sc_hd__and4_4
X_08682_ cpuregs\[28\]\[11\] cpuregs\[29\]\[11\] cpuregs\[30\]\[11\] cpuregs\[31\]\[11\]
+ net279 _00008_ VGND VGND VPWR VPWR _04373_ sky130_fd_sc_hd__mux4_1
X_04914_ net444 VGND VGND VPWR VPWR _01547_ sky130_fd_sc_hd__inv_16
X_07633_ _02654_ cpuregs\[17\]\[17\] _03574_ VGND VGND VPWR VPWR _00565_ sky130_fd_sc_hd__mux2_1
XFILLER_38_365 VGND VGND VPWR VPWR sky130_fd_sc_hd__fill_2
XFILLER_53_335 VGND VGND VPWR VPWR sky130_fd_sc_hd__fill_1
X_07564_ cpuregs\[25\]\[15\] _02646_ _03571_ VGND VGND VPWR VPWR _00499_ sky130_fd_sc_hd__mux2_1
XTAP_TAPCELL_ROW_24_717 VGND VPWR sky130_fd_sc_hd__tapvpwrvgnd_1
X_07495_ cpuregs\[26\]\[13\] _02638_ _03568_ VGND VGND VPWR VPWR _00433_ sky130_fd_sc_hd__mux2_1
XTAP_TAPCELL_ROW_66_1394 VGND VPWR sky130_fd_sc_hd__tapvpwrvgnd_1
XTAP_TAPCELL_ROW_66_1383 VGND VPWR sky130_fd_sc_hd__tapvpwrvgnd_1
XFILLER_61_390 VGND VGND VPWR VPWR sky130_fd_sc_hd__fill_2
X_09303_ net130 _04208_ _04811_ _04207_ VGND VGND VPWR VPWR _00988_ sky130_fd_sc_hd__o211a_1
XFILLER_21_210 VPWR VGND VPWR VGND sky130_ef_sc_hd__decap_12
X_06515_ _00015_ _02942_ _02945_ _02735_ VGND VGND VPWR VPWR _02946_ sky130_fd_sc_hd__o211a_1
X_09234_ cpuregs\[1\]\[13\] _02638_ net244 VGND VGND VPWR VPWR _00931_ sky130_fd_sc_hd__mux2_1
XPHY_EDGE_ROW_3_Right_3 VGND VGND VPWR VPWR sky130_fd_sc_hd__decap_3
XFILLER_22_755 VGND VGND VPWR VPWR sky130_fd_sc_hd__fill_1
X_06446_ net202 _02720_ VGND VGND VPWR VPWR _02879_ sky130_fd_sc_hd__or2_1
X_09165_ mem_rdata_q\[23\] mem_rdata_q\[22\] mem_rdata_q\[21\] _04782_ VGND VGND VPWR
+ VPWR _04783_ sky130_fd_sc_hd__or4_1
X_08116_ _03927_ _03928_ VGND VGND VPWR VPWR _03929_ sky130_fd_sc_hd__and2_1
X_06377_ _01578_ _02811_ VGND VGND VPWR VPWR _02812_ sky130_fd_sc_hd__or2_1
XFILLER_134_101 VGND VGND VPWR VPWR sky130_fd_sc_hd__fill_2
X_05328_ reg_pc\[21\] decoded_imm\[21\] VGND VGND VPWR VPWR _01922_ sky130_fd_sc_hd__nand2_1
XFILLER_107_337 VGND VGND VPWR VPWR sky130_fd_sc_hd__fill_1
X_09096_ instr_beq _04748_ _04749_ _04750_ VGND VGND VPWR VPWR _00847_ sky130_fd_sc_hd__a22o_1
X_08047_ _01547_ reg_next_pc\[14\] _01645_ _03701_ VGND VGND VPWR VPWR _03866_ sky130_fd_sc_hd__a22o_1
X_05259_ net7 _01666_ _01858_ VGND VGND VPWR VPWR _01859_ sky130_fd_sc_hd__o21a_1
XFILLER_116_893 VGND VGND VPWR VPWR sky130_fd_sc_hd__decap_3
XFILLER_131_841 VPWR VGND VPWR VGND sky130_ef_sc_hd__decap_12
XFILLER_0_125 VPWR VGND VPWR VGND sky130_ef_sc_hd__decap_12
X_09998_ clknet_leaf_41_clk _00128_ VGND VGND VPWR VPWR cpuregs\[12\]\[28\] sky130_fd_sc_hd__dfxtp_1
XTAP_TAPCELL_ROW_110_2093 VGND VPWR sky130_fd_sc_hd__tapvpwrvgnd_1
XFILLER_0_169 VPWR VGND VPWR VGND sky130_ef_sc_hd__decap_12
X_08949_ net269 _04624_ _01559_ VGND VGND VPWR VPWR _04626_ sky130_fd_sc_hd__a21o_1
XFILLER_103_598 VGND VGND VPWR VPWR sky130_fd_sc_hd__fill_1
Xclkbuf_leaf_68_clk clknet_4_13_0_clk VGND VGND VPWR VPWR clknet_leaf_68_clk sky130_fd_sc_hd__clkbuf_8
XTAP_TAPCELL_ROW_86_1704 VGND VPWR sky130_fd_sc_hd__tapvpwrvgnd_1
XFILLER_151_55 VGND VGND VPWR VPWR sky130_fd_sc_hd__fill_1
X_10911_ clknet_leaf_30_clk _00973_ VGND VGND VPWR VPWR net143 sky130_fd_sc_hd__dfxtp_1
XTAP_TAPCELL_ROW_86_1715 VGND VPWR sky130_fd_sc_hd__tapvpwrvgnd_1
XFILLER_57_685 VGND VGND VPWR VPWR sky130_fd_sc_hd__fill_1
XFILLER_29_365 VGND VGND VPWR VPWR sky130_fd_sc_hd__fill_1
XFILLER_45_847 VPWR VGND VPWR VGND sky130_ef_sc_hd__decap_12
XFILLER_72_666 VGND VGND VPWR VPWR sky130_fd_sc_hd__fill_1
XFILLER_56_195 VGND VGND VPWR VPWR sky130_fd_sc_hd__fill_1
X_10842_ clknet_leaf_111_clk _00907_ VGND VGND VPWR VPWR decoded_imm_j\[11\] sky130_fd_sc_hd__dfxtp_2
X_10773_ clknet_leaf_50_clk alu_out\[26\] VGND VGND VPWR VPWR alu_out_q\[26\] sky130_fd_sc_hd__dfxtp_1
XTAP_TAPCELL_ROW_117_2203 VGND VPWR sky130_fd_sc_hd__tapvpwrvgnd_1
XFILLER_8_225 VGND VGND VPWR VPWR sky130_fd_sc_hd__decap_4
XFILLER_60_41 VGND VGND VPWR VPWR sky130_fd_sc_hd__decap_8
XFILLER_153_421 VGND VGND VPWR VPWR sky130_fd_sc_hd__fill_2
XTAP_TAPCELL_ROW_97_1877 VGND VPWR sky130_fd_sc_hd__tapvpwrvgnd_1
XFILLER_60_85 VGND VGND VPWR VPWR sky130_fd_sc_hd__fill_1
X_11325_ clknet_leaf_46_clk _01372_ VGND VGND VPWR VPWR cpuregs\[5\]\[22\] sky130_fd_sc_hd__dfxtp_1
XTAP_TAPCELL_ROW_130_2414 VGND VPWR sky130_fd_sc_hd__tapvpwrvgnd_1
XFILLER_126_657 VGND VGND VPWR VPWR sky130_fd_sc_hd__decap_4
XTAP_TAPCELL_ROW_97_1888 VGND VPWR sky130_fd_sc_hd__tapvpwrvgnd_1
XTAP_TAPCELL_ROW_10_499 VGND VPWR sky130_fd_sc_hd__tapvpwrvgnd_1
XTAP_TAPCELL_ROW_10_488 VGND VPWR sky130_fd_sc_hd__tapvpwrvgnd_1
XFILLER_109_90 VGND VGND VPWR VPWR sky130_fd_sc_hd__fill_1
X_11256_ clknet_leaf_22_clk _01303_ VGND VGND VPWR VPWR cpuregs\[22\]\[17\] sky130_fd_sc_hd__dfxtp_1
XFILLER_5_69 VPWR VGND VPWR VGND sky130_ef_sc_hd__decap_12
XFILLER_4_486 VGND VGND VPWR VPWR sky130_fd_sc_hd__fill_2
XFILLER_4_475 VGND VGND VPWR VPWR sky130_fd_sc_hd__fill_1
X_10207_ clknet_leaf_10_clk _00337_ VGND VGND VPWR VPWR cpuregs\[14\]\[13\] sky130_fd_sc_hd__dfxtp_1
X_11187_ clknet_leaf_11_clk _01234_ VGND VGND VPWR VPWR cpuregs\[29\]\[12\] sky130_fd_sc_hd__dfxtp_1
X_10138_ clknet_leaf_136_clk _00268_ VGND VGND VPWR VPWR cpuregs\[21\]\[8\] sky130_fd_sc_hd__dfxtp_1
XTAP_TAPCELL_ROW_128_2387 VGND VPWR sky130_fd_sc_hd__tapvpwrvgnd_1
XTAP_TAPCELL_ROW_128_2376 VGND VPWR sky130_fd_sc_hd__tapvpwrvgnd_1
XFILLER_94_257 VGND VGND VPWR VPWR sky130_fd_sc_hd__fill_1
Xclkbuf_leaf_59_clk clknet_4_12_0_clk VGND VGND VPWR VPWR clknet_leaf_59_clk sky130_fd_sc_hd__clkbuf_8
X_10069_ clknet_leaf_141_clk _00199_ VGND VGND VPWR VPWR cpuregs\[2\]\[3\] sky130_fd_sc_hd__dfxtp_1
XFILLER_36_825 VPWR VGND VPWR VGND sky130_ef_sc_hd__decap_12
XFILLER_90_430 VGND VGND VPWR VPWR sky130_fd_sc_hd__decap_8
XFILLER_63_655 VGND VGND VPWR VPWR sky130_fd_sc_hd__decap_6
XFILLER_35_335 VGND VGND VPWR VPWR sky130_fd_sc_hd__fill_1
XFILLER_36_869 VPWR VGND VPWR VGND sky130_ef_sc_hd__decap_12
XTAP_TAPCELL_ROW_141_2587 VGND VPWR sky130_fd_sc_hd__tapvpwrvgnd_1
XFILLER_90_474 VGND VGND VPWR VPWR sky130_fd_sc_hd__fill_2
XFILLER_50_305 VGND VGND VPWR VPWR sky130_fd_sc_hd__decap_3
XFILLER_149_738 VGND VGND VPWR VPWR sky130_fd_sc_hd__decap_3
X_07280_ cpuregs\[2\]\[31\] _02712_ net250 VGND VGND VPWR VPWR _00227_ sky130_fd_sc_hd__mux2_1
X_06300_ cpuregs\[20\]\[0\] cpuregs\[21\]\[0\] cpuregs\[22\]\[0\] cpuregs\[23\]\[0\]
+ net268 net262 VGND VGND VPWR VPWR _02738_ sky130_fd_sc_hd__mux4_1
X_06231_ _02676_ _02677_ _02584_ VGND VGND VPWR VPWR _02678_ sky130_fd_sc_hd__mux2_8
XFILLER_148_259 VGND VGND VPWR VPWR sky130_fd_sc_hd__decap_8
XFILLER_129_495 VGND VGND VPWR VPWR sky130_fd_sc_hd__decap_8
X_06162_ reg_out\[10\] alu_out_q\[10\] net591 VGND VGND VPWR VPWR _02622_ sky130_fd_sc_hd__mux2_1
XFILLER_117_679 VGND VGND VPWR VPWR sky130_fd_sc_hd__decap_6
XFILLER_105_819 VGND VGND VPWR VPWR sky130_fd_sc_hd__fill_2
X_05113_ net13 _01669_ net130 net27 _01723_ VGND VGND VPWR VPWR _01724_ sky130_fd_sc_hd__a221o_1
X_06093_ cpuregs\[8\]\[4\] cpuregs\[9\]\[4\] cpuregs\[10\]\[4\] cpuregs\[11\]\[4\]
+ net278 net273 VGND VGND VPWR VPWR _02564_ sky130_fd_sc_hd__mux4_1
X_09921_ clknet_leaf_73_clk _00056_ VGND VGND VPWR VPWR cpuregs\[11\]\[19\] sky130_fd_sc_hd__dfxtp_1
XFILLER_104_329 VGND VGND VPWR VPWR sky130_fd_sc_hd__fill_1
X_05044_ is_slli_srli_srai _01649_ _01662_ _01648_ VGND VGND VPWR VPWR _00021_ sky130_fd_sc_hd__a22o_1
XFILLER_131_148 VPWR VGND VPWR VGND sky130_ef_sc_hd__decap_12
XFILLER_131_137 VGND VGND VPWR VPWR sky130_fd_sc_hd__fill_2
XFILLER_98_541 VGND VGND VPWR VPWR sky130_fd_sc_hd__decap_3
X_09852_ _02691_ cpuregs\[10\]\[26\] _04876_ VGND VGND VPWR VPWR _01536_ sky130_fd_sc_hd__mux2_1
XFILLER_112_351 VGND VGND VPWR VPWR sky130_fd_sc_hd__decap_6
XFILLER_98_552 VPWR VGND VPWR VGND sky130_ef_sc_hd__decap_12
X_09783_ _02678_ cpuregs\[7\]\[23\] _04874_ VGND VGND VPWR VPWR _01437_ sky130_fd_sc_hd__mux2_1
X_08803_ _01559_ _04486_ _04487_ _04480_ _01560_ VGND VGND VPWR VPWR _04488_ sky130_fd_sc_hd__a221o_1
XFILLER_58_427 VGND VGND VPWR VPWR sky130_fd_sc_hd__decap_4
X_06995_ cpuregs\[16\]\[25\] cpuregs\[17\]\[25\] cpuregs\[18\]\[25\] cpuregs\[19\]\[25\]
+ net267 net261 VGND VGND VPWR VPWR _03408_ sky130_fd_sc_hd__mux4_1
XFILLER_100_568 VGND VGND VPWR VPWR sky130_fd_sc_hd__fill_2
X_08734_ cpuregs\[24\]\[14\] cpuregs\[25\]\[14\] cpuregs\[26\]\[14\] cpuregs\[27\]\[14\]
+ net275 net271 VGND VGND VPWR VPWR _04422_ sky130_fd_sc_hd__mux4_1
XFILLER_73_408 VGND VGND VPWR VPWR sky130_fd_sc_hd__fill_2
X_05946_ net123 net215 _01665_ VGND VGND VPWR VPWR net109 sky130_fd_sc_hd__mux2_1
XTAP_TAPCELL_ROW_68_1423 VGND VPWR sky130_fd_sc_hd__tapvpwrvgnd_1
XTAP_TAPCELL_ROW_68_1412 VGND VPWR sky130_fd_sc_hd__tapvpwrvgnd_1
XFILLER_38_162 VGND VGND VPWR VPWR sky130_fd_sc_hd__decap_4
X_05877_ _02433_ _02431_ instr_sub VGND VGND VPWR VPWR _02434_ sky130_fd_sc_hd__mux2_1
X_08665_ cpuregs\[24\]\[10\] cpuregs\[25\]\[10\] cpuregs\[26\]\[10\] cpuregs\[27\]\[10\]
+ net275 net271 VGND VGND VPWR VPWR _04357_ sky130_fd_sc_hd__mux4_1
XFILLER_54_633 VGND VGND VPWR VPWR sky130_fd_sc_hd__decap_8
XFILLER_38_195 VGND VGND VPWR VPWR sky130_fd_sc_hd__fill_1
XFILLER_81_463 VPWR VGND VPWR VGND sky130_ef_sc_hd__decap_12
XFILLER_81_18 VPWR VGND VPWR VGND sky130_ef_sc_hd__decap_12
X_07616_ _02586_ cpuregs\[17\]\[0\] _03574_ VGND VGND VPWR VPWR _00548_ sky130_fd_sc_hd__mux2_1
X_08596_ _04286_ _04287_ _01558_ VGND VGND VPWR VPWR _04292_ sky130_fd_sc_hd__mux2_1
XTAP_TAPCELL_ROW_81_1634 VGND VPWR sky130_fd_sc_hd__tapvpwrvgnd_1
XTAP_TAPCELL_ROW_81_1623 VGND VPWR sky130_fd_sc_hd__tapvpwrvgnd_1
X_07547_ _02712_ cpuregs\[16\]\[31\] _03570_ VGND VGND VPWR VPWR _00483_ sky130_fd_sc_hd__mux2_1
XFILLER_54_699 VGND VGND VPWR VPWR sky130_fd_sc_hd__fill_1
XFILLER_35_880 VPWR VGND VPWR VGND sky130_ef_sc_hd__decap_12
X_07478_ cpuregs\[15\]\[29\] _02704_ net246 VGND VGND VPWR VPWR _00417_ sky130_fd_sc_hd__mux2_1
XFILLER_50_883 VGND VGND VPWR VPWR sky130_fd_sc_hd__decap_3
XPHY_EDGE_ROW_101_Left_255 VGND VGND VPWR VPWR sky130_fd_sc_hd__decap_3
X_09217_ is_sb_sh_sw _02514_ _04743_ _04795_ VGND VGND VPWR VPWR _00915_ sky130_fd_sc_hd__a22o_1
XFILLER_10_769 VPWR VGND VPWR VGND sky130_ef_sc_hd__decap_12
X_06429_ _02861_ _02862_ VGND VGND VPWR VPWR _02863_ sky130_fd_sc_hd__and2_1
XFILLER_147_281 VGND VGND VPWR VPWR sky130_fd_sc_hd__decap_4
XFILLER_135_421 VGND VGND VPWR VPWR sky130_fd_sc_hd__fill_2
X_09148_ instr_sll _04748_ _04752_ _04772_ VGND VGND VPWR VPWR _00872_ sky130_fd_sc_hd__a22o_1
XFILLER_5_217 VGND VGND VPWR VPWR sky130_fd_sc_hd__decap_6
XTAP_TAPCELL_ROW_79_1596 VGND VPWR sky130_fd_sc_hd__tapvpwrvgnd_1
X_09079_ mem_rdata_q\[6\] net29 _01609_ VGND VGND VPWR VPWR _01100_ sky130_fd_sc_hd__mux2_1
XFILLER_123_627 VPWR VGND VPWR VGND sky130_ef_sc_hd__decap_12
XTAP_TAPCELL_ROW_112_2122 VGND VPWR sky130_fd_sc_hd__tapvpwrvgnd_1
XFILLER_107_178 VPWR VGND VPWR VGND sky130_ef_sc_hd__decap_12
X_11110_ clknet_leaf_102_clk _00023_ VGND VGND VPWR VPWR cpu_state\[6\] sky130_fd_sc_hd__dfxtp_4
XFILLER_146_77 VGND VGND VPWR VPWR sky130_fd_sc_hd__decap_6
XFILLER_104_830 VPWR VGND VPWR VGND sky130_ef_sc_hd__decap_12
XTAP_TAPCELL_ROW_92_1796 VGND VPWR sky130_fd_sc_hd__tapvpwrvgnd_1
X_11041_ clknet_leaf_102_clk _01098_ VGND VGND VPWR VPWR mem_rdata_q\[4\] sky130_fd_sc_hd__dfxtp_1
XPHY_EDGE_ROW_110_Left_264 VGND VGND VPWR VPWR sky130_fd_sc_hd__decap_3
XFILLER_76_257 VGND VGND VPWR VPWR sky130_fd_sc_hd__fill_1
XFILLER_76_279 VGND VGND VPWR VPWR sky130_fd_sc_hd__decap_8
XFILLER_64_419 VGND VGND VPWR VPWR sky130_fd_sc_hd__fill_1
XFILLER_18_825 VPWR VGND VPWR VGND sky130_ef_sc_hd__decap_12
XFILLER_29_162 VGND VGND VPWR VPWR sky130_fd_sc_hd__decap_6
XFILLER_18_869 VPWR VGND VPWR VGND sky130_ef_sc_hd__decap_12
XFILLER_33_828 VPWR VGND VPWR VGND sky130_ef_sc_hd__decap_12
XFILLER_44_165 VGND VGND VPWR VPWR sky130_fd_sc_hd__fill_2
XTAP_TAPCELL_ROW_123_2295 VGND VPWR sky130_fd_sc_hd__tapvpwrvgnd_1
X_10825_ clknet_leaf_99_clk _00890_ VGND VGND VPWR VPWR decoded_imm_j\[8\] sky130_fd_sc_hd__dfxtp_1
XFILLER_13_530 VGND VGND VPWR VPWR sky130_fd_sc_hd__fill_1
XTAP_TAPCELL_ROW_15_569 VGND VPWR sky130_fd_sc_hd__tapvpwrvgnd_1
XTAP_TAPCELL_ROW_99_1917 VGND VPWR sky130_fd_sc_hd__tapvpwrvgnd_1
X_10756_ clknet_leaf_133_clk alu_out\[9\] VGND VGND VPWR VPWR alu_out_q\[9\] sky130_fd_sc_hd__dfxtp_1
XFILLER_41_872 VGND VGND VPWR VPWR sky130_fd_sc_hd__decap_6
X_10687_ clknet_leaf_85_clk _00785_ VGND VGND VPWR VPWR net40 sky130_fd_sc_hd__dfxtp_1
XFILLER_40_382 VGND VGND VPWR VPWR sky130_fd_sc_hd__fill_1
XFILLER_139_782 VGND VGND VPWR VPWR sky130_fd_sc_hd__fill_2
XFILLER_114_605 VGND VGND VPWR VPWR sky130_fd_sc_hd__fill_1
XFILLER_126_498 VGND VGND VPWR VPWR sky130_fd_sc_hd__fill_1
X_11308_ clknet_leaf_140_clk _01355_ VGND VGND VPWR VPWR cpuregs\[5\]\[5\] sky130_fd_sc_hd__dfxtp_1
XFILLER_68_714 VGND VGND VPWR VPWR sky130_fd_sc_hd__fill_1
X_11239_ clknet_leaf_119_clk _01286_ VGND VGND VPWR VPWR cpuregs\[22\]\[0\] sky130_fd_sc_hd__dfxtp_1
XFILLER_122_671 VPWR VGND VPWR VGND sky130_ef_sc_hd__decap_12
XTAP_TAPCELL_ROW_143_2616 VGND VPWR sky130_fd_sc_hd__tapvpwrvgnd_1
XFILLER_110_855 VGND VGND VPWR VPWR sky130_fd_sc_hd__decap_8
X_05800_ _02110_ _02356_ _02212_ VGND VGND VPWR VPWR _02365_ sky130_fd_sc_hd__o21bai_1
XTAP_TAPCELL_ROW_143_2627 VGND VPWR sky130_fd_sc_hd__tapvpwrvgnd_1
X_06780_ cpuregs\[4\]\[17\] cpuregs\[5\]\[17\] cpuregs\[6\]\[17\] cpuregs\[7\]\[17\]
+ net265 net260 VGND VGND VPWR VPWR _03201_ sky130_fd_sc_hd__mux4_1
XFILLER_76_780 VGND VGND VPWR VPWR sky130_fd_sc_hd__fill_1
XFILLER_55_408 VPWR VGND VPWR VGND sky130_ef_sc_hd__decap_12
XFILLER_82_249 VGND VGND VPWR VPWR sky130_fd_sc_hd__decap_3
XFILLER_75_290 VGND VGND VPWR VPWR sky130_fd_sc_hd__decap_3
X_05731_ _02122_ _02240_ _02237_ VGND VGND VPWR VPWR _02304_ sky130_fd_sc_hd__a21oi_1
XFILLER_91_783 VGND VGND VPWR VPWR sky130_fd_sc_hd__fill_1
X_05662_ net171 net97 _02238_ _02244_ VGND VGND VPWR VPWR alu_out\[0\] sky130_fd_sc_hd__a31o_1
X_08450_ _04183_ _04185_ _04186_ _01579_ VGND VGND VPWR VPWR _04187_ sky130_fd_sc_hd__a22o_1
XFILLER_24_806 VGND VGND VPWR VPWR sky130_fd_sc_hd__decap_6
X_07401_ cpuregs\[14\]\[19\] _02662_ _03564_ VGND VGND VPWR VPWR _00343_ sky130_fd_sc_hd__mux2_1
X_08381_ count_cycle\[44\] _04134_ count_cycle\[45\] VGND VGND VPWR VPWR _04137_ sky130_fd_sc_hd__a21o_1
XFILLER_36_699 VGND VGND VPWR VPWR sky130_fd_sc_hd__fill_1
X_07332_ cpuregs\[21\]\[16\] _02649_ net248 VGND VGND VPWR VPWR _00276_ sky130_fd_sc_hd__mux2_1
XTAP_TAPCELL_ROW_63_1342 VGND VPWR sky130_fd_sc_hd__tapvpwrvgnd_1
X_05593_ net233 _02137_ net201 VGND VGND VPWR VPWR _02176_ sky130_fd_sc_hd__nor3b_1
XFILLER_50_135 VGND VGND VPWR VPWR sky130_fd_sc_hd__decap_4
XFILLER_32_861 VGND VGND VPWR VPWR sky130_fd_sc_hd__decap_6
XTAP_TAPCELL_ROW_34_878 VGND VPWR sky130_fd_sc_hd__tapvpwrvgnd_1
X_07263_ cpuregs\[2\]\[14\] _02641_ net250 VGND VGND VPWR VPWR _00210_ sky130_fd_sc_hd__mux2_1
XFILLER_31_393 VPWR VGND VPWR VGND sky130_ef_sc_hd__decap_12
XFILLER_136_218 VGND VGND VPWR VPWR sky130_fd_sc_hd__decap_8
X_09002_ _04667_ _04668_ _01558_ VGND VGND VPWR VPWR _04676_ sky130_fd_sc_hd__mux2_1
X_06214_ reg_pc\[20\] _02660_ VGND VGND VPWR VPWR _02664_ sky130_fd_sc_hd__xor2_1
X_07194_ cpuregs\[30\]\[12\] _02633_ net252 VGND VGND VPWR VPWR _00144_ sky130_fd_sc_hd__mux2_1
XFILLER_145_741 VGND VGND VPWR VPWR sky130_fd_sc_hd__decap_4
XFILLER_129_281 VGND VGND VPWR VPWR sky130_fd_sc_hd__decap_4
X_06145_ reg_out\[7\] alu_out_q\[7\] net590 VGND VGND VPWR VPWR _02608_ sky130_fd_sc_hd__mux2_2
XFILLER_145_785 VPWR VGND VPWR VGND sky130_ef_sc_hd__decap_12
XFILLER_144_262 VGND VGND VPWR VPWR sky130_fd_sc_hd__fill_1
XFILLER_144_251 VGND VGND VPWR VPWR sky130_fd_sc_hd__fill_1
XFILLER_2_209 VPWR VGND VPWR VGND sky130_ef_sc_hd__decap_12
XFILLER_144_284 VGND VGND VPWR VPWR sky130_fd_sc_hd__fill_1
XFILLER_104_137 VGND VGND VPWR VPWR sky130_fd_sc_hd__decap_3
X_06076_ cpuregs\[20\]\[3\] cpuregs\[21\]\[3\] cpuregs\[22\]\[3\] cpuregs\[23\]\[3\]
+ net279 _00008_ VGND VGND VPWR VPWR _02548_ sky130_fd_sc_hd__mux4_1
XFILLER_116_47 VGND VGND VPWR VPWR sky130_fd_sc_hd__fill_1
X_05027_ instr_rdcycle _01588_ _01649_ VGND VGND VPWR VPWR _01650_ sky130_fd_sc_hd__o21a_1
X_09904_ clknet_leaf_127_clk _00039_ VGND VGND VPWR VPWR cpuregs\[11\]\[2\] sky130_fd_sc_hd__dfxtp_1
X_09835_ _02621_ cpuregs\[10\]\[9\] _04876_ VGND VGND VPWR VPWR _01519_ sky130_fd_sc_hd__mux2_1
XFILLER_112_181 VPWR VGND VPWR VGND sky130_ef_sc_hd__decap_12
XFILLER_100_321 VGND VGND VPWR VPWR sky130_fd_sc_hd__decap_4
X_06978_ _03386_ _03387_ _00014_ VGND VGND VPWR VPWR _03392_ sky130_fd_sc_hd__mux2_1
XFILLER_100_365 VPWR VGND VPWR VGND sky130_ef_sc_hd__decap_12
X_09766_ _02607_ cpuregs\[7\]\[6\] _04874_ VGND VGND VPWR VPWR _01420_ sky130_fd_sc_hd__mux2_1
X_08717_ cpuregs\[28\]\[13\] cpuregs\[29\]\[13\] cpuregs\[30\]\[13\] cpuregs\[31\]\[13\]
+ net275 net271 VGND VGND VPWR VPWR _04406_ sky130_fd_sc_hd__mux4_1
X_05929_ mem_wordsize\[1\] net108 net234 _01672_ VGND VGND VPWR VPWR net128 sky130_fd_sc_hd__a22o_1
X_09697_ _02593_ cpuregs\[5\]\[3\] _04872_ VGND VGND VPWR VPWR _01353_ sky130_fd_sc_hd__mux2_1
XFILLER_26_121 VPWR VGND VPWR VGND sky130_ef_sc_hd__decap_12
Xrebuffer62 _04083_ VGND VGND VPWR VPWR net448 sky130_fd_sc_hd__dlygate4sd1_1
Xrebuffer40 net427 VGND VGND VPWR VPWR net426 sky130_fd_sc_hd__dlygate4sd1_1
Xrebuffer51 net438 VGND VGND VPWR VPWR net437 sky130_fd_sc_hd__dlygate4sd1_1
XFILLER_27_666 VGND VGND VPWR VPWR sky130_fd_sc_hd__decap_6
X_08648_ cpuregs\[0\]\[9\] cpuregs\[1\]\[9\] cpuregs\[2\]\[9\] cpuregs\[3\]\[9\] net278
+ net273 VGND VGND VPWR VPWR _04341_ sky130_fd_sc_hd__mux4_1
XFILLER_15_839 VGND VGND VPWR VPWR sky130_fd_sc_hd__fill_1
XFILLER_41_102 VGND VGND VPWR VPWR sky130_fd_sc_hd__decap_4
XFILLER_42_614 VGND VGND VPWR VPWR sky130_fd_sc_hd__fill_2
X_08579_ _04262_ _04263_ _00009_ VGND VGND VPWR VPWR _04276_ sky130_fd_sc_hd__mux2_1
XFILLER_25_55 VGND VGND VPWR VPWR sky130_fd_sc_hd__fill_1
X_10610_ clknet_leaf_110_clk _00740_ VGND VGND VPWR VPWR count_cycle\[33\] sky130_fd_sc_hd__dfxtp_1
XTAP_TAPCELL_ROW_12_517 VGND VPWR sky130_fd_sc_hd__tapvpwrvgnd_1
XFILLER_128_719 VGND VGND VPWR VPWR sky130_fd_sc_hd__decap_6
X_10541_ clknet_leaf_65_clk _00671_ VGND VGND VPWR VPWR reg_pc\[27\] sky130_fd_sc_hd__dfxtp_1
XFILLER_10_533 VGND VGND VPWR VPWR sky130_fd_sc_hd__decap_8
XTAP_TAPCELL_ROW_12_528 VGND VPWR sky130_fd_sc_hd__tapvpwrvgnd_1
XFILLER_10_577 VGND VGND VPWR VPWR sky130_fd_sc_hd__decap_8
XFILLER_108_421 VPWR VGND VPWR VGND sky130_ef_sc_hd__decap_12
X_10472_ clknet_leaf_83_clk _00602_ VGND VGND VPWR VPWR count_instr\[21\] sky130_fd_sc_hd__dfxtp_1
XTAP_TAPCELL_ROW_94_1836 VGND VPWR sky130_fd_sc_hd__tapvpwrvgnd_1
Xrebuffer185 net572 VGND VGND VPWR VPWR net571 sky130_fd_sc_hd__dlymetal6s2s_1
Xrebuffer196 net583 VGND VGND VPWR VPWR net582 sky130_fd_sc_hd__dlygate4sd1_1
XFILLER_150_221 VPWR VGND VPWR VGND sky130_ef_sc_hd__decap_12
XFILLER_123_446 VGND VGND VPWR VPWR sky130_fd_sc_hd__fill_2
XFILLER_151_777 VGND VGND VPWR VPWR sky130_fd_sc_hd__decap_6
XFILLER_150_265 VPWR VGND VPWR VGND sky130_ef_sc_hd__decap_12
X_11024_ clknet_leaf_69_clk _01086_ VGND VGND VPWR VPWR cpuregs\[19\]\[24\] sky130_fd_sc_hd__dfxtp_1
XFILLER_104_682 VGND VGND VPWR VPWR sky130_fd_sc_hd__decap_8
XFILLER_89_360 VGND VGND VPWR VPWR sky130_fd_sc_hd__fill_2
XFILLER_2_15 VPWR VGND VPWR VGND sky130_ef_sc_hd__decap_12
XFILLER_49_257 VGND VGND VPWR VPWR sky130_fd_sc_hd__fill_1
XTAP_TAPCELL_ROW_125_2335 VGND VPWR sky130_fd_sc_hd__tapvpwrvgnd_1
XTAP_TAPCELL_ROW_125_2324 VGND VPWR sky130_fd_sc_hd__tapvpwrvgnd_1
XFILLER_92_503 VGND VGND VPWR VPWR sky130_fd_sc_hd__decap_6
XFILLER_64_216 VGND VGND VPWR VPWR sky130_fd_sc_hd__decap_6
XFILLER_18_666 VPWR VGND VPWR VGND sky130_ef_sc_hd__decap_12
XFILLER_60_400 VGND VGND VPWR VPWR sky130_fd_sc_hd__decap_6
XFILLER_18_699 VGND VGND VPWR VPWR sky130_fd_sc_hd__fill_1
XFILLER_21_809 VPWR VGND VPWR VGND sky130_ef_sc_hd__decap_12
XTAP_TAPCELL_ROW_103_1987 VGND VPWR sky130_fd_sc_hd__tapvpwrvgnd_1
XTAP_TAPCELL_ROW_103_1976 VGND VPWR sky130_fd_sc_hd__tapvpwrvgnd_1
X_10808_ clknet_leaf_98_clk _00873_ VGND VGND VPWR VPWR instr_slt sky130_fd_sc_hd__dfxtp_1
XFILLER_14_861 VGND VGND VPWR VPWR sky130_fd_sc_hd__decap_6
XTAP_TAPCELL_ROW_31_826 VGND VPWR sky130_fd_sc_hd__tapvpwrvgnd_1
XFILLER_32_157 VGND VGND VPWR VPWR sky130_fd_sc_hd__decap_4
XTAP_TAPCELL_ROW_45_1050 VGND VPWR sky130_fd_sc_hd__tapvpwrvgnd_1
X_10739_ clknet_leaf_19_clk _00836_ VGND VGND VPWR VPWR net226 sky130_fd_sc_hd__dfxtp_2
XFILLER_13_382 VGND VGND VPWR VPWR sky130_fd_sc_hd__decap_8
XFILLER_13_393 VGND VGND VPWR VPWR sky130_fd_sc_hd__fill_1
XFILLER_146_549 VGND VGND VPWR VPWR sky130_fd_sc_hd__fill_1
XFILLER_127_785 VPWR VGND VPWR VGND sky130_ef_sc_hd__decap_12
XFILLER_127_763 VPWR VGND VPWR VGND sky130_ef_sc_hd__decap_12
Xoutput105 net105 VGND VGND VPWR VPWR mem_la_wdata[17] sky130_fd_sc_hd__buf_2
Xoutput116 net116 VGND VGND VPWR VPWR mem_la_wdata[27] sky130_fd_sc_hd__buf_2
XFILLER_99_113 VGND VGND VPWR VPWR sky130_fd_sc_hd__decap_4
Xoutput149 net149 VGND VGND VPWR VPWR mem_wdata[22] sky130_fd_sc_hd__buf_2
Xoutput138 net138 VGND VGND VPWR VPWR mem_wdata[12] sky130_fd_sc_hd__buf_2
Xoutput127 net127 VGND VGND VPWR VPWR mem_la_wdata[8] sky130_fd_sc_hd__buf_2
XFILLER_142_755 VGND VGND VPWR VPWR sky130_fd_sc_hd__fill_1
X_07950_ decoded_imm_j\[7\] _03694_ VGND VGND VPWR VPWR _03776_ sky130_fd_sc_hd__or2_1
XFILLER_142_799 VPWR VGND VPWR VGND sky130_ef_sc_hd__decap_12
X_06901_ _02714_ _03301_ _03302_ _03304_ _03317_ VGND VGND VPWR VPWR _03318_ sky130_fd_sc_hd__o41a_1
X_07881_ reg_pc\[28\] _01624_ _01628_ _03716_ VGND VGND VPWR VPWR _00672_ sky130_fd_sc_hd__a22o_1
XFILLER_68_566 VGND VGND VPWR VPWR sky130_fd_sc_hd__decap_8
X_06832_ cpuregs\[16\]\[19\] cpuregs\[17\]\[19\] cpuregs\[18\]\[19\] cpuregs\[19\]\[19\]
+ _00012_ _00013_ VGND VGND VPWR VPWR _03251_ sky130_fd_sc_hd__mux4_1
X_09620_ _02691_ cpuregs\[3\]\[26\] _04868_ VGND VGND VPWR VPWR _01280_ sky130_fd_sc_hd__mux2_1
XFILLER_55_216 VGND VGND VPWR VPWR sky130_fd_sc_hd__decap_8
X_09551_ cpuregs\[23\]\[23\] _02678_ _04866_ VGND VGND VPWR VPWR _01213_ sky130_fd_sc_hd__mux2_1
X_06763_ reg_pc\[16\] _02751_ _03184_ _02715_ VGND VGND VPWR VPWR _03185_ sky130_fd_sc_hd__a211o_1
XTAP_TAPCELL_ROW_39_948 VGND VPWR sky130_fd_sc_hd__tapvpwrvgnd_1
XTAP_TAPCELL_ROW_39_959 VGND VPWR sky130_fd_sc_hd__tapvpwrvgnd_1
X_08502_ net87 net56 _04208_ VGND VGND VPWR VPWR _00800_ sky130_fd_sc_hd__mux2_1
X_05714_ _02133_ _02288_ VGND VGND VPWR VPWR _02289_ sky130_fd_sc_hd__nand2_1
X_09482_ cpuregs\[24\]\[20\] _02665_ _04864_ VGND VGND VPWR VPWR _01146_ sky130_fd_sc_hd__mux2_1
XFILLER_91_580 VPWR VGND VPWR VGND sky130_ef_sc_hd__decap_12
X_06694_ cpuregs\[8\]\[14\] cpuregs\[9\]\[14\] cpuregs\[10\]\[14\] cpuregs\[11\]\[14\]
+ net265 net260 VGND VGND VPWR VPWR _03118_ sky130_fd_sc_hd__mux4_1
X_05645_ _01568_ net227 _02081_ _02223_ VGND VGND VPWR VPWR _02228_ sky130_fd_sc_hd__o22a_1
X_08433_ _01660_ _02719_ _02725_ VGND VGND VPWR VPWR _04170_ sky130_fd_sc_hd__a21o_1
XFILLER_51_444 VGND VGND VPWR VPWR sky130_fd_sc_hd__decap_4
XFILLER_24_669 VGND VGND VPWR VPWR sky130_fd_sc_hd__decap_3
XFILLER_149_321 VPWR VGND VPWR VGND sky130_ef_sc_hd__decap_12
X_08364_ count_cycle\[38\] _04124_ _04126_ VGND VGND VPWR VPWR _00745_ sky130_fd_sc_hd__o21a_1
X_05576_ net200 net126 VGND VGND VPWR VPWR _02159_ sky130_fd_sc_hd__or2_1
XFILLER_137_505 VGND VGND VPWR VPWR sky130_fd_sc_hd__decap_4
X_07315_ _03557_ _03561_ VGND VGND VPWR VPWR _03562_ sky130_fd_sc_hd__nor2_8
X_08295_ count_cycle\[13\] count_cycle\[14\] _04078_ VGND VGND VPWR VPWR _04082_ sky130_fd_sc_hd__and3_1
XFILLER_118_752 VGND VGND VPWR VPWR sky130_fd_sc_hd__decap_4
X_07246_ cpuregs\[13\]\[30\] _02709_ net251 VGND VGND VPWR VPWR _00194_ sky130_fd_sc_hd__mux2_1
XFILLER_106_903 VGND VGND VPWR VPWR sky130_fd_sc_hd__fill_1
X_07177_ cpuregs\[12\]\[31\] _02712_ net253 VGND VGND VPWR VPWR _00131_ sky130_fd_sc_hd__mux2_1
XFILLER_11_57 VPWR VGND VPWR VGND sky130_ef_sc_hd__decap_12
XFILLER_127_57 VGND VGND VPWR VPWR sky130_fd_sc_hd__decap_8
XTAP_TAPCELL_ROW_76_1555 VGND VPWR sky130_fd_sc_hd__tapvpwrvgnd_1
XTAP_TAPCELL_ROW_76_1544 VGND VPWR sky130_fd_sc_hd__tapvpwrvgnd_1
XFILLER_3_529 VPWR VGND VPWR VGND sky130_ef_sc_hd__decap_12
X_06128_ reg_out\[4\] alu_out_q\[4\] net589 VGND VGND VPWR VPWR _02594_ sky130_fd_sc_hd__mux2_2
X_06059_ cpuregs\[28\]\[2\] cpuregs\[29\]\[2\] cpuregs\[30\]\[2\] cpuregs\[31\]\[2\]
+ net279 _00008_ VGND VGND VPWR VPWR _02532_ sky130_fd_sc_hd__mux4_1
X_09818_ _02688_ cpuregs\[8\]\[25\] _04875_ VGND VGND VPWR VPWR _01471_ sky130_fd_sc_hd__mux2_1
XFILLER_87_897 VGND VGND VPWR VPWR sky130_fd_sc_hd__decap_3
XFILLER_87_875 VGND VGND VPWR VPWR sky130_fd_sc_hd__decap_8
XFILLER_143_89 VGND VGND VPWR VPWR sky130_fd_sc_hd__fill_1
X_09749_ _02675_ cpuregs\[6\]\[22\] _04873_ VGND VGND VPWR VPWR _01404_ sky130_fd_sc_hd__mux2_1
XTAP_TAPCELL_ROW_107_2043 VGND VPWR sky130_fd_sc_hd__tapvpwrvgnd_1
XFILLER_100_195 VGND VGND VPWR VPWR sky130_fd_sc_hd__fill_1
XFILLER_100_162 VGND VGND VPWR VPWR sky130_fd_sc_hd__decap_6
XFILLER_61_208 VGND VGND VPWR VPWR sky130_fd_sc_hd__decap_6
XTAP_TAPCELL_ROW_17_609 VGND VPWR sky130_fd_sc_hd__tapvpwrvgnd_1
XFILLER_27_463 VGND VGND VPWR VPWR sky130_fd_sc_hd__decap_3
XTAP_TAPCELL_ROW_120_2254 VGND VPWR sky130_fd_sc_hd__tapvpwrvgnd_1
XFILLER_70_764 VGND VGND VPWR VPWR sky130_fd_sc_hd__decap_4
XFILLER_14_135 VGND VGND VPWR VPWR sky130_fd_sc_hd__decap_4
XFILLER_42_455 VGND VGND VPWR VPWR sky130_fd_sc_hd__decap_8
XFILLER_14_157 VGND VGND VPWR VPWR sky130_fd_sc_hd__fill_2
XFILLER_30_628 VGND VGND VPWR VPWR sky130_fd_sc_hd__fill_1
XFILLER_52_75 VGND VGND VPWR VPWR sky130_fd_sc_hd__decap_8
XFILLER_52_64 VGND VGND VPWR VPWR sky130_fd_sc_hd__fill_2
XFILLER_52_53 VGND VGND VPWR VPWR sky130_fd_sc_hd__fill_2
Xinput18 mem_rdata[25] VGND VGND VPWR VPWR net18 sky130_fd_sc_hd__buf_2
XFILLER_11_853 VPWR VGND VPWR VGND sky130_ef_sc_hd__decap_12
XFILLER_10_352 VPWR VGND VPWR VGND sky130_ef_sc_hd__decap_12
XFILLER_6_301 VGND VGND VPWR VPWR sky130_fd_sc_hd__decap_6
X_10524_ clknet_leaf_132_clk _00654_ VGND VGND VPWR VPWR reg_pc\[10\] sky130_fd_sc_hd__dfxtp_2
Xinput29 mem_rdata[6] VGND VGND VPWR VPWR net29 sky130_fd_sc_hd__buf_1
XFILLER_11_897 VPWR VGND VPWR VGND sky130_ef_sc_hd__decap_12
X_10455_ clknet_leaf_108_clk _00585_ VGND VGND VPWR VPWR count_instr\[4\] sky130_fd_sc_hd__dfxtp_1
XFILLER_6_345 VPWR VGND VPWR VGND sky130_ef_sc_hd__decap_12
XFILLER_108_295 VPWR VGND VPWR VGND sky130_ef_sc_hd__decap_12
XFILLER_108_273 VGND VGND VPWR VPWR sky130_fd_sc_hd__fill_1
XFILLER_124_755 VGND VGND VPWR VPWR sky130_fd_sc_hd__fill_1
X_10386_ clknet_leaf_118_clk _00516_ VGND VGND VPWR VPWR cpuregs\[20\]\[0\] sky130_fd_sc_hd__dfxtp_1
XFILLER_78_820 VGND VGND VPWR VPWR sky130_fd_sc_hd__decap_6
XFILLER_111_438 VGND VGND VPWR VPWR sky130_fd_sc_hd__fill_2
X_11007_ clknet_leaf_144_clk _01069_ VGND VGND VPWR VPWR cpuregs\[19\]\[7\] sky130_fd_sc_hd__dfxtp_1
XFILLER_92_333 VPWR VGND VPWR VGND sky130_ef_sc_hd__decap_12
XFILLER_93_878 VGND VGND VPWR VPWR sky130_fd_sc_hd__fill_1
XFILLER_18_430 VGND VGND VPWR VPWR sky130_fd_sc_hd__decap_4
XTAP_TAPCELL_ROW_36_907 VGND VPWR sky130_fd_sc_hd__tapvpwrvgnd_1
XFILLER_52_219 VGND VGND VPWR VPWR sky130_fd_sc_hd__decap_8
XFILLER_61_753 VPWR VGND VPWR VGND sky130_ef_sc_hd__decap_12
X_05430_ reg_pc\[29\] decoded_imm\[29\] VGND VGND VPWR VPWR _02016_ sky130_fd_sc_hd__and2_1
XFILLER_21_617 VGND VGND VPWR VPWR sky130_fd_sc_hd__decap_8
XTAP_TAPCELL_ROW_138_2537 VGND VPWR sky130_fd_sc_hd__tapvpwrvgnd_1
X_05361_ cpu_state\[3\] _01947_ _01951_ _01952_ VGND VGND VPWR VPWR _04893_ sky130_fd_sc_hd__a211o_1
XFILLER_119_516 VGND VGND VPWR VPWR sky130_fd_sc_hd__decap_4
XFILLER_119_505 VGND VGND VPWR VPWR sky130_fd_sc_hd__decap_4
X_07100_ cpuregs\[20\]\[29\] cpuregs\[21\]\[29\] cpuregs\[22\]\[29\] cpuregs\[23\]\[29\]
+ net266 net261 VGND VGND VPWR VPWR _03509_ sky130_fd_sc_hd__mux4_1
X_05292_ reg_pc\[17\] decoded_imm\[17\] _01869_ _01876_ _01878_ VGND VGND VPWR VPWR
+ _01889_ sky130_fd_sc_hd__a221oi_4
X_08080_ _03868_ _03880_ VGND VGND VPWR VPWR _03896_ sky130_fd_sc_hd__nand2_1
XFILLER_9_194 VGND VGND VPWR VPWR sky130_fd_sc_hd__fill_2
XTAP_TAPCELL_ROW_151_2748 VGND VPWR sky130_fd_sc_hd__tapvpwrvgnd_1
X_07031_ _03434_ _03435_ _01579_ VGND VGND VPWR VPWR _03443_ sky130_fd_sc_hd__mux2_1
XTAP_TAPCELL_ROW_58_1252 VGND VPWR sky130_fd_sc_hd__tapvpwrvgnd_1
XTAP_TAPCELL_ROW_58_1263 VGND VPWR sky130_fd_sc_hd__tapvpwrvgnd_1
XPHY_EDGE_ROW_143_Right_143 VGND VGND VPWR VPWR sky130_fd_sc_hd__decap_3
X_08982_ _01558_ _04654_ _01560_ VGND VGND VPWR VPWR _04657_ sky130_fd_sc_hd__o21a_1
XFILLER_87_105 VGND VGND VPWR VPWR sky130_fd_sc_hd__decap_6
XTAP_TAPCELL_ROW_71_1463 VGND VPWR sky130_fd_sc_hd__tapvpwrvgnd_1
X_07933_ _01547_ reg_next_pc\[5\] _01645_ _03692_ VGND VGND VPWR VPWR _03761_ sky130_fd_sc_hd__a22o_1
X_07864_ reg_pc\[20\] _01624_ _01628_ _03707_ VGND VGND VPWR VPWR _00664_ sky130_fd_sc_hd__a22o_1
XTAP_TAPCELL_ROW_71_1474 VGND VPWR sky130_fd_sc_hd__tapvpwrvgnd_1
XFILLER_29_717 VGND VGND VPWR VPWR sky130_fd_sc_hd__fill_2
XFILLER_110_471 VGND VGND VPWR VPWR sky130_fd_sc_hd__decap_4
X_06815_ reg_pc\[18\] _02751_ _03234_ _02715_ VGND VGND VPWR VPWR _03235_ sky130_fd_sc_hd__a211o_1
X_09603_ _02621_ cpuregs\[3\]\[9\] _04868_ VGND VGND VPWR VPWR _01263_ sky130_fd_sc_hd__mux2_1
X_07795_ _03664_ count_instr\[52\] count_instr\[51\] count_instr\[53\] VGND VGND VPWR
+ VPWR _03669_ sky130_fd_sc_hd__and4_1
X_06746_ net177 _02721_ _03088_ _01641_ VGND VGND VPWR VPWR _03168_ sky130_fd_sc_hd__o211a_1
XFILLER_37_794 VPWR VGND VPWR VGND sky130_ef_sc_hd__decap_12
X_09534_ cpuregs\[23\]\[6\] _02607_ _04866_ VGND VGND VPWR VPWR _01196_ sky130_fd_sc_hd__mux2_1
X_06677_ net258 _03092_ _00016_ VGND VGND VPWR VPWR _03102_ sky130_fd_sc_hd__o21a_1
X_09465_ cpuregs\[24\]\[3\] _02593_ net243 VGND VGND VPWR VPWR _01129_ sky130_fd_sc_hd__mux2_1
XFILLER_36_282 VPWR VGND VPWR VGND sky130_ef_sc_hd__decap_12
X_08416_ count_cycle\[56\] _04154_ count_cycle\[58\] count_cycle\[57\] VGND VGND VPWR
+ VPWR _04159_ sky130_fd_sc_hd__and4_1
X_05628_ net210 _02110_ VGND VGND VPWR VPWR _02211_ sky130_fd_sc_hd__nor2_1
XFILLER_11_105 VGND VGND VPWR VPWR sky130_fd_sc_hd__decap_6
XFILLER_12_606 VGND VGND VPWR VPWR sky130_fd_sc_hd__fill_1
XFILLER_138_803 VGND VGND VPWR VPWR sky130_fd_sc_hd__decap_8
X_09396_ _02586_ cpuregs\[18\]\[0\] _04862_ VGND VGND VPWR VPWR _01030_ sky130_fd_sc_hd__mux2_1
XFILLER_138_825 VPWR VGND VPWR VGND sky130_ef_sc_hd__decap_12
X_08347_ count_cycle\[32\] _04114_ _01549_ VGND VGND VPWR VPWR _04116_ sky130_fd_sc_hd__a21oi_1
X_05559_ net606 net108 VGND VGND VPWR VPWR _02142_ sky130_fd_sc_hd__or2_1
XFILLER_138_869 VPWR VGND VPWR VGND sky130_ef_sc_hd__decap_12
X_08278_ count_cycle\[7\] net397 count_cycle\[8\] VGND VGND VPWR VPWR _04071_ sky130_fd_sc_hd__a21o_1
XTAP_TAPCELL_ROW_22_678 VGND VPWR sky130_fd_sc_hd__tapvpwrvgnd_1
XTAP_TAPCELL_ROW_22_689 VGND VPWR sky130_fd_sc_hd__tapvpwrvgnd_1
XFILLER_153_839 VGND VGND VPWR VPWR sky130_fd_sc_hd__fill_1
X_07229_ cpuregs\[13\]\[13\] _02638_ net251 VGND VGND VPWR VPWR _00177_ sky130_fd_sc_hd__mux2_1
XFILLER_4_805 VGND VGND VPWR VPWR sky130_fd_sc_hd__decap_6
XFILLER_98_49 VGND VGND VPWR VPWR sky130_fd_sc_hd__fill_1
X_10240_ clknet_leaf_26_clk _00370_ VGND VGND VPWR VPWR cpuregs\[27\]\[14\] sky130_fd_sc_hd__dfxtp_1
XFILLER_4_849 VPWR VGND VPWR VGND sky130_ef_sc_hd__decap_12
XFILLER_145_390 VGND VGND VPWR VPWR sky130_fd_sc_hd__fill_2
XFILLER_105_243 VGND VGND VPWR VPWR sky130_fd_sc_hd__decap_4
XFILLER_3_337 VPWR VGND VPWR VGND sky130_ef_sc_hd__decap_12
XFILLER_133_596 VGND VGND VPWR VPWR sky130_fd_sc_hd__fill_1
XFILLER_79_639 VGND VGND VPWR VPWR sky130_fd_sc_hd__fill_2
X_10171_ clknet_leaf_146_clk _00301_ VGND VGND VPWR VPWR cpuregs\[9\]\[9\] sky130_fd_sc_hd__dfxtp_1
XPHY_EDGE_ROW_110_Right_110 VGND VGND VPWR VPWR sky130_fd_sc_hd__decap_3
XFILLER_47_20 VPWR VGND VPWR VGND sky130_ef_sc_hd__decap_12
XTAP_TAPCELL_ROW_89_1757 VGND VPWR sky130_fd_sc_hd__tapvpwrvgnd_1
XFILLER_59_385 VGND VGND VPWR VPWR sky130_fd_sc_hd__fill_1
XTAP_TAPCELL_ROW_2_370 VGND VPWR sky130_fd_sc_hd__tapvpwrvgnd_1
XFILLER_103_81 VPWR VGND VPWR VGND sky130_ef_sc_hd__decap_12
XFILLER_15_455 VGND VGND VPWR VPWR sky130_fd_sc_hd__fill_1
XTAP_TAPCELL_ROW_100_1935 VGND VPWR sky130_fd_sc_hd__tapvpwrvgnd_1
XTAP_TAPCELL_ROW_100_1924 VGND VPWR sky130_fd_sc_hd__tapvpwrvgnd_1
XFILLER_7_610 VGND VGND VPWR VPWR sky130_fd_sc_hd__decap_6
XTAP_TAPCELL_ROW_41_987 VGND VPWR sky130_fd_sc_hd__tapvpwrvgnd_1
X_10507_ clknet_leaf_81_clk _00637_ VGND VGND VPWR VPWR count_instr\[56\] sky130_fd_sc_hd__dfxtp_1
XFILLER_6_153 VPWR VGND VPWR VGND sky130_ef_sc_hd__decap_12
XTAP_TAPCELL_ROW_133_2467 VGND VPWR sky130_fd_sc_hd__tapvpwrvgnd_1
XTAP_TAPCELL_ROW_133_2456 VGND VPWR sky130_fd_sc_hd__tapvpwrvgnd_1
X_11487_ clknet_leaf_74_clk _01531_ VGND VGND VPWR VPWR cpuregs\[10\]\[21\] sky130_fd_sc_hd__dfxtp_1
XFILLER_152_861 VGND VGND VPWR VPWR sky130_fd_sc_hd__decap_6
X_10438_ clknet_leaf_76_clk _00568_ VGND VGND VPWR VPWR cpuregs\[17\]\[20\] sky130_fd_sc_hd__dfxtp_1
XFILLER_6_197 VPWR VGND VPWR VGND sky130_ef_sc_hd__decap_12
X_10369_ clknet_leaf_15_clk _00499_ VGND VGND VPWR VPWR cpuregs\[25\]\[15\] sky130_fd_sc_hd__dfxtp_1
XFILLER_151_393 VPWR VGND VPWR VGND sky130_ef_sc_hd__decap_12
XFILLER_112_769 VGND VGND VPWR VPWR sky130_fd_sc_hd__decap_8
XFILLER_97_447 VGND VGND VPWR VPWR sky130_fd_sc_hd__fill_1
XFILLER_69_149 VGND VGND VPWR VPWR sky130_fd_sc_hd__decap_3
X_04930_ net178 VGND VGND VPWR VPWR _01563_ sky130_fd_sc_hd__inv_2
XFILLER_66_801 VGND VGND VPWR VPWR sky130_fd_sc_hd__decap_8
XTAP_TAPCELL_ROW_53_1182 VGND VPWR sky130_fd_sc_hd__tapvpwrvgnd_1
XFILLER_19_3 VPWR VGND VPWR VGND sky130_ef_sc_hd__decap_12
XFILLER_81_815 VGND VGND VPWR VPWR sky130_fd_sc_hd__decap_8
Xclkbuf_4_1_0_clk clknet_0_clk VGND VGND VPWR VPWR clknet_4_1_0_clk sky130_fd_sc_hd__clkbuf_8
XTAP_TAPCELL_ROW_0_318 VGND VPWR sky130_fd_sc_hd__tapvpwrvgnd_1
XFILLER_93_697 VGND VGND VPWR VPWR sky130_fd_sc_hd__decap_6
XFILLER_92_174 VPWR VGND VPWR VGND sky130_ef_sc_hd__decap_12
X_07580_ cpuregs\[25\]\[31\] _02712_ _03571_ VGND VGND VPWR VPWR _00515_ sky130_fd_sc_hd__mux2_1
X_06600_ _03018_ _03026_ _03027_ _01581_ _01580_ VGND VGND VPWR VPWR _03028_ sky130_fd_sc_hd__a221o_1
XFILLER_53_539 VPWR VGND VPWR VGND sky130_ef_sc_hd__decap_12
XTAP_TAPCELL_ROW_0_329 VGND VPWR sky130_fd_sc_hd__tapvpwrvgnd_1
XFILLER_19_783 VGND VGND VPWR VPWR sky130_fd_sc_hd__fill_1
X_06531_ _02744_ _02881_ _02958_ _02960_ VGND VGND VPWR VPWR _02961_ sky130_fd_sc_hd__a31o_1
XFILLER_34_753 VGND VGND VPWR VPWR sky130_fd_sc_hd__decap_3
X_09250_ cpuregs\[1\]\[29\] _02704_ net244 VGND VGND VPWR VPWR _00947_ sky130_fd_sc_hd__mux2_1
X_08201_ _03715_ _04002_ VGND VGND VPWR VPWR _04007_ sky130_fd_sc_hd__nor2_1
X_06462_ reg_pc\[5\] _02751_ _02892_ _02894_ _02715_ VGND VGND VPWR VPWR _02895_ sky130_fd_sc_hd__a221o_1
X_05413_ _01994_ _01995_ _01999_ _02000_ VGND VGND VPWR VPWR _04897_ sky130_fd_sc_hd__a211o_1
X_09181_ decoded_imm_j\[6\] _01120_ _02513_ VGND VGND VPWR VPWR _00888_ sky130_fd_sc_hd__mux2_1
X_06393_ cpuregs\[2\]\[3\] cpuregs\[3\]\[3\] net268 VGND VGND VPWR VPWR _02828_ sky130_fd_sc_hd__mux2_1
X_08132_ _03917_ _03927_ _03928_ VGND VGND VPWR VPWR _03944_ sky130_fd_sc_hd__a21bo_1
X_05344_ net15 _01665_ _01856_ VGND VGND VPWR VPWR _01937_ sky130_fd_sc_hd__a21o_1
XFILLER_146_165 VPWR VGND VPWR VGND sky130_ef_sc_hd__decap_12
X_05275_ net256 _01872_ _01873_ net178 cpu_state\[4\] VGND VGND VPWR VPWR _01874_
+ sky130_fd_sc_hd__a32o_1
X_08063_ decoded_imm_j\[16\] _03703_ VGND VGND VPWR VPWR _03880_ sky130_fd_sc_hd__nand2_1
XFILLER_135_839 VGND VGND VPWR VPWR sky130_fd_sc_hd__fill_1
X_07014_ _03398_ _03401_ _03424_ _01621_ VGND VGND VPWR VPWR _03426_ sky130_fd_sc_hd__a31o_1
Xpicorv32_341 VGND VGND VPWR VPWR picorv32_341/HI pcpi_insn[24] sky130_fd_sc_hd__conb_1
Xpicorv32_352 VGND VGND VPWR VPWR picorv32_352/HI trace_data[2] sky130_fd_sc_hd__conb_1
Xpicorv32_363 VGND VGND VPWR VPWR picorv32_363/HI trace_data[13] sky130_fd_sc_hd__conb_1
Xpicorv32_330 VGND VGND VPWR VPWR picorv32_330/HI pcpi_insn[13] sky130_fd_sc_hd__conb_1
XTAP_TAPCELL_ROW_73_1503 VGND VPWR sky130_fd_sc_hd__tapvpwrvgnd_1
Xpicorv32_374 VGND VGND VPWR VPWR picorv32_374/HI trace_data[24] sky130_fd_sc_hd__conb_1
Xpicorv32_385 VGND VGND VPWR VPWR picorv32_385/HI trace_data[35] sky130_fd_sc_hd__conb_1
X_08965_ _04632_ _04639_ _04640_ _01560_ _00010_ VGND VGND VPWR VPWR _04641_ sky130_fd_sc_hd__a221o_1
XFILLER_130_533 VGND VGND VPWR VPWR sky130_fd_sc_hd__fill_1
XFILLER_0_329 VGND VGND VPWR VPWR sky130_fd_sc_hd__decap_3
X_07916_ _03743_ _03744_ _03742_ VGND VGND VPWR VPWR _03745_ sky130_fd_sc_hd__a21oi_1
X_08896_ cpuregs\[20\]\[23\] cpuregs\[21\]\[23\] cpuregs\[22\]\[23\] cpuregs\[23\]\[23\]
+ net276 net272 VGND VGND VPWR VPWR _04575_ sky130_fd_sc_hd__mux4_1
XFILLER_96_491 VGND VGND VPWR VPWR sky130_fd_sc_hd__fill_2
XFILLER_84_29 VPWR VGND VPWR VGND sky130_ef_sc_hd__decap_12
XFILLER_75_119 VGND VGND VPWR VPWR sky130_fd_sc_hd__fill_1
XFILLER_84_642 VGND VGND VPWR VPWR sky130_fd_sc_hd__fill_2
XFILLER_72_804 VGND VGND VPWR VPWR sky130_fd_sc_hd__fill_1
X_07847_ _02631_ reg_next_pc\[12\] _02482_ VGND VGND VPWR VPWR _03699_ sky130_fd_sc_hd__mux2_2
XTAP_TAPCELL_ROW_104_2002 VGND VPWR sky130_fd_sc_hd__tapvpwrvgnd_1
X_07778_ _03658_ net34 _03657_ VGND VGND VPWR VPWR _00627_ sky130_fd_sc_hd__and3b_1
XFILLER_56_377 VGND VGND VPWR VPWR sky130_fd_sc_hd__decap_6
X_09517_ cpuregs\[31\]\[22\] _02675_ _04865_ VGND VGND VPWR VPWR _01180_ sky130_fd_sc_hd__mux2_1
X_06729_ _03143_ _03150_ _03151_ _01581_ _01580_ VGND VGND VPWR VPWR _03152_ sky130_fd_sc_hd__a221o_1
XFILLER_25_742 VGND VGND VPWR VPWR sky130_fd_sc_hd__fill_2
XTAP_TAPCELL_ROW_27_759 VGND VPWR sky130_fd_sc_hd__tapvpwrvgnd_1
XTAP_TAPCELL_ROW_84_1676 VGND VPWR sky130_fd_sc_hd__tapvpwrvgnd_1
XFILLER_24_263 VGND VGND VPWR VPWR sky130_fd_sc_hd__decap_8
X_09448_ _02662_ cpuregs\[19\]\[19\] _04863_ VGND VGND VPWR VPWR _01081_ sky130_fd_sc_hd__mux2_1
XFILLER_25_797 VPWR VGND VPWR VGND sky130_ef_sc_hd__decap_12
X_09379_ instr_jal decoded_imm_j\[6\] _04823_ mem_rdata_q\[26\] _04747_ VGND VGND
+ VPWR VPWR _04852_ sky130_fd_sc_hd__a221o_1
XFILLER_33_55 VGND VGND VPWR VPWR sky130_fd_sc_hd__fill_1
XFILLER_149_55 VGND VGND VPWR VPWR sky130_fd_sc_hd__fill_1
X_11410_ clknet_leaf_13_clk _01454_ VGND VGND VPWR VPWR cpuregs\[8\]\[8\] sky130_fd_sc_hd__dfxtp_1
XFILLER_33_88 VGND VGND VPWR VPWR sky130_fd_sc_hd__fill_2
XFILLER_123_3 VPWR VGND VPWR VGND sky130_ef_sc_hd__decap_12
X_11341_ clknet_leaf_141_clk _01385_ VGND VGND VPWR VPWR cpuregs\[6\]\[3\] sky130_fd_sc_hd__dfxtp_1
XFILLER_137_187 VGND VGND VPWR VPWR sky130_fd_sc_hd__fill_2
XTAP_TAPCELL_ROW_115_2164 VGND VPWR sky130_fd_sc_hd__tapvpwrvgnd_1
XFILLER_4_635 VGND VGND VPWR VPWR sky130_fd_sc_hd__decap_8
XFILLER_153_669 VGND VGND VPWR VPWR sky130_fd_sc_hd__decap_3
XFILLER_141_809 VPWR VGND VPWR VGND sky130_ef_sc_hd__decap_12
XFILLER_134_861 VGND VGND VPWR VPWR sky130_fd_sc_hd__decap_6
XTAP_TAPCELL_ROW_115_2175 VGND VPWR sky130_fd_sc_hd__tapvpwrvgnd_1
X_11272_ clknet_leaf_115_clk _01319_ VGND VGND VPWR VPWR cpuregs\[4\]\[1\] sky130_fd_sc_hd__dfxtp_1
XFILLER_4_657 VPWR VGND VPWR VGND sky130_ef_sc_hd__decap_12
X_10223_ clknet_leaf_33_clk _00353_ VGND VGND VPWR VPWR cpuregs\[14\]\[29\] sky130_fd_sc_hd__dfxtp_1
XFILLER_3_167 VGND VGND VPWR VPWR sky130_fd_sc_hd__fill_1
X_10154_ clknet_leaf_70_clk _00284_ VGND VGND VPWR VPWR cpuregs\[21\]\[24\] sky130_fd_sc_hd__dfxtp_1
XFILLER_133_393 VGND VGND VPWR VPWR sky130_fd_sc_hd__fill_2
XFILLER_79_447 VGND VGND VPWR VPWR sky130_fd_sc_hd__fill_1
XTAP_TAPCELL_ROW_7_451 VGND VPWR sky130_fd_sc_hd__tapvpwrvgnd_1
XTAP_TAPCELL_ROW_7_440 VGND VPWR sky130_fd_sc_hd__tapvpwrvgnd_1
XFILLER_0_841 VGND VGND VPWR VPWR sky130_fd_sc_hd__fill_2
XFILLER_79_469 VGND VGND VPWR VPWR sky130_fd_sc_hd__decap_3
XFILLER_58_41 VGND VGND VPWR VPWR sky130_fd_sc_hd__decap_8
X_10085_ clknet_leaf_71_clk _00215_ VGND VGND VPWR VPWR cpuregs\[2\]\[19\] sky130_fd_sc_hd__dfxtp_1
XFILLER_58_96 VGND VGND VPWR VPWR sky130_fd_sc_hd__fill_2
XFILLER_74_141 VGND VGND VPWR VPWR sky130_fd_sc_hd__decap_4
XFILLER_35_517 VPWR VGND VPWR VGND sky130_ef_sc_hd__decap_12
XFILLER_74_73 VGND VGND VPWR VPWR sky130_fd_sc_hd__decap_8
XFILLER_62_325 VPWR VGND VPWR VGND sky130_ef_sc_hd__decap_12
X_10987_ clknet_leaf_71_clk _01049_ VGND VGND VPWR VPWR cpuregs\[18\]\[19\] sky130_fd_sc_hd__dfxtp_1
XFILLER_71_870 VGND VGND VPWR VPWR sky130_fd_sc_hd__fill_2
XFILLER_43_561 VGND VGND VPWR VPWR sky130_fd_sc_hd__decap_8
XFILLER_129_644 VGND VGND VPWR VPWR sky130_fd_sc_hd__fill_1
X_11608_ net122 VGND VGND VPWR VPWR net228 sky130_fd_sc_hd__clkbuf_1
XFILLER_7_462 VGND VGND VPWR VPWR sky130_fd_sc_hd__fill_1
XFILLER_116_349 VGND VGND VPWR VPWR sky130_fd_sc_hd__decap_8
X_05060_ cpu_state\[3\] cpu_state\[6\] cpu_state\[4\] VGND VGND VPWR VPWR _01675_
+ sky130_fd_sc_hd__or3_1
XFILLER_143_179 VPWR VGND VPWR VGND sky130_ef_sc_hd__decap_12
XTAP_TAPCELL_ROW_55_1211 VGND VPWR sky130_fd_sc_hd__tapvpwrvgnd_1
XFILLER_152_680 VPWR VGND VPWR VGND sky130_ef_sc_hd__decap_12
XFILLER_112_533 VPWR VGND VPWR VGND sky130_ef_sc_hd__decap_12
XFILLER_97_222 VGND VGND VPWR VPWR sky130_fd_sc_hd__fill_2
XFILLER_97_266 VPWR VGND VPWR VGND sky130_ef_sc_hd__decap_12
XFILLER_85_406 VGND VGND VPWR VPWR sky130_fd_sc_hd__decap_4
XFILLER_39_801 VPWR VGND VPWR VGND sky130_ef_sc_hd__decap_12
XFILLER_85_428 VPWR VGND VPWR VGND sky130_ef_sc_hd__decap_12
X_08750_ _04436_ _04437_ _04266_ _04434_ VGND VGND VPWR VPWR _04438_ sky130_fd_sc_hd__o211a_1
X_05962_ net196 _02484_ _01582_ VGND VGND VPWR VPWR net89 sky130_fd_sc_hd__mux2_1
XTAP_TAPCELL_ROW_146_2669 VGND VPWR sky130_fd_sc_hd__tapvpwrvgnd_1
X_05893_ _02066_ _02413_ _02210_ VGND VGND VPWR VPWR _02448_ sky130_fd_sc_hd__a21oi_1
X_07701_ _03609_ net34 _03608_ VGND VGND VPWR VPWR _00599_ sky130_fd_sc_hd__and3b_1
X_08681_ cpuregs\[8\]\[11\] cpuregs\[9\]\[11\] cpuregs\[10\]\[11\] cpuregs\[11\]\[11\]
+ net279 _00008_ VGND VGND VPWR VPWR _04372_ sky130_fd_sc_hd__mux4_1
XFILLER_38_333 VPWR VGND VPWR VGND sky130_ef_sc_hd__decap_12
X_04913_ mem_do_rinst VGND VGND VPWR VPWR _01546_ sky130_fd_sc_hd__inv_2
X_07632_ _02649_ cpuregs\[17\]\[16\] _03574_ VGND VGND VPWR VPWR _00564_ sky130_fd_sc_hd__mux2_1
X_07563_ cpuregs\[25\]\[14\] _02641_ _03571_ VGND VGND VPWR VPWR _00498_ sky130_fd_sc_hd__mux2_1
XFILLER_81_678 VGND VGND VPWR VPWR sky130_fd_sc_hd__decap_8
X_09302_ net167 _04206_ VGND VGND VPWR VPWR _04811_ sky130_fd_sc_hd__or2_1
XFILLER_0_81 VGND VGND VPWR VPWR sky130_fd_sc_hd__decap_3
XFILLER_22_701 VGND VGND VPWR VPWR sky130_fd_sc_hd__decap_8
XTAP_TAPCELL_ROW_24_718 VGND VPWR sky130_fd_sc_hd__tapvpwrvgnd_1
XFILLER_110_27 VGND VGND VPWR VPWR sky130_fd_sc_hd__fill_1
XTAP_TAPCELL_ROW_66_1395 VGND VPWR sky130_fd_sc_hd__tapvpwrvgnd_1
XTAP_TAPCELL_ROW_66_1384 VGND VPWR sky130_fd_sc_hd__tapvpwrvgnd_1
X_07494_ cpuregs\[26\]\[12\] _02633_ _03568_ VGND VGND VPWR VPWR _00432_ sky130_fd_sc_hd__mux2_1
X_06514_ _02940_ _02943_ _02944_ _00016_ _01580_ VGND VGND VPWR VPWR _02945_ sky130_fd_sc_hd__a221o_1
XFILLER_139_419 VGND VGND VPWR VPWR sky130_fd_sc_hd__fill_2
X_09233_ cpuregs\[1\]\[12\] _02633_ net244 VGND VGND VPWR VPWR _00930_ sky130_fd_sc_hd__mux2_1
XFILLER_21_222 VGND VGND VPWR VPWR sky130_fd_sc_hd__fill_2
X_06445_ _01622_ _02875_ _02876_ _02877_ VGND VGND VPWR VPWR _02878_ sky130_fd_sc_hd__and4_1
X_09164_ _04762_ _04779_ _04780_ _04781_ VGND VGND VPWR VPWR _04782_ sky130_fd_sc_hd__or4b_1
X_08115_ decoded_imm_j\[20\] _03707_ VGND VGND VPWR VPWR _03928_ sky130_fd_sc_hd__nand2_1
X_06376_ cpuregs\[26\]\[3\] cpuregs\[27\]\[3\] net268 VGND VGND VPWR VPWR _02811_
+ sky130_fd_sc_hd__mux2_1
XFILLER_135_625 VGND VGND VPWR VPWR sky130_fd_sc_hd__fill_2
X_05327_ reg_pc\[21\] decoded_imm\[21\] VGND VGND VPWR VPWR _01921_ sky130_fd_sc_hd__or2_1
X_09095_ is_beq_bne_blt_bge_bltu_bgeu net34 _04746_ VGND VGND VPWR VPWR _04750_ sky130_fd_sc_hd__and3_2
XFILLER_134_124 VPWR VGND VPWR VGND sky130_ef_sc_hd__decap_12
XFILLER_123_809 VPWR VGND VPWR VGND sky130_ef_sc_hd__decap_12
XFILLER_116_850 VPWR VGND VPWR VGND sky130_ef_sc_hd__decap_12
X_08046_ _03861_ _03864_ _03576_ VGND VGND VPWR VPWR _03865_ sky130_fd_sc_hd__a21oi_1
X_05258_ mem_wordsize\[2\] _01758_ _01665_ VGND VGND VPWR VPWR _01858_ sky130_fd_sc_hd__a21o_1
XFILLER_89_723 VGND VGND VPWR VPWR sky130_fd_sc_hd__decap_4
X_05189_ _01771_ _01793_ cpu_state\[6\] VGND VGND VPWR VPWR _01794_ sky130_fd_sc_hd__o21ai_1
XFILLER_1_605 VGND VGND VPWR VPWR sky130_fd_sc_hd__decap_8
XFILLER_131_853 VPWR VGND VPWR VGND sky130_ef_sc_hd__decap_12
XFILLER_103_511 VGND VGND VPWR VPWR sky130_fd_sc_hd__fill_2
XFILLER_135_57 VPWR VGND VPWR VGND sky130_ef_sc_hd__decap_12
X_09997_ clknet_leaf_41_clk _00127_ VGND VGND VPWR VPWR cpuregs\[12\]\[27\] sky130_fd_sc_hd__dfxtp_1
XTAP_TAPCELL_ROW_110_2094 VGND VPWR sky130_fd_sc_hd__tapvpwrvgnd_1
XFILLER_48_108 VGND VGND VPWR VPWR sky130_fd_sc_hd__decap_4
XFILLER_0_137 VGND VGND VPWR VPWR sky130_fd_sc_hd__decap_3
X_08948_ net270 _04620_ _04619_ _01560_ VGND VGND VPWR VPWR _04625_ sky130_fd_sc_hd__o211a_1
XFILLER_131_897 VPWR VGND VPWR VGND sky130_ef_sc_hd__decap_12
X_08879_ net216 _01585_ _04558_ _04559_ VGND VGND VPWR VPWR _00827_ sky130_fd_sc_hd__o22a_1
XTAP_TAPCELL_ROW_86_1705 VGND VPWR sky130_fd_sc_hd__tapvpwrvgnd_1
X_10910_ clknet_leaf_31_clk _00972_ VGND VGND VPWR VPWR net142 sky130_fd_sc_hd__dfxtp_1
XFILLER_72_601 VPWR VGND VPWR VGND sky130_ef_sc_hd__decap_12
XFILLER_56_141 VPWR VGND VPWR VGND sky130_ef_sc_hd__decap_12
XFILLER_28_88 VPWR VGND VPWR VGND sky130_ef_sc_hd__decap_12
XFILLER_45_837 VGND VGND VPWR VPWR sky130_fd_sc_hd__decap_3
XFILLER_71_111 VGND VGND VPWR VPWR sky130_fd_sc_hd__fill_1
XFILLER_45_859 VPWR VGND VPWR VGND sky130_ef_sc_hd__decap_12
X_10841_ clknet_leaf_89_clk _00906_ VGND VGND VPWR VPWR decoded_imm_j\[18\] sky130_fd_sc_hd__dfxtp_1
XFILLER_71_166 VGND VGND VPWR VPWR sky130_fd_sc_hd__fill_2
XFILLER_44_21 VGND VGND VPWR VPWR sky130_fd_sc_hd__decap_6
X_10772_ clknet_leaf_50_clk alu_out\[25\] VGND VGND VPWR VPWR alu_out_q\[25\] sky130_fd_sc_hd__dfxtp_1
XFILLER_40_520 VGND VGND VPWR VPWR sky130_fd_sc_hd__decap_8
XFILLER_9_727 VGND VGND VPWR VPWR sky130_fd_sc_hd__fill_1
XTAP_TAPCELL_ROW_117_2204 VGND VPWR sky130_fd_sc_hd__tapvpwrvgnd_1
XFILLER_126_614 VGND VGND VPWR VPWR sky130_fd_sc_hd__fill_1
XFILLER_125_113 VGND VGND VPWR VPWR sky130_fd_sc_hd__decap_6
XFILLER_153_455 VGND VGND VPWR VPWR sky130_fd_sc_hd__fill_1
X_11324_ clknet_leaf_75_clk _01371_ VGND VGND VPWR VPWR cpuregs\[5\]\[21\] sky130_fd_sc_hd__dfxtp_1
XTAP_TAPCELL_ROW_130_2415 VGND VPWR sky130_fd_sc_hd__tapvpwrvgnd_1
XTAP_TAPCELL_ROW_130_2404 VGND VPWR sky130_fd_sc_hd__tapvpwrvgnd_1
XTAP_TAPCELL_ROW_97_1889 VGND VPWR sky130_fd_sc_hd__tapvpwrvgnd_1
XTAP_TAPCELL_ROW_97_1878 VGND VPWR sky130_fd_sc_hd__tapvpwrvgnd_1
XTAP_TAPCELL_ROW_10_489 VGND VPWR sky130_fd_sc_hd__tapvpwrvgnd_1
XFILLER_5_15 VPWR VGND VPWR VGND sky130_ef_sc_hd__decap_12
XFILLER_4_421 VPWR VGND VPWR VGND sky130_ef_sc_hd__decap_12
XFILLER_141_617 VPWR VGND VPWR VGND sky130_ef_sc_hd__decap_12
X_11255_ clknet_leaf_54_clk _01302_ VGND VGND VPWR VPWR cpuregs\[22\]\[16\] sky130_fd_sc_hd__dfxtp_1
XFILLER_69_84 VGND VGND VPWR VPWR sky130_fd_sc_hd__fill_2
X_10206_ clknet_leaf_9_clk _00336_ VGND VGND VPWR VPWR cpuregs\[14\]\[12\] sky130_fd_sc_hd__dfxtp_1
X_11186_ clknet_leaf_148_clk _01233_ VGND VGND VPWR VPWR cpuregs\[29\]\[11\] sky130_fd_sc_hd__dfxtp_1
XFILLER_67_417 VGND VGND VPWR VPWR sky130_fd_sc_hd__fill_1
XTAP_TAPCELL_ROW_50_1130 VGND VPWR sky130_fd_sc_hd__tapvpwrvgnd_1
XFILLER_0_671 VGND VGND VPWR VPWR sky130_fd_sc_hd__fill_1
X_10137_ clknet_leaf_144_clk _00267_ VGND VGND VPWR VPWR cpuregs\[21\]\[7\] sky130_fd_sc_hd__dfxtp_1
XTAP_TAPCELL_ROW_128_2377 VGND VPWR sky130_fd_sc_hd__tapvpwrvgnd_1
X_10068_ clknet_leaf_121_clk _00198_ VGND VGND VPWR VPWR cpuregs\[2\]\[2\] sky130_fd_sc_hd__dfxtp_1
XPHY_EDGE_ROW_13_Right_13 VGND VGND VPWR VPWR sky130_fd_sc_hd__decap_3
XFILLER_36_837 VPWR VGND VPWR VGND sky130_ef_sc_hd__decap_12
XTAP_TAPCELL_ROW_141_2588 VGND VPWR sky130_fd_sc_hd__tapvpwrvgnd_1
XFILLER_63_689 VPWR VGND VPWR VGND sky130_ef_sc_hd__decap_12
XFILLER_63_667 VGND VGND VPWR VPWR sky130_fd_sc_hd__decap_4
XFILLER_51_807 VGND VGND VPWR VPWR sky130_fd_sc_hd__decap_3
XFILLER_35_358 VPWR VGND VPWR VGND sky130_ef_sc_hd__decap_12
XFILLER_50_317 VGND VGND VPWR VPWR sky130_fd_sc_hd__fill_1
XFILLER_44_881 VPWR VGND VPWR VGND sky130_ef_sc_hd__decap_12
XTAP_TAPCELL_ROW_48_1092 VGND VPWR sky130_fd_sc_hd__tapvpwrvgnd_1
X_06230_ reg_pc\[23\] _02673_ VGND VGND VPWR VPWR _02677_ sky130_fd_sc_hd__xor2_1
XPHY_EDGE_ROW_22_Right_22 VGND VGND VPWR VPWR sky130_fd_sc_hd__decap_3
XFILLER_144_411 VGND VGND VPWR VPWR sky130_fd_sc_hd__decap_8
X_06161_ _02621_ cpuregs\[11\]\[9\] _02582_ VGND VGND VPWR VPWR _00046_ sky130_fd_sc_hd__mux2_1
X_05112_ net171 mem_wordsize\[1\] _01722_ VGND VGND VPWR VPWR _01723_ sky130_fd_sc_hd__and3_1
X_06092_ cpuregs\[12\]\[4\] cpuregs\[13\]\[4\] cpuregs\[14\]\[4\] cpuregs\[15\]\[4\]
+ net278 net273 VGND VGND VPWR VPWR _02563_ sky130_fd_sc_hd__mux4_1
X_09920_ clknet_leaf_53_clk _00055_ VGND VGND VPWR VPWR cpuregs\[11\]\[18\] sky130_fd_sc_hd__dfxtp_1
X_05043_ cpu_state\[2\] is_sll_srl_sra _01653_ _01656_ _01660_ VGND VGND VPWR VPWR
+ _01662_ sky130_fd_sc_hd__a41o_1
XFILLER_132_639 VGND VGND VPWR VPWR sky130_fd_sc_hd__decap_4
XFILLER_113_820 VGND VGND VPWR VPWR sky130_fd_sc_hd__decap_8
X_09851_ _02688_ cpuregs\[10\]\[25\] _04876_ VGND VGND VPWR VPWR _01535_ sky130_fd_sc_hd__mux2_1
XFILLER_98_564 VGND VGND VPWR VPWR sky130_fd_sc_hd__decap_3
X_09782_ _02675_ cpuregs\[7\]\[22\] _04874_ VGND VGND VPWR VPWR _01436_ sky130_fd_sc_hd__mux2_1
X_06994_ cpuregs\[20\]\[25\] cpuregs\[21\]\[25\] cpuregs\[22\]\[25\] cpuregs\[23\]\[25\]
+ net267 net261 VGND VGND VPWR VPWR _03407_ sky130_fd_sc_hd__mux4_1
XFILLER_113_897 VPWR VGND VPWR VGND sky130_ef_sc_hd__decap_12
X_08802_ _01558_ _04478_ _00010_ VGND VGND VPWR VPWR _04487_ sky130_fd_sc_hd__o21a_1
XPHY_EDGE_ROW_31_Right_31 VGND VGND VPWR VPWR sky130_fd_sc_hd__decap_3
X_05945_ net122 net213 _01665_ VGND VGND VPWR VPWR net107 sky130_fd_sc_hd__mux2_1
X_08733_ net207 _01585_ _04420_ _04421_ VGND VGND VPWR VPWR _00819_ sky130_fd_sc_hd__o22a_1
XTAP_TAPCELL_ROW_68_1424 VGND VPWR sky130_fd_sc_hd__tapvpwrvgnd_1
XTAP_TAPCELL_ROW_68_1413 VGND VPWR sky130_fd_sc_hd__tapvpwrvgnd_1
XFILLER_121_15 VPWR VGND VPWR VGND sky130_ef_sc_hd__decap_12
X_05876_ _02051_ _02058_ _02432_ _02050_ VGND VGND VPWR VPWR _02433_ sky130_fd_sc_hd__o31ai_2
XFILLER_81_431 VPWR VGND VPWR VGND sky130_ef_sc_hd__decap_12
X_08664_ cpuregs\[28\]\[10\] cpuregs\[29\]\[10\] cpuregs\[30\]\[10\] cpuregs\[31\]\[10\]
+ net277 net271 VGND VGND VPWR VPWR _04356_ sky130_fd_sc_hd__mux4_1
XFILLER_54_645 VPWR VGND VPWR VGND sky130_ef_sc_hd__decap_12
XFILLER_53_111 VGND VGND VPWR VPWR sky130_fd_sc_hd__fill_1
XFILLER_26_325 VGND VGND VPWR VPWR sky130_fd_sc_hd__decap_6
X_07615_ _03557_ _03569_ VGND VGND VPWR VPWR _03574_ sky130_fd_sc_hd__or2_4
X_08595_ net270 _04283_ net269 VGND VGND VPWR VPWR _04291_ sky130_fd_sc_hd__o21a_1
X_07546_ _02709_ cpuregs\[16\]\[30\] _03570_ VGND VGND VPWR VPWR _00482_ sky130_fd_sc_hd__mux2_1
XTAP_TAPCELL_ROW_81_1635 VGND VPWR sky130_fd_sc_hd__tapvpwrvgnd_1
XFILLER_81_486 VGND VGND VPWR VPWR sky130_fd_sc_hd__fill_1
XTAP_TAPCELL_ROW_81_1624 VGND VPWR sky130_fd_sc_hd__tapvpwrvgnd_1
XFILLER_35_892 VGND VGND VPWR VPWR sky130_fd_sc_hd__decap_4
XFILLER_22_542 VGND VGND VPWR VPWR sky130_fd_sc_hd__fill_2
X_07477_ cpuregs\[15\]\[28\] _02699_ net246 VGND VGND VPWR VPWR _00416_ sky130_fd_sc_hd__mux2_1
X_09216_ is_jalr_addi_slti_sltiu_xori_ori_andi _04746_ _04798_ VGND VGND VPWR VPWR
+ _00914_ sky130_fd_sc_hd__o21a_1
XPHY_EDGE_ROW_40_Right_40 VGND VGND VPWR VPWR sky130_fd_sc_hd__decap_3
X_06428_ decoded_imm\[4\] net197 VGND VGND VPWR VPWR _02862_ sky130_fd_sc_hd__nand2_1
X_09147_ instr_sub _04748_ _04749_ _04774_ VGND VGND VPWR VPWR _00871_ sky130_fd_sc_hd__a22o_1
X_06359_ net171 decoded_imm\[0\] _02768_ _02767_ VGND VGND VPWR VPWR _02795_ sky130_fd_sc_hd__a31o_1
XFILLER_135_444 VGND VGND VPWR VPWR sky130_fd_sc_hd__decap_4
XFILLER_107_113 VGND VGND VPWR VPWR sky130_fd_sc_hd__decap_8
X_09078_ _04738_ _01096_ VGND VGND VPWR VPWR _04739_ sky130_fd_sc_hd__and2b_1
XFILLER_123_617 VGND VGND VPWR VPWR sky130_fd_sc_hd__decap_3
XTAP_TAPCELL_ROW_112_2123 VGND VPWR sky130_fd_sc_hd__tapvpwrvgnd_1
XTAP_TAPCELL_ROW_79_1597 VGND VPWR sky130_fd_sc_hd__tapvpwrvgnd_1
X_08029_ _03801_ _03808_ _03845_ _03848_ VGND VGND VPWR VPWR _03849_ sky130_fd_sc_hd__a31oi_1
XFILLER_123_639 VGND VGND VPWR VPWR sky130_fd_sc_hd__decap_6
XFILLER_104_842 VGND VGND VPWR VPWR sky130_fd_sc_hd__fill_1
XFILLER_104_820 VGND VGND VPWR VPWR sky130_fd_sc_hd__decap_4
XTAP_TAPCELL_ROW_92_1797 VGND VPWR sky130_fd_sc_hd__tapvpwrvgnd_1
X_11040_ clknet_leaf_104_clk _01097_ VGND VGND VPWR VPWR mem_rdata_q\[3\] sky130_fd_sc_hd__dfxtp_1
XFILLER_92_707 VGND VGND VPWR VPWR sky130_fd_sc_hd__fill_1
XFILLER_92_729 VPWR VGND VPWR VGND sky130_ef_sc_hd__decap_12
XFILLER_18_837 VPWR VGND VPWR VGND sky130_ef_sc_hd__decap_12
XFILLER_45_645 VGND VGND VPWR VPWR sky130_fd_sc_hd__fill_1
XFILLER_72_453 VPWR VGND VPWR VGND sky130_ef_sc_hd__decap_12
XTAP_TAPCELL_ROW_123_2296 VGND VPWR sky130_fd_sc_hd__tapvpwrvgnd_1
X_10824_ clknet_leaf_100_clk _00889_ VGND VGND VPWR VPWR decoded_imm_j\[7\] sky130_fd_sc_hd__dfxtp_1
XFILLER_26_881 VPWR VGND VPWR VGND sky130_ef_sc_hd__decap_12
XFILLER_25_391 VGND VGND VPWR VPWR sky130_fd_sc_hd__fill_1
XTAP_TAPCELL_ROW_99_1918 VGND VPWR sky130_fd_sc_hd__tapvpwrvgnd_1
X_10755_ clknet_leaf_133_clk alu_out\[8\] VGND VGND VPWR VPWR alu_out_q\[8\] sky130_fd_sc_hd__dfxtp_1
X_10686_ clknet_leaf_85_clk _00784_ VGND VGND VPWR VPWR net39 sky130_fd_sc_hd__dfxtp_1
XFILLER_138_271 VGND VGND VPWR VPWR sky130_fd_sc_hd__fill_2
XFILLER_5_741 VPWR VGND VPWR VGND sky130_ef_sc_hd__decap_12
XFILLER_58_7 VGND VGND VPWR VPWR sky130_fd_sc_hd__decap_3
XFILLER_4_251 VGND VGND VPWR VPWR sky130_fd_sc_hd__fill_1
X_11307_ clknet_leaf_137_clk _01354_ VGND VGND VPWR VPWR cpuregs\[5\]\[4\] sky130_fd_sc_hd__dfxtp_1
XFILLER_141_447 VGND VGND VPWR VPWR sky130_fd_sc_hd__fill_1
XFILLER_113_138 VGND VGND VPWR VPWR sky130_fd_sc_hd__decap_3
XFILLER_107_680 VPWR VGND VPWR VGND sky130_ef_sc_hd__decap_12
XFILLER_5_785 VPWR VGND VPWR VGND sky130_ef_sc_hd__decap_12
XFILLER_4_262 VPWR VGND VPWR VGND sky130_ef_sc_hd__decap_12
XFILLER_141_458 VGND VGND VPWR VPWR sky130_fd_sc_hd__decap_4
XFILLER_122_650 VPWR VGND VPWR VGND sky130_ef_sc_hd__decap_12
X_11238_ clknet_leaf_13_clk _01285_ VGND VGND VPWR VPWR cpuregs\[3\]\[31\] sky130_fd_sc_hd__dfxtp_1
X_11169_ clknet_leaf_44_clk _01216_ VGND VGND VPWR VPWR cpuregs\[23\]\[26\] sky130_fd_sc_hd__dfxtp_1
XFILLER_122_683 VGND VGND VPWR VPWR sky130_fd_sc_hd__fill_1
XFILLER_95_501 VGND VGND VPWR VPWR sky130_fd_sc_hd__decap_3
XFILLER_67_214 VGND VGND VPWR VPWR sky130_fd_sc_hd__decap_8
XFILLER_121_193 VGND VGND VPWR VPWR sky130_fd_sc_hd__fill_1
XFILLER_110_867 VGND VGND VPWR VPWR sky130_fd_sc_hd__fill_1
XTAP_TAPCELL_ROW_143_2617 VGND VPWR sky130_fd_sc_hd__tapvpwrvgnd_1
XFILLER_67_269 VGND VGND VPWR VPWR sky130_fd_sc_hd__decap_8
X_05730_ _02124_ _02301_ _02302_ _02241_ VGND VGND VPWR VPWR _02303_ sky130_fd_sc_hd__o211a_1
XFILLER_63_420 VGND VGND VPWR VPWR sky130_fd_sc_hd__fill_1
XFILLER_35_111 VGND VGND VPWR VPWR sky130_fd_sc_hd__fill_1
X_05661_ is_compare _02236_ _02237_ _02128_ _02243_ VGND VGND VPWR VPWR _02244_ sky130_fd_sc_hd__a221o_1
X_07400_ cpuregs\[14\]\[18\] _02657_ net247 VGND VGND VPWR VPWR _00342_ sky130_fd_sc_hd__mux2_1
X_08380_ count_cycle\[44\] _04134_ _04136_ VGND VGND VPWR VPWR _00751_ sky130_fd_sc_hd__o21a_1
X_07331_ cpuregs\[21\]\[15\] _02646_ net248 VGND VGND VPWR VPWR _00275_ sky130_fd_sc_hd__mux2_1
X_05592_ _02115_ _02138_ _02171_ _02174_ VGND VGND VPWR VPWR _02175_ sky130_fd_sc_hd__and4b_1
XTAP_TAPCELL_ROW_63_1343 VGND VPWR sky130_fd_sc_hd__tapvpwrvgnd_1
XTAP_TAPCELL_ROW_63_1332 VGND VPWR sky130_fd_sc_hd__tapvpwrvgnd_1
XTAP_TAPCELL_ROW_34_868 VGND VPWR sky130_fd_sc_hd__tapvpwrvgnd_1
XFILLER_50_158 VGND VGND VPWR VPWR sky130_fd_sc_hd__fill_1
XTAP_TAPCELL_ROW_34_879 VGND VPWR sky130_fd_sc_hd__tapvpwrvgnd_1
X_07262_ cpuregs\[2\]\[13\] _02638_ net250 VGND VGND VPWR VPWR _00209_ sky130_fd_sc_hd__mux2_1
X_09001_ _01558_ _04671_ _01559_ VGND VGND VPWR VPWR _04675_ sky130_fd_sc_hd__o21a_1
X_06213_ reg_out\[20\] alu_out_q\[20\] net595 VGND VGND VPWR VPWR _02663_ sky130_fd_sc_hd__mux2_1
X_07193_ cpuregs\[30\]\[11\] _02630_ net252 VGND VGND VPWR VPWR _00143_ sky130_fd_sc_hd__mux2_1
XFILLER_117_444 VGND VGND VPWR VPWR sky130_fd_sc_hd__decap_4
X_06144_ _02607_ cpuregs\[11\]\[6\] _02582_ VGND VGND VPWR VPWR _00043_ sky130_fd_sc_hd__mux2_1
XFILLER_105_617 VPWR VGND VPWR VGND sky130_ef_sc_hd__decap_12
XFILLER_145_797 VPWR VGND VPWR VGND sky130_ef_sc_hd__decap_12
XFILLER_117_488 VPWR VGND VPWR VGND sky130_ef_sc_hd__decap_12
XFILLER_104_105 VGND VGND VPWR VPWR sky130_fd_sc_hd__fill_1
X_06075_ _01559_ _02542_ _02546_ VGND VGND VPWR VPWR _02547_ sky130_fd_sc_hd__a21oi_1
XFILLER_132_469 VGND VGND VPWR VPWR sky130_fd_sc_hd__fill_1
XFILLER_132_458 VGND VGND VPWR VPWR sky130_fd_sc_hd__fill_2
X_05026_ _01586_ _01606_ VGND VGND VPWR VPWR _01649_ sky130_fd_sc_hd__nor2_1
X_09903_ clknet_leaf_118_clk _00038_ VGND VGND VPWR VPWR cpuregs\[11\]\[1\] sky130_fd_sc_hd__dfxtp_1
X_09834_ _02616_ cpuregs\[10\]\[8\] _04876_ VGND VGND VPWR VPWR _01518_ sky130_fd_sc_hd__mux2_1
XFILLER_112_193 VGND VGND VPWR VPWR sky130_fd_sc_hd__decap_3
X_06977_ _00014_ _03385_ _00016_ VGND VGND VPWR VPWR _03391_ sky130_fd_sc_hd__o21a_1
XFILLER_100_377 VPWR VGND VPWR VGND sky130_ef_sc_hd__decap_12
XFILLER_86_589 VGND VGND VPWR VPWR sky130_fd_sc_hd__decap_3
XFILLER_73_206 VGND VGND VPWR VPWR sky130_fd_sc_hd__decap_4
X_09765_ _02603_ cpuregs\[7\]\[5\] _04874_ VGND VGND VPWR VPWR _01419_ sky130_fd_sc_hd__mux2_1
Xrebuffer30 net415 VGND VGND VPWR VPWR net416 sky130_fd_sc_hd__dlymetal6s2s_1
X_08716_ cpuregs\[16\]\[13\] cpuregs\[17\]\[13\] cpuregs\[18\]\[13\] cpuregs\[19\]\[13\]
+ net277 net271 VGND VGND VPWR VPWR _04405_ sky130_fd_sc_hd__mux4_1
X_05928_ mem_wordsize\[1\] net108 net234 mem_wordsize\[2\] VGND VGND VPWR VPWR _02475_
+ sky130_fd_sc_hd__a22o_1
X_09696_ _02590_ cpuregs\[5\]\[2\] _04872_ VGND VGND VPWR VPWR _01352_ sky130_fd_sc_hd__mux2_1
XFILLER_39_494 VGND VGND VPWR VPWR sky130_fd_sc_hd__decap_8
X_05859_ _02082_ _02086_ _02417_ _02084_ VGND VGND VPWR VPWR _02418_ sky130_fd_sc_hd__o31a_1
XFILLER_92_29 VPWR VGND VPWR VGND sky130_ef_sc_hd__decap_12
Xrebuffer63 _04083_ VGND VGND VPWR VPWR net449 sky130_fd_sc_hd__dlygate4sd1_1
Xrebuffer52 net439 VGND VGND VPWR VPWR net438 sky130_fd_sc_hd__dlygate4sd1_1
XFILLER_66_291 VGND VGND VPWR VPWR sky130_fd_sc_hd__fill_1
Xrebuffer41 net428 VGND VGND VPWR VPWR net427 sky130_fd_sc_hd__dlygate4sd1_1
XFILLER_54_442 VPWR VGND VPWR VGND sky130_ef_sc_hd__decap_12
X_08647_ cpuregs\[4\]\[9\] cpuregs\[5\]\[9\] cpuregs\[6\]\[9\] cpuregs\[7\]\[9\] net278
+ net273 VGND VGND VPWR VPWR _04340_ sky130_fd_sc_hd__mux4_1
XFILLER_26_133 VGND VGND VPWR VPWR sky130_fd_sc_hd__decap_6
XFILLER_54_475 VGND VGND VPWR VPWR sky130_fd_sc_hd__fill_1
X_08578_ _04272_ _04273_ _04274_ _00011_ _00010_ VGND VGND VPWR VPWR _04275_ sky130_fd_sc_hd__a221o_1
XFILLER_41_147 VGND VGND VPWR VPWR sky130_fd_sc_hd__decap_6
X_07529_ _02638_ cpuregs\[16\]\[13\] _03570_ VGND VGND VPWR VPWR _00465_ sky130_fd_sc_hd__mux2_1
XTAP_TAPCELL_ROW_12_518 VGND VPWR sky130_fd_sc_hd__tapvpwrvgnd_1
X_10540_ clknet_leaf_65_clk _00670_ VGND VGND VPWR VPWR reg_pc\[26\] sky130_fd_sc_hd__dfxtp_2
XFILLER_10_523 VGND VGND VPWR VPWR sky130_fd_sc_hd__decap_8
XTAP_TAPCELL_ROW_12_529 VGND VPWR sky130_fd_sc_hd__tapvpwrvgnd_1
XFILLER_23_895 VGND VGND VPWR VPWR sky130_fd_sc_hd__fill_1
XFILLER_41_11 VPWR VGND VPWR VGND sky130_ef_sc_hd__decap_12
X_10471_ clknet_leaf_84_clk _00601_ VGND VGND VPWR VPWR count_instr\[20\] sky130_fd_sc_hd__dfxtp_1
XFILLER_41_55 VGND VGND VPWR VPWR sky130_fd_sc_hd__fill_1
XFILLER_41_66 VGND VGND VPWR VPWR sky130_fd_sc_hd__decap_3
XFILLER_108_433 VGND VGND VPWR VPWR sky130_fd_sc_hd__decap_3
XFILLER_10_589 VGND VGND VPWR VPWR sky130_fd_sc_hd__decap_8
XFILLER_123_403 VPWR VGND VPWR VGND sky130_ef_sc_hd__decap_12
XTAP_TAPCELL_ROW_94_1837 VGND VPWR sky130_fd_sc_hd__tapvpwrvgnd_1
Xrebuffer186 net573 VGND VGND VPWR VPWR net572 sky130_fd_sc_hd__dlygate4sd1_1
Xrebuffer197 net584 VGND VGND VPWR VPWR net583 sky130_fd_sc_hd__dlygate4sd1_1
XFILLER_150_233 VGND VGND VPWR VPWR sky130_fd_sc_hd__decap_8
XFILLER_96_309 VPWR VGND VPWR VGND sky130_ef_sc_hd__decap_12
XFILLER_2_755 VGND VGND VPWR VPWR sky130_fd_sc_hd__fill_1
XFILLER_150_277 VGND VGND VPWR VPWR sky130_fd_sc_hd__decap_4
X_11023_ clknet_leaf_42_clk _01085_ VGND VGND VPWR VPWR cpuregs\[19\]\[23\] sky130_fd_sc_hd__dfxtp_1
XFILLER_49_225 VGND VGND VPWR VPWR sky130_fd_sc_hd__decap_4
XFILLER_2_27 VGND VGND VPWR VPWR sky130_fd_sc_hd__fill_1
XTAP_TAPCELL_ROW_125_2325 VGND VPWR sky130_fd_sc_hd__tapvpwrvgnd_1
XFILLER_66_41 VPWR VGND VPWR VGND sky130_ef_sc_hd__decap_12
XTAP_TAPCELL_ROW_125_2336 VGND VPWR sky130_fd_sc_hd__tapvpwrvgnd_1
XFILLER_66_85 VPWR VGND VPWR VGND sky130_ef_sc_hd__decap_12
XFILLER_17_111 VGND VGND VPWR VPWR sky130_fd_sc_hd__fill_1
XFILLER_18_678 VGND VGND VPWR VPWR sky130_fd_sc_hd__fill_1
XFILLER_60_412 VGND VGND VPWR VPWR sky130_fd_sc_hd__decap_8
XFILLER_72_294 VGND VGND VPWR VPWR sky130_fd_sc_hd__fill_1
XFILLER_60_445 VPWR VGND VPWR VGND sky130_ef_sc_hd__decap_12
XFILLER_33_659 VGND VGND VPWR VPWR sky130_fd_sc_hd__decap_4
XTAP_TAPCELL_ROW_103_1977 VGND VPWR sky130_fd_sc_hd__tapvpwrvgnd_1
X_10807_ clknet_leaf_99_clk _00872_ VGND VGND VPWR VPWR instr_sll sky130_fd_sc_hd__dfxtp_1
XTAP_TAPCELL_ROW_31_827 VGND VPWR sky130_fd_sc_hd__tapvpwrvgnd_1
XFILLER_41_670 VGND VGND VPWR VPWR sky130_fd_sc_hd__fill_2
XTAP_TAPCELL_ROW_45_1051 VGND VPWR sky130_fd_sc_hd__tapvpwrvgnd_1
X_10738_ clknet_leaf_57_clk _00835_ VGND VGND VPWR VPWR net224 sky130_fd_sc_hd__dfxtp_2
XPHY_EDGE_ROW_124_Right_124 VGND VGND VPWR VPWR sky130_fd_sc_hd__decap_3
X_10669_ clknet_leaf_65_clk _04897_ VGND VGND VPWR VPWR reg_out\[27\] sky130_fd_sc_hd__dfxtp_1
XTAP_TAPCELL_ROW_153_2790 VGND VPWR sky130_fd_sc_hd__tapvpwrvgnd_1
XFILLER_127_775 VGND VGND VPWR VPWR sky130_fd_sc_hd__decap_8
Xoutput106 net106 VGND VGND VPWR VPWR mem_la_wdata[18] sky130_fd_sc_hd__buf_2
XFILLER_127_797 VPWR VGND VPWR VGND sky130_ef_sc_hd__decap_12
Xoutput117 net117 VGND VGND VPWR VPWR mem_la_wdata[28] sky130_fd_sc_hd__buf_2
Xoutput139 net139 VGND VGND VPWR VPWR mem_wdata[13] sky130_fd_sc_hd__buf_2
Xoutput128 net128 VGND VGND VPWR VPWR mem_la_wdata[9] sky130_fd_sc_hd__buf_2
XFILLER_142_778 VGND VGND VPWR VPWR sky130_fd_sc_hd__fill_1
XFILLER_99_169 VGND VGND VPWR VPWR sky130_fd_sc_hd__decap_8
X_06900_ reg_pc\[21\] _02751_ _03314_ _03316_ _02715_ VGND VGND VPWR VPWR _03317_
+ sky130_fd_sc_hd__a221o_1
X_07880_ _02697_ reg_next_pc\[28\] net596 VGND VGND VPWR VPWR _03716_ sky130_fd_sc_hd__mux2_2
XFILLER_96_865 VGND VGND VPWR VPWR sky130_fd_sc_hd__decap_3
X_06831_ cpuregs\[20\]\[19\] cpuregs\[21\]\[19\] cpuregs\[22\]\[19\] cpuregs\[23\]\[19\]
+ _00012_ _00013_ VGND VGND VPWR VPWR _03250_ sky130_fd_sc_hd__mux4_1
XFILLER_95_375 VPWR VGND VPWR VGND sky130_ef_sc_hd__decap_12
XFILLER_68_589 VGND VGND VPWR VPWR sky130_fd_sc_hd__decap_6
X_09550_ cpuregs\[23\]\[22\] _02675_ _04866_ VGND VGND VPWR VPWR _01212_ sky130_fd_sc_hd__mux2_1
X_06762_ _00015_ _03180_ _03183_ _02735_ VGND VGND VPWR VPWR _03184_ sky130_fd_sc_hd__o211a_1
XFILLER_49_781 VGND VGND VPWR VPWR sky130_fd_sc_hd__decap_3
XTAP_TAPCELL_ROW_39_949 VGND VPWR sky130_fd_sc_hd__tapvpwrvgnd_1
X_08501_ net85 net54 _04208_ VGND VGND VPWR VPWR _00799_ sky130_fd_sc_hd__mux2_1
X_09481_ cpuregs\[24\]\[19\] _02662_ _04864_ VGND VGND VPWR VPWR _01145_ sky130_fd_sc_hd__mux2_1
XFILLER_83_559 VGND VGND VPWR VPWR sky130_fd_sc_hd__fill_1
X_05713_ instr_sub _02286_ _02287_ VGND VGND VPWR VPWR _02288_ sky130_fd_sc_hd__o21a_1
XTAP_TAPCELL_ROW_19_640 VGND VPWR sky130_fd_sc_hd__tapvpwrvgnd_1
X_08432_ count_cycle\[63\] _04167_ _04169_ VGND VGND VPWR VPWR _00770_ sky130_fd_sc_hd__o21ba_1
X_06693_ cpuregs\[12\]\[14\] cpuregs\[13\]\[14\] cpuregs\[14\]\[14\] cpuregs\[15\]\[14\]
+ net265 net260 VGND VGND VPWR VPWR _03117_ sky130_fd_sc_hd__mux4_1
XFILLER_63_261 VGND VGND VPWR VPWR sky130_fd_sc_hd__decap_8
XFILLER_36_464 VGND VGND VPWR VPWR sky130_fd_sc_hd__decap_4
XFILLER_36_486 VGND VGND VPWR VPWR sky130_fd_sc_hd__fill_2
X_05644_ _02075_ _02079_ _02210_ _02225_ VGND VGND VPWR VPWR _02227_ sky130_fd_sc_hd__a31o_1
XFILLER_91_592 VPWR VGND VPWR VGND sky130_ef_sc_hd__decap_12
X_08363_ count_cycle\[38\] _04124_ _01549_ VGND VGND VPWR VPWR _04126_ sky130_fd_sc_hd__a21oi_1
X_05575_ net200 net126 VGND VGND VPWR VPWR _02158_ sky130_fd_sc_hd__nand2_1
XFILLER_149_333 VGND VGND VPWR VPWR sky130_fd_sc_hd__decap_3
X_08294_ count_cycle\[13\] _04078_ count_cycle\[14\] VGND VGND VPWR VPWR _04081_ sky130_fd_sc_hd__a21o_1
X_07314_ latched_rd\[3\] latched_rd\[4\] latched_rd\[2\] VGND VGND VPWR VPWR _03561_
+ sky130_fd_sc_hd__nand3b_4
X_07245_ cpuregs\[13\]\[29\] _02704_ net251 VGND VGND VPWR VPWR _00193_ sky130_fd_sc_hd__mux2_1
XFILLER_145_561 VPWR VGND VPWR VGND sky130_ef_sc_hd__decap_12
X_07176_ cpuregs\[12\]\[30\] _02709_ net253 VGND VGND VPWR VPWR _00130_ sky130_fd_sc_hd__mux2_1
XTAP_TAPCELL_ROW_76_1545 VGND VPWR sky130_fd_sc_hd__tapvpwrvgnd_1
XFILLER_11_69 VPWR VGND VPWR VGND sky130_ef_sc_hd__decap_12
X_06127_ _02593_ cpuregs\[11\]\[3\] _02582_ VGND VGND VPWR VPWR _00040_ sky130_fd_sc_hd__mux2_1
X_06058_ _00009_ _02530_ _02529_ _01559_ VGND VGND VPWR VPWR _02531_ sky130_fd_sc_hd__o211a_1
XFILLER_99_670 VGND VGND VPWR VPWR sky130_fd_sc_hd__fill_2
X_05009_ mem_do_prefetch _01613_ VGND VGND VPWR VPWR _01633_ sky130_fd_sc_hd__or2_1
XFILLER_120_439 VPWR VGND VPWR VGND sky130_ef_sc_hd__decap_12
XFILLER_86_331 VPWR VGND VPWR VGND sky130_ef_sc_hd__decap_12
XFILLER_59_556 VGND VGND VPWR VPWR sky130_fd_sc_hd__decap_4
XFILLER_59_545 VGND VGND VPWR VPWR sky130_fd_sc_hd__decap_3
XFILLER_143_57 VPWR VGND VPWR VGND sky130_ef_sc_hd__decap_12
X_09817_ _02683_ cpuregs\[8\]\[24\] _04875_ VGND VGND VPWR VPWR _01470_ sky130_fd_sc_hd__mux2_1
XFILLER_100_141 VGND VGND VPWR VPWR sky130_fd_sc_hd__fill_2
XFILLER_100_130 VGND VGND VPWR VPWR sky130_fd_sc_hd__fill_1
XFILLER_87_887 VGND VGND VPWR VPWR sky130_fd_sc_hd__fill_2
XFILLER_47_707 VGND VGND VPWR VPWR sky130_fd_sc_hd__fill_2
XFILLER_47_729 VGND VGND VPWR VPWR sky130_fd_sc_hd__fill_1
X_09748_ _02670_ cpuregs\[6\]\[21\] _04873_ VGND VGND VPWR VPWR _01403_ sky130_fd_sc_hd__mux2_1
XTAP_TAPCELL_ROW_107_2044 VGND VPWR sky130_fd_sc_hd__tapvpwrvgnd_1
XFILLER_101_686 VGND VGND VPWR VPWR sky130_fd_sc_hd__decap_4
XFILLER_55_740 VPWR VGND VPWR VGND sky130_ef_sc_hd__decap_12
XFILLER_27_453 VGND VGND VPWR VPWR sky130_fd_sc_hd__fill_1
X_09679_ cpuregs\[4\]\[18\] _02657_ net238 VGND VGND VPWR VPWR _01336_ sky130_fd_sc_hd__mux2_1
XFILLER_82_581 VGND VGND VPWR VPWR sky130_fd_sc_hd__decap_6
XPHY_EDGE_ROW_6_Left_160 VGND VGND VPWR VPWR sky130_fd_sc_hd__decap_3
XFILLER_15_615 VGND VGND VPWR VPWR sky130_fd_sc_hd__fill_1
XFILLER_153_3 VPWR VGND VPWR VGND sky130_ef_sc_hd__decap_12
XTAP_TAPCELL_ROW_120_2255 VGND VPWR sky130_fd_sc_hd__tapvpwrvgnd_1
XTAP_TAPCELL_ROW_120_2244 VGND VPWR sky130_fd_sc_hd__tapvpwrvgnd_1
XFILLER_52_21 VGND VGND VPWR VPWR sky130_fd_sc_hd__decap_6
XFILLER_11_821 VPWR VGND VPWR VGND sky130_ef_sc_hd__decap_12
X_10523_ clknet_leaf_131_clk _00653_ VGND VGND VPWR VPWR reg_pc\[9\] sky130_fd_sc_hd__dfxtp_1
XFILLER_11_865 VPWR VGND VPWR VGND sky130_ef_sc_hd__decap_12
Xinput19 mem_rdata[26] VGND VGND VPWR VPWR net19 sky130_fd_sc_hd__buf_2
XFILLER_124_701 VPWR VGND VPWR VGND sky130_ef_sc_hd__decap_12
X_10454_ clknet_leaf_108_clk _00584_ VGND VGND VPWR VPWR count_instr\[3\] sky130_fd_sc_hd__dfxtp_1
XFILLER_6_357 VGND VGND VPWR VPWR sky130_fd_sc_hd__decap_6
X_10385_ clknet_leaf_17_clk _00515_ VGND VGND VPWR VPWR cpuregs\[25\]\[31\] sky130_fd_sc_hd__dfxtp_1
XFILLER_124_767 VPWR VGND VPWR VGND sky130_ef_sc_hd__decap_12
XFILLER_97_607 VGND VGND VPWR VPWR sky130_fd_sc_hd__decap_6
XFILLER_111_417 VGND VGND VPWR VPWR sky130_fd_sc_hd__fill_1
XFILLER_77_84 VGND VGND VPWR VPWR sky130_fd_sc_hd__fill_1
X_11006_ clknet_leaf_3_clk _01068_ VGND VGND VPWR VPWR cpuregs\[19\]\[6\] sky130_fd_sc_hd__dfxtp_1
XFILLER_93_835 VGND VGND VPWR VPWR sky130_fd_sc_hd__decap_4
XFILLER_92_345 VGND VGND VPWR VPWR sky130_fd_sc_hd__decap_4
XFILLER_65_559 VGND VGND VPWR VPWR sky130_fd_sc_hd__fill_1
XTAP_TAPCELL_ROW_36_908 VGND VPWR sky130_fd_sc_hd__tapvpwrvgnd_1
XFILLER_46_773 VPWR VGND VPWR VGND sky130_ef_sc_hd__decap_12
XFILLER_61_765 VPWR VGND VPWR VGND sky130_ef_sc_hd__decap_12
XFILLER_60_253 VGND VGND VPWR VPWR sky130_fd_sc_hd__decap_3
XTAP_TAPCELL_ROW_138_2538 VGND VPWR sky130_fd_sc_hd__tapvpwrvgnd_1
X_05360_ cpu_state\[6\] _01860_ _01948_ cpu_state\[4\] net186 VGND VGND VPWR VPWR
+ _01952_ sky130_fd_sc_hd__a32o_1
XFILLER_60_297 VGND VGND VPWR VPWR sky130_fd_sc_hd__decap_8
XFILLER_119_539 VGND VGND VPWR VPWR sky130_fd_sc_hd__decap_8
X_05291_ _01886_ _01887_ VGND VGND VPWR VPWR _01888_ sky130_fd_sc_hd__and2b_1
XTAP_TAPCELL_ROW_151_2749 VGND VPWR sky130_fd_sc_hd__tapvpwrvgnd_1
X_07030_ _00014_ _03436_ _01581_ VGND VGND VPWR VPWR _03442_ sky130_fd_sc_hd__o21a_1
XFILLER_127_561 VGND VGND VPWR VPWR sky130_fd_sc_hd__decap_8
XTAP_TAPCELL_ROW_58_1253 VGND VPWR sky130_fd_sc_hd__tapvpwrvgnd_1
XTAP_TAPCELL_ROW_58_1264 VGND VPWR sky130_fd_sc_hd__tapvpwrvgnd_1
XFILLER_142_586 VGND VGND VPWR VPWR sky130_fd_sc_hd__fill_2
X_08981_ net270 _04655_ VGND VGND VPWR VPWR _04656_ sky130_fd_sc_hd__or2_1
XFILLER_114_266 VPWR VGND VPWR VGND sky130_ef_sc_hd__decap_12
XTAP_TAPCELL_ROW_71_1464 VGND VPWR sky130_fd_sc_hd__tapvpwrvgnd_1
X_07932_ _03756_ _03759_ _03576_ VGND VGND VPWR VPWR _03760_ sky130_fd_sc_hd__a21oi_1
X_07863_ _02663_ reg_next_pc\[20\] net597 VGND VGND VPWR VPWR _03707_ sky130_fd_sc_hd__mux2_2
XFILLER_96_673 VGND VGND VPWR VPWR sky130_fd_sc_hd__fill_2
XFILLER_96_662 VGND VGND VPWR VPWR sky130_fd_sc_hd__decap_6
XFILLER_84_813 VPWR VGND VPWR VGND sky130_ef_sc_hd__decap_12
XTAP_TAPCELL_ROW_71_1475 VGND VPWR sky130_fd_sc_hd__tapvpwrvgnd_1
XFILLER_3_81 VPWR VGND VPWR VGND sky130_ef_sc_hd__decap_12
X_06814_ _00015_ _03230_ _03233_ _02735_ VGND VGND VPWR VPWR _03234_ sky130_fd_sc_hd__o211a_1
XFILLER_56_515 VGND VGND VPWR VPWR sky130_fd_sc_hd__fill_1
X_09602_ _02616_ cpuregs\[3\]\[8\] _04868_ VGND VGND VPWR VPWR _01262_ sky130_fd_sc_hd__mux2_1
X_07794_ _03668_ net34 _03667_ VGND VGND VPWR VPWR _00633_ sky130_fd_sc_hd__and3b_1
X_09533_ cpuregs\[23\]\[5\] _02603_ _04866_ VGND VGND VPWR VPWR _01195_ sky130_fd_sc_hd__mux2_1
X_06745_ net183 net254 VGND VGND VPWR VPWR _03167_ sky130_fd_sc_hd__or2_1
XFILLER_36_261 VGND VGND VPWR VPWR sky130_fd_sc_hd__fill_1
XFILLER_37_762 VGND VGND VPWR VPWR sky130_fd_sc_hd__decap_6
X_06676_ _03095_ _03096_ _03097_ _03098_ _01579_ _01581_ VGND VGND VPWR VPWR _03101_
+ sky130_fd_sc_hd__mux4_1
X_09464_ cpuregs\[24\]\[2\] _02590_ net243 VGND VGND VPWR VPWR _01128_ sky130_fd_sc_hd__mux2_1
XFILLER_36_294 VPWR VGND VPWR VGND sky130_ef_sc_hd__decap_12
X_08415_ _04158_ net34 _04157_ VGND VGND VPWR VPWR _00764_ sky130_fd_sc_hd__and3b_1
X_05627_ _02065_ _02209_ _02204_ VGND VGND VPWR VPWR _02210_ sky130_fd_sc_hd__a21o_1
X_09395_ _03554_ _03569_ VGND VGND VPWR VPWR _04862_ sky130_fd_sc_hd__or2_4
XFILLER_40_905 VGND VGND VPWR VPWR sky130_fd_sc_hd__decap_3
X_08346_ _04114_ _04115_ VGND VGND VPWR VPWR _00738_ sky130_fd_sc_hd__nor2_1
XFILLER_138_837 VPWR VGND VPWR VGND sky130_ef_sc_hd__decap_12
XFILLER_20_640 VGND VGND VPWR VPWR sky130_fd_sc_hd__decap_4
XFILLER_20_651 VGND VGND VPWR VPWR sky130_fd_sc_hd__fill_1
X_05558_ _02139_ _02140_ VGND VGND VPWR VPWR _02141_ sky130_fd_sc_hd__or2_1
X_05489_ net192 net224 VGND VGND VPWR VPWR _02072_ sky130_fd_sc_hd__and2_1
X_08277_ count_cycle\[7\] net398 _04070_ VGND VGND VPWR VPWR _00714_ sky130_fd_sc_hd__o21a_1
XTAP_TAPCELL_ROW_22_679 VGND VPWR sky130_fd_sc_hd__tapvpwrvgnd_1
XFILLER_153_818 VGND VGND VPWR VPWR sky130_fd_sc_hd__decap_4
XFILLER_137_358 VGND VGND VPWR VPWR sky130_fd_sc_hd__fill_1
XFILLER_106_701 VGND VGND VPWR VPWR sky130_fd_sc_hd__fill_2
X_07228_ cpuregs\[13\]\[12\] _02633_ net251 VGND VGND VPWR VPWR _00176_ sky130_fd_sc_hd__mux2_1
XFILLER_152_339 VGND VGND VPWR VPWR sky130_fd_sc_hd__fill_1
XFILLER_146_881 VPWR VGND VPWR VGND sky130_ef_sc_hd__decap_12
X_07159_ cpuregs\[12\]\[13\] _02638_ net253 VGND VGND VPWR VPWR _00113_ sky130_fd_sc_hd__mux2_1
XFILLER_3_327 VGND VGND VPWR VPWR sky130_fd_sc_hd__decap_8
XFILLER_3_305 VPWR VGND VPWR VGND sky130_ef_sc_hd__decap_12
XFILLER_133_553 VGND VGND VPWR VPWR sky130_fd_sc_hd__fill_1
XFILLER_3_349 VPWR VGND VPWR VGND sky130_ef_sc_hd__decap_12
XFILLER_121_704 VGND VGND VPWR VPWR sky130_fd_sc_hd__fill_2
X_10170_ clknet_leaf_13_clk _00300_ VGND VGND VPWR VPWR cpuregs\[9\]\[8\] sky130_fd_sc_hd__dfxtp_1
XFILLER_121_737 VGND VGND VPWR VPWR sky130_fd_sc_hd__decap_3
XFILLER_120_214 VGND VGND VPWR VPWR sky130_fd_sc_hd__fill_2
XFILLER_78_139 VGND VGND VPWR VPWR sky130_fd_sc_hd__fill_1
XFILLER_47_32 VPWR VGND VPWR VGND sky130_ef_sc_hd__decap_12
XTAP_TAPCELL_ROW_89_1758 VGND VPWR sky130_fd_sc_hd__tapvpwrvgnd_1
XTAP_TAPCELL_ROW_2_371 VGND VPWR sky130_fd_sc_hd__tapvpwrvgnd_1
XTAP_TAPCELL_ROW_2_360 VGND VPWR sky130_fd_sc_hd__tapvpwrvgnd_1
XFILLER_103_93 VGND VGND VPWR VPWR sky130_fd_sc_hd__decap_3
XFILLER_63_20 VPWR VGND VPWR VGND sky130_ef_sc_hd__decap_12
XFILLER_27_294 VPWR VGND VPWR VGND sky130_ef_sc_hd__decap_12
XPHY_EDGE_ROW_69_Right_69 VGND VGND VPWR VPWR sky130_fd_sc_hd__decap_3
XFILLER_15_478 VGND VGND VPWR VPWR sky130_fd_sc_hd__fill_1
XFILLER_42_253 VGND VGND VPWR VPWR sky130_fd_sc_hd__decap_6
XTAP_TAPCELL_ROW_100_1936 VGND VPWR sky130_fd_sc_hd__tapvpwrvgnd_1
XTAP_TAPCELL_ROW_100_1925 VGND VPWR sky130_fd_sc_hd__tapvpwrvgnd_1
XFILLER_8_15 VPWR VGND VPWR VGND sky130_ef_sc_hd__decap_12
XTAP_TAPCELL_ROW_42_1010 VGND VPWR sky130_fd_sc_hd__tapvpwrvgnd_1
XFILLER_11_673 VGND VGND VPWR VPWR sky130_fd_sc_hd__decap_8
XFILLER_7_633 VGND VGND VPWR VPWR sky130_fd_sc_hd__decap_4
XTAP_TAPCELL_ROW_41_988 VGND VPWR sky130_fd_sc_hd__tapvpwrvgnd_1
X_11486_ clknet_leaf_72_clk _01530_ VGND VGND VPWR VPWR cpuregs\[10\]\[20\] sky130_fd_sc_hd__dfxtp_1
X_10506_ clknet_leaf_81_clk _00636_ VGND VGND VPWR VPWR count_instr\[55\] sky130_fd_sc_hd__dfxtp_1
XFILLER_6_121 VPWR VGND VPWR VGND sky130_ef_sc_hd__decap_12
X_10437_ clknet_leaf_71_clk _00567_ VGND VGND VPWR VPWR cpuregs\[17\]\[19\] sky130_fd_sc_hd__dfxtp_1
XTAP_TAPCELL_ROW_133_2457 VGND VPWR sky130_fd_sc_hd__tapvpwrvgnd_1
XFILLER_109_561 VGND VGND VPWR VPWR sky130_fd_sc_hd__decap_6
XFILLER_6_165 VPWR VGND VPWR VGND sky130_ef_sc_hd__decap_12
XFILLER_124_531 VGND VGND VPWR VPWR sky130_fd_sc_hd__fill_1
XPHY_EDGE_ROW_78_Right_78 VGND VGND VPWR VPWR sky130_fd_sc_hd__decap_3
XFILLER_124_586 VGND VGND VPWR VPWR sky130_fd_sc_hd__fill_2
X_10368_ clknet_leaf_26_clk _00498_ VGND VGND VPWR VPWR cpuregs\[25\]\[14\] sky130_fd_sc_hd__dfxtp_1
XFILLER_40_7 VPWR VGND VPWR VGND sky130_ef_sc_hd__decap_12
XFILLER_88_83 VGND VGND VPWR VPWR sky130_fd_sc_hd__fill_1
X_10299_ clknet_leaf_146_clk _00429_ VGND VGND VPWR VPWR cpuregs\[26\]\[9\] sky130_fd_sc_hd__dfxtp_1
XFILLER_66_813 VGND VGND VPWR VPWR sky130_fd_sc_hd__fill_1
XTAP_TAPCELL_ROW_53_1183 VGND VPWR sky130_fd_sc_hd__tapvpwrvgnd_1
XTAP_TAPCELL_ROW_53_1172 VGND VPWR sky130_fd_sc_hd__tapvpwrvgnd_1
XFILLER_77_161 VGND VGND VPWR VPWR sky130_fd_sc_hd__decap_6
XPHY_EDGE_ROW_69_Left_223 VGND VGND VPWR VPWR sky130_fd_sc_hd__decap_3
XFILLER_65_312 VGND VGND VPWR VPWR sky130_fd_sc_hd__fill_2
XFILLER_38_537 VGND VGND VPWR VPWR sky130_fd_sc_hd__fill_1
XTAP_TAPCELL_ROW_0_308 VGND VPWR sky130_fd_sc_hd__tapvpwrvgnd_1
XTAP_TAPCELL_ROW_0_319 VGND VPWR sky130_fd_sc_hd__tapvpwrvgnd_1
XFILLER_92_197 VPWR VGND VPWR VGND sky130_ef_sc_hd__decap_12
XFILLER_92_186 VGND VGND VPWR VPWR sky130_fd_sc_hd__decap_8
XPHY_EDGE_ROW_87_Right_87 VGND VGND VPWR VPWR sky130_fd_sc_hd__decap_3
XFILLER_74_890 VGND VGND VPWR VPWR sky130_fd_sc_hd__decap_6
X_06530_ _01641_ _02879_ _02959_ _02714_ VGND VGND VPWR VPWR _02960_ sky130_fd_sc_hd__a31o_1
XTAP_TAPCELL_ROW_29_790 VGND VPWR sky130_fd_sc_hd__tapvpwrvgnd_1
XFILLER_61_551 VGND VGND VPWR VPWR sky130_fd_sc_hd__decap_8
X_06461_ _01581_ _02893_ _02735_ VGND VGND VPWR VPWR _02894_ sky130_fd_sc_hd__o21a_1
X_08200_ net34 _04006_ VGND VGND VPWR VPWR _00701_ sky130_fd_sc_hd__and2_1
X_05412_ cpu_state\[6\] _01860_ _01996_ cpu_state\[4\] net190 VGND VGND VPWR VPWR
+ _02000_ sky130_fd_sc_hd__a32o_1
XPHY_EDGE_ROW_78_Left_232 VGND VGND VPWR VPWR sky130_fd_sc_hd__decap_3
X_09180_ mem_rdata_q\[26\] net19 _01609_ VGND VGND VPWR VPWR _01120_ sky130_fd_sc_hd__mux2_1
X_06392_ cpuregs\[0\]\[3\] cpuregs\[1\]\[3\] net268 VGND VGND VPWR VPWR _02827_ sky130_fd_sc_hd__mux2_1
X_05343_ _01934_ _01935_ VGND VGND VPWR VPWR _01936_ sky130_fd_sc_hd__nor2_1
X_08131_ _03894_ _03897_ _03942_ VGND VGND VPWR VPWR _03943_ sky130_fd_sc_hd__a21oi_2
X_05274_ count_cycle\[16\] _01588_ VGND VGND VPWR VPWR _01873_ sky130_fd_sc_hd__or2_1
X_08062_ decoded_imm_j\[16\] _03703_ VGND VGND VPWR VPWR _03879_ sky130_fd_sc_hd__or2_1
Xpicorv32_320 VGND VGND VPWR VPWR picorv32_320/HI pcpi_insn[3] sky130_fd_sc_hd__conb_1
XFILLER_146_177 VPWR VGND VPWR VGND sky130_ef_sc_hd__decap_12
XFILLER_134_306 VGND VGND VPWR VPWR sky130_fd_sc_hd__fill_2
XFILLER_128_881 VPWR VGND VPWR VGND sky130_ef_sc_hd__decap_12
X_07013_ _03398_ _03401_ _03424_ VGND VGND VPWR VPWR _03425_ sky130_fd_sc_hd__a21oi_1
XPHY_EDGE_ROW_96_Right_96 VGND VGND VPWR VPWR sky130_fd_sc_hd__decap_3
Xpicorv32_353 VGND VGND VPWR VPWR picorv32_353/HI trace_data[3] sky130_fd_sc_hd__conb_1
Xpicorv32_331 VGND VGND VPWR VPWR picorv32_331/HI pcpi_insn[14] sky130_fd_sc_hd__conb_1
XFILLER_108_49 VGND VGND VPWR VPWR sky130_fd_sc_hd__decap_3
XFILLER_108_27 VGND VGND VPWR VPWR sky130_fd_sc_hd__fill_1
XTAP_TAPCELL_ROW_73_1504 VGND VPWR sky130_fd_sc_hd__tapvpwrvgnd_1
XFILLER_1_809 VPWR VGND VPWR VGND sky130_ef_sc_hd__decap_12
Xpicorv32_342 VGND VGND VPWR VPWR picorv32_342/HI pcpi_insn[25] sky130_fd_sc_hd__conb_1
Xpicorv32_386 VGND VGND VPWR VPWR picorv32_386/HI trace_valid sky130_fd_sc_hd__conb_1
Xpicorv32_375 VGND VGND VPWR VPWR picorv32_375/HI trace_data[25] sky130_fd_sc_hd__conb_1
XFILLER_143_895 VGND VGND VPWR VPWR sky130_fd_sc_hd__fill_1
Xpicorv32_364 VGND VGND VPWR VPWR picorv32_364/HI trace_data[14] sky130_fd_sc_hd__conb_1
X_08964_ _04634_ _04635_ _01558_ VGND VGND VPWR VPWR _04640_ sky130_fd_sc_hd__mux2_1
XFILLER_124_15 VPWR VGND VPWR VGND sky130_ef_sc_hd__decap_12
XPHY_EDGE_ROW_87_Left_241 VGND VGND VPWR VPWR sky130_fd_sc_hd__decap_3
X_07915_ decoded_imm_j\[4\] _03691_ VGND VGND VPWR VPWR _03744_ sky130_fd_sc_hd__nand2_1
X_08895_ net217 _01585_ _04573_ _04574_ VGND VGND VPWR VPWR _00828_ sky130_fd_sc_hd__o22a_1
XFILLER_84_19 VGND VGND VPWR VPWR sky130_fd_sc_hd__decap_8
XFILLER_69_673 VGND VGND VPWR VPWR sky130_fd_sc_hd__fill_1
XFILLER_68_150 VGND VGND VPWR VPWR sky130_fd_sc_hd__decap_8
XFILLER_29_515 VGND VGND VPWR VPWR sky130_fd_sc_hd__decap_6
XFILLER_84_654 VGND VGND VPWR VPWR sky130_fd_sc_hd__fill_2
X_07846_ reg_pc\[11\] _01624_ _01628_ _03698_ VGND VGND VPWR VPWR _00655_ sky130_fd_sc_hd__a22o_1
XFILLER_57_857 VGND VGND VPWR VPWR sky130_fd_sc_hd__fill_1
XTAP_TAPCELL_ROW_104_2003 VGND VPWR sky130_fd_sc_hd__tapvpwrvgnd_1
X_07777_ _03654_ count_instr\[45\] count_instr\[46\] VGND VGND VPWR VPWR _03658_ sky130_fd_sc_hd__and3_1
X_04989_ instr_lhu instr_lh _01616_ VGND VGND VPWR VPWR _01617_ sky130_fd_sc_hd__nor3_1
X_09516_ cpuregs\[31\]\[21\] _02670_ _04865_ VGND VGND VPWR VPWR _01179_ sky130_fd_sc_hd__mux2_1
XFILLER_71_337 VGND VGND VPWR VPWR sky130_fd_sc_hd__fill_2
X_06728_ _03147_ _03148_ _01579_ VGND VGND VPWR VPWR _03151_ sky130_fd_sc_hd__mux2_1
XFILLER_17_57 VPWR VGND VPWR VGND sky130_ef_sc_hd__decap_12
X_09447_ _02657_ cpuregs\[19\]\[18\] _04863_ VGND VGND VPWR VPWR _01080_ sky130_fd_sc_hd__mux2_1
XTAP_TAPCELL_ROW_84_1677 VGND VPWR sky130_fd_sc_hd__tapvpwrvgnd_1
XFILLER_24_253 VGND VGND VPWR VPWR sky130_fd_sc_hd__fill_1
XPHY_EDGE_ROW_96_Left_250 VGND VGND VPWR VPWR sky130_fd_sc_hd__decap_3
X_06659_ _03082_ _03083_ VGND VGND VPWR VPWR _03084_ sky130_fd_sc_hd__nand2_1
X_09378_ decoded_imm\[7\] _04746_ _04851_ VGND VGND VPWR VPWR _01023_ sky130_fd_sc_hd__o21a_1
XFILLER_8_419 VGND VGND VPWR VPWR sky130_fd_sc_hd__fill_1
XFILLER_40_757 VPWR VGND VPWR VGND sky130_ef_sc_hd__decap_12
XFILLER_137_122 VPWR VGND VPWR VGND sky130_ef_sc_hd__decap_12
X_08329_ count_cycle\[25\] _04102_ net34 VGND VGND VPWR VPWR _04105_ sky130_fd_sc_hd__o21ai_1
X_11340_ clknet_leaf_121_clk _01384_ VGND VGND VPWR VPWR cpuregs\[6\]\[2\] sky130_fd_sc_hd__dfxtp_1
XFILLER_20_481 VGND VGND VPWR VPWR sky130_fd_sc_hd__fill_1
XFILLER_153_615 VGND VGND VPWR VPWR sky130_fd_sc_hd__fill_1
XFILLER_137_177 VGND VGND VPWR VPWR sky130_fd_sc_hd__fill_1
XFILLER_116_3 VGND VGND VPWR VPWR sky130_fd_sc_hd__decap_3
XTAP_TAPCELL_ROW_115_2176 VGND VPWR sky130_fd_sc_hd__tapvpwrvgnd_1
XTAP_TAPCELL_ROW_115_2165 VGND VPWR sky130_fd_sc_hd__tapvpwrvgnd_1
XFILLER_3_113 VPWR VGND VPWR VGND sky130_ef_sc_hd__decap_12
X_11271_ clknet_leaf_124_clk _01318_ VGND VGND VPWR VPWR cpuregs\[4\]\[0\] sky130_fd_sc_hd__dfxtp_1
XFILLER_140_309 VGND VGND VPWR VPWR sky130_fd_sc_hd__decap_8
X_10222_ clknet_leaf_35_clk _00352_ VGND VGND VPWR VPWR cpuregs\[14\]\[28\] sky130_fd_sc_hd__dfxtp_1
XFILLER_121_501 VGND VGND VPWR VPWR sky130_fd_sc_hd__decap_3
XFILLER_79_415 VGND VGND VPWR VPWR sky130_fd_sc_hd__fill_1
XFILLER_4_669 VPWR VGND VPWR VGND sky130_ef_sc_hd__decap_12
X_10153_ clknet_leaf_52_clk _00283_ VGND VGND VPWR VPWR cpuregs\[21\]\[23\] sky130_fd_sc_hd__dfxtp_1
XFILLER_58_20 VGND VGND VPWR VPWR sky130_fd_sc_hd__decap_8
XTAP_TAPCELL_ROW_7_441 VGND VPWR sky130_fd_sc_hd__tapvpwrvgnd_1
XFILLER_66_109 VPWR VGND VPWR VGND sky130_ef_sc_hd__decap_12
XFILLER_0_853 VGND VGND VPWR VPWR sky130_fd_sc_hd__decap_4
XFILLER_0_875 VGND VGND VPWR VPWR sky130_fd_sc_hd__fill_1
X_10084_ clknet_leaf_23_clk _00214_ VGND VGND VPWR VPWR cpuregs\[2\]\[18\] sky130_fd_sc_hd__dfxtp_1
XFILLER_102_781 VGND VGND VPWR VPWR sky130_fd_sc_hd__fill_2
XFILLER_48_813 VGND VGND VPWR VPWR sky130_fd_sc_hd__fill_2
XFILLER_74_41 VPWR VGND VPWR VGND sky130_ef_sc_hd__decap_12
XFILLER_74_197 VGND VGND VPWR VPWR sky130_fd_sc_hd__decap_6
X_10986_ clknet_leaf_42_clk _01048_ VGND VGND VPWR VPWR cpuregs\[18\]\[18\] sky130_fd_sc_hd__dfxtp_1
XFILLER_70_381 VGND VGND VPWR VPWR sky130_fd_sc_hd__fill_1
X_11607_ net119 VGND VGND VPWR VPWR net225 sky130_fd_sc_hd__clkbuf_1
XFILLER_7_430 VGND VGND VPWR VPWR sky130_fd_sc_hd__fill_2
XFILLER_144_626 VGND VGND VPWR VPWR sky130_fd_sc_hd__fill_2
XFILLER_7_485 VGND VGND VPWR VPWR sky130_fd_sc_hd__fill_1
X_11469_ clknet_leaf_139_clk _01513_ VGND VGND VPWR VPWR cpuregs\[10\]\[3\] sky130_fd_sc_hd__dfxtp_1
XFILLER_143_169 VGND VGND VPWR VPWR sky130_fd_sc_hd__fill_1
XTAP_TAPCELL_ROW_55_1212 VGND VPWR sky130_fd_sc_hd__tapvpwrvgnd_1
XFILLER_152_692 VGND VGND VPWR VPWR sky130_fd_sc_hd__decap_8
XFILLER_125_895 VGND VGND VPWR VPWR sky130_fd_sc_hd__fill_1
XFILLER_97_212 VGND VGND VPWR VPWR sky130_fd_sc_hd__fill_1
XFILLER_31_3 VPWR VGND VPWR VGND sky130_ef_sc_hd__decap_12
XFILLER_112_545 VPWR VGND VPWR VGND sky130_ef_sc_hd__decap_12
XFILLER_97_289 VGND VGND VPWR VPWR sky130_fd_sc_hd__fill_1
XFILLER_97_278 VGND VGND VPWR VPWR sky130_fd_sc_hd__fill_2
X_07700_ count_instr\[18\] count_instr\[17\] _03605_ VGND VGND VPWR VPWR _03609_ sky130_fd_sc_hd__and3_1
XFILLER_39_813 VGND VGND VPWR VPWR sky130_fd_sc_hd__decap_6
XFILLER_39_835 VGND VGND VPWR VPWR sky130_fd_sc_hd__decap_4
X_05961_ reg_out\[3\] reg_next_pc\[3\] net596 VGND VGND VPWR VPWR _02484_ sky130_fd_sc_hd__mux2_1
X_05892_ _02054_ _02064_ _02433_ _02446_ _02063_ VGND VGND VPWR VPWR _02447_ sky130_fd_sc_hd__o221a_1
XFILLER_93_440 VGND VGND VPWR VPWR sky130_fd_sc_hd__decap_8
X_04912_ latched_is_lb VGND VGND VPWR VPWR _01545_ sky130_fd_sc_hd__inv_2
X_08680_ cpuregs\[12\]\[11\] cpuregs\[13\]\[11\] cpuregs\[14\]\[11\] cpuregs\[15\]\[11\]
+ net279 _00008_ VGND VGND VPWR VPWR _04371_ sky130_fd_sc_hd__mux4_1
XFILLER_38_345 VGND VGND VPWR VPWR sky130_fd_sc_hd__fill_2
XFILLER_39_857 VPWR VGND VPWR VGND sky130_ef_sc_hd__decap_12
X_07631_ _02646_ cpuregs\[17\]\[15\] _03574_ VGND VGND VPWR VPWR _00563_ sky130_fd_sc_hd__mux2_1
XFILLER_81_602 VGND VGND VPWR VPWR sky130_fd_sc_hd__fill_2
XFILLER_66_698 VGND VGND VPWR VPWR sky130_fd_sc_hd__fill_2
X_07562_ cpuregs\[25\]\[13\] _02638_ _03571_ VGND VGND VPWR VPWR _00497_ sky130_fd_sc_hd__mux2_1
XFILLER_53_337 VGND VGND VPWR VPWR sky130_fd_sc_hd__decap_3
X_09301_ net159 net121 _04206_ VGND VGND VPWR VPWR _00987_ sky130_fd_sc_hd__mux2_1
X_06513_ _02935_ _02936_ _01579_ VGND VGND VPWR VPWR _02944_ sky130_fd_sc_hd__mux2_1
XTAP_TAPCELL_ROW_24_708 VGND VPWR sky130_fd_sc_hd__tapvpwrvgnd_1
XTAP_TAPCELL_ROW_66_1385 VGND VPWR sky130_fd_sc_hd__tapvpwrvgnd_1
X_07493_ cpuregs\[26\]\[11\] _02630_ _03568_ VGND VGND VPWR VPWR _00431_ sky130_fd_sc_hd__mux2_1
XTAP_TAPCELL_ROW_24_719 VGND VPWR sky130_fd_sc_hd__tapvpwrvgnd_1
X_09232_ cpuregs\[1\]\[11\] _02630_ net244 VGND VGND VPWR VPWR _00929_ sky130_fd_sc_hd__mux2_1
X_06444_ _02862_ _02874_ VGND VGND VPWR VPWR _02877_ sky130_fd_sc_hd__or2_1
X_09163_ mem_rdata_q\[3\] mem_rdata_q\[4\] mem_rdata_q\[5\] mem_rdata_q\[6\] VGND
+ VGND VPWR VPWR _04781_ sky130_fd_sc_hd__and4b_1
X_06375_ cpuregs\[24\]\[3\] cpuregs\[25\]\[3\] net268 VGND VGND VPWR VPWR _02810_
+ sky130_fd_sc_hd__mux2_1
XFILLER_21_278 VGND VGND VPWR VPWR sky130_fd_sc_hd__fill_2
XFILLER_119_133 VGND VGND VPWR VPWR sky130_fd_sc_hd__fill_2
X_05326_ cpu_state\[3\] _01913_ _01914_ _01920_ VGND VGND VPWR VPWR _04890_ sky130_fd_sc_hd__a31o_1
X_08114_ decoded_imm_j\[20\] _03707_ VGND VGND VPWR VPWR _03927_ sky130_fd_sc_hd__or2_1
X_09094_ mem_rdata_q\[14\] mem_rdata_q\[13\] mem_rdata_q\[12\] VGND VGND VPWR VPWR
+ _04749_ sky130_fd_sc_hd__nor3_2
XFILLER_134_136 VGND VGND VPWR VPWR sky130_fd_sc_hd__decap_4
X_08045_ instr_jal _03862_ _03863_ VGND VGND VPWR VPWR _03864_ sky130_fd_sc_hd__or3_1
X_05257_ _01856_ VGND VGND VPWR VPWR _01857_ sky130_fd_sc_hd__inv_2
XFILLER_143_670 VGND VGND VPWR VPWR sky130_fd_sc_hd__fill_2
XFILLER_122_309 VGND VGND VPWR VPWR sky130_fd_sc_hd__decap_6
XFILLER_116_862 VGND VGND VPWR VPWR sky130_fd_sc_hd__decap_6
XFILLER_89_702 VGND VGND VPWR VPWR sky130_fd_sc_hd__decap_4
X_05188_ net2 _01666_ _01667_ net19 _01772_ VGND VGND VPWR VPWR _01793_ sky130_fd_sc_hd__o221a_1
XFILLER_131_821 VPWR VGND VPWR VGND sky130_ef_sc_hd__decap_12
XFILLER_115_372 VPWR VGND VPWR VGND sky130_ef_sc_hd__decap_12
XFILLER_89_746 VGND VGND VPWR VPWR sky130_fd_sc_hd__fill_1
XFILLER_135_69 VGND VGND VPWR VPWR sky130_fd_sc_hd__decap_8
X_09996_ clknet_leaf_44_clk _00126_ VGND VGND VPWR VPWR cpuregs\[12\]\[26\] sky130_fd_sc_hd__dfxtp_1
XFILLER_131_865 VPWR VGND VPWR VGND sky130_ef_sc_hd__decap_12
XTAP_TAPCELL_ROW_110_2084 VGND VPWR sky130_fd_sc_hd__tapvpwrvgnd_1
XFILLER_103_556 VGND VGND VPWR VPWR sky130_fd_sc_hd__decap_4
XTAP_TAPCELL_ROW_4_400 VGND VPWR sky130_fd_sc_hd__tapvpwrvgnd_1
X_08947_ _04611_ _04612_ net270 VGND VGND VPWR VPWR _04624_ sky130_fd_sc_hd__mux2_1
XTAP_TAPCELL_ROW_110_2095 VGND VPWR sky130_fd_sc_hd__tapvpwrvgnd_1
XFILLER_103_589 VGND VGND VPWR VPWR sky130_fd_sc_hd__fill_1
XFILLER_76_418 VGND VGND VPWR VPWR sky130_fd_sc_hd__fill_2
X_08878_ decoded_imm\[21\] _01654_ _01586_ VGND VGND VPWR VPWR _04559_ sky130_fd_sc_hd__a21o_1
XFILLER_29_334 VGND VGND VPWR VPWR sky130_fd_sc_hd__fill_2
XFILLER_151_57 VPWR VGND VPWR VGND sky130_ef_sc_hd__decap_12
XTAP_TAPCELL_ROW_86_1706 VGND VPWR sky130_fd_sc_hd__tapvpwrvgnd_1
XFILLER_84_473 VGND VGND VPWR VPWR sky130_fd_sc_hd__decap_3
XFILLER_84_451 VGND VGND VPWR VPWR sky130_fd_sc_hd__decap_3
XFILLER_72_613 VPWR VGND VPWR VGND sky130_ef_sc_hd__decap_12
XFILLER_56_153 VGND VGND VPWR VPWR sky130_fd_sc_hd__fill_2
X_07829_ _01628_ _03689_ VGND VGND VPWR VPWR _03690_ sky130_fd_sc_hd__nand2_1
XFILLER_45_827 VGND VGND VPWR VPWR sky130_fd_sc_hd__fill_1
X_10840_ clknet_leaf_88_clk _00905_ VGND VGND VPWR VPWR decoded_imm_j\[17\] sky130_fd_sc_hd__dfxtp_1
XFILLER_56_197 VGND VGND VPWR VPWR sky130_fd_sc_hd__fill_2
XFILLER_25_551 VGND VGND VPWR VPWR sky130_fd_sc_hd__decap_8
X_10771_ clknet_leaf_50_clk alu_out\[24\] VGND VGND VPWR VPWR alu_out_q\[24\] sky130_fd_sc_hd__dfxtp_1
XFILLER_13_724 VGND VGND VPWR VPWR sky130_fd_sc_hd__decap_4
Xclkbuf_leaf_145_clk clknet_4_2_0_clk VGND VGND VPWR VPWR clknet_leaf_145_clk sky130_fd_sc_hd__clkbuf_8
XFILLER_12_245 VGND VGND VPWR VPWR sky130_fd_sc_hd__decap_6
XTAP_TAPCELL_ROW_117_2205 VGND VPWR sky130_fd_sc_hd__tapvpwrvgnd_1
XFILLER_40_587 VGND VGND VPWR VPWR sky130_fd_sc_hd__fill_1
XFILLER_100_83 VGND VGND VPWR VPWR sky130_fd_sc_hd__fill_1
XFILLER_60_65 VGND VGND VPWR VPWR sky130_fd_sc_hd__fill_2
XFILLER_40_598 VGND VGND VPWR VPWR sky130_fd_sc_hd__fill_2
XFILLER_138_486 VGND VGND VPWR VPWR sky130_fd_sc_hd__decap_8
XFILLER_138_475 VGND VGND VPWR VPWR sky130_fd_sc_hd__fill_1
XFILLER_153_434 VGND VGND VPWR VPWR sky130_fd_sc_hd__decap_3
X_11323_ clknet_leaf_76_clk _01370_ VGND VGND VPWR VPWR cpuregs\[5\]\[20\] sky130_fd_sc_hd__dfxtp_1
XTAP_TAPCELL_ROW_130_2416 VGND VPWR sky130_fd_sc_hd__tapvpwrvgnd_1
XTAP_TAPCELL_ROW_130_2405 VGND VPWR sky130_fd_sc_hd__tapvpwrvgnd_1
XTAP_TAPCELL_ROW_97_1879 VGND VPWR sky130_fd_sc_hd__tapvpwrvgnd_1
XFILLER_5_27 VPWR VGND VPWR VGND sky130_ef_sc_hd__decap_12
XFILLER_4_433 VPWR VGND VPWR VGND sky130_ef_sc_hd__decap_12
Xclkbuf_4_0_0_clk clknet_0_clk VGND VGND VPWR VPWR clknet_4_0_0_clk sky130_fd_sc_hd__clkbuf_8
XFILLER_141_629 VGND VGND VPWR VPWR sky130_fd_sc_hd__decap_3
XFILLER_125_169 VGND VGND VPWR VPWR sky130_fd_sc_hd__decap_3
XFILLER_107_862 VPWR VGND VPWR VGND sky130_ef_sc_hd__decap_12
X_11254_ clknet_leaf_20_clk _01301_ VGND VGND VPWR VPWR cpuregs\[22\]\[15\] sky130_fd_sc_hd__dfxtp_1
X_10205_ clknet_leaf_147_clk _00335_ VGND VGND VPWR VPWR cpuregs\[14\]\[11\] sky130_fd_sc_hd__dfxtp_1
XFILLER_121_353 VGND VGND VPWR VPWR sky130_fd_sc_hd__fill_2
X_11185_ clknet_leaf_14_clk _01232_ VGND VGND VPWR VPWR cpuregs\[29\]\[10\] sky130_fd_sc_hd__dfxtp_1
XFILLER_95_727 VGND VGND VPWR VPWR sky130_fd_sc_hd__fill_1
XTAP_TAPCELL_ROW_50_1131 VGND VPWR sky130_fd_sc_hd__tapvpwrvgnd_1
XFILLER_0_650 VGND VGND VPWR VPWR sky130_fd_sc_hd__decap_4
X_10136_ clknet_leaf_0_clk _00266_ VGND VGND VPWR VPWR cpuregs\[21\]\[6\] sky130_fd_sc_hd__dfxtp_1
XTAP_TAPCELL_ROW_128_2378 VGND VPWR sky130_fd_sc_hd__tapvpwrvgnd_1
X_10067_ clknet_leaf_115_clk _00197_ VGND VGND VPWR VPWR cpuregs\[2\]\[1\] sky130_fd_sc_hd__dfxtp_1
XFILLER_63_613 VGND VGND VPWR VPWR sky130_fd_sc_hd__decap_3
XFILLER_48_687 VGND VGND VPWR VPWR sky130_fd_sc_hd__fill_1
XFILLER_36_805 VGND VGND VPWR VPWR sky130_fd_sc_hd__decap_6
XFILLER_75_484 VPWR VGND VPWR VGND sky130_ef_sc_hd__decap_12
XFILLER_36_849 VPWR VGND VPWR VGND sky130_ef_sc_hd__decap_12
XTAP_TAPCELL_ROW_141_2589 VGND VPWR sky130_fd_sc_hd__tapvpwrvgnd_1
X_10969_ clknet_leaf_116_clk _01031_ VGND VGND VPWR VPWR cpuregs\[18\]\[1\] sky130_fd_sc_hd__dfxtp_1
Xclkbuf_leaf_136_clk clknet_4_3_0_clk VGND VGND VPWR VPWR clknet_leaf_136_clk sky130_fd_sc_hd__clkbuf_8
XFILLER_44_893 VPWR VGND VPWR VGND sky130_ef_sc_hd__decap_12
XTAP_TAPCELL_ROW_48_1093 VGND VPWR sky130_fd_sc_hd__tapvpwrvgnd_1
XFILLER_148_217 VGND VGND VPWR VPWR sky130_fd_sc_hd__fill_1
X_06160_ _02583_ _02617_ _02618_ _02620_ VGND VGND VPWR VPWR _02621_ sky130_fd_sc_hd__a22o_4
XFILLER_117_659 VPWR VGND VPWR VGND sky130_ef_sc_hd__decap_12
X_05111_ net4 net21 net608 VGND VGND VPWR VPWR _01722_ sky130_fd_sc_hd__mux2_1
X_06091_ _02560_ _02561_ _01558_ VGND VGND VPWR VPWR _02562_ sky130_fd_sc_hd__mux2_1
XFILLER_104_309 VPWR VGND VPWR VGND sky130_ef_sc_hd__decap_12
X_05042_ _01637_ _01640_ cpu_state\[4\] VGND VGND VPWR VPWR _01661_ sky130_fd_sc_hd__o21ai_1
X_09850_ _02683_ cpuregs\[10\]\[24\] _04876_ VGND VGND VPWR VPWR _01534_ sky130_fd_sc_hd__mux2_1
XFILLER_113_865 VPWR VGND VPWR VGND sky130_ef_sc_hd__decap_12
X_09781_ _02670_ cpuregs\[7\]\[21\] _04874_ VGND VGND VPWR VPWR _01435_ sky130_fd_sc_hd__mux2_1
X_06993_ net184 _02721_ _02744_ _03405_ VGND VGND VPWR VPWR _03406_ sky130_fd_sc_hd__o211a_1
X_08801_ _04483_ _04484_ _01558_ VGND VGND VPWR VPWR _04486_ sky130_fd_sc_hd__mux2_1
XFILLER_100_504 VPWR VGND VPWR VGND sky130_ef_sc_hd__decap_12
XFILLER_98_598 VGND VGND VPWR VPWR sky130_fd_sc_hd__fill_1
XFILLER_98_587 VGND VGND VPWR VPWR sky130_fd_sc_hd__fill_1
XFILLER_58_418 VGND VGND VPWR VPWR sky130_fd_sc_hd__fill_2
X_05944_ net119 net212 _01665_ VGND VGND VPWR VPWR net106 sky130_fd_sc_hd__mux2_1
X_08732_ decoded_imm\[13\] _01654_ _01586_ VGND VGND VPWR VPWR _04421_ sky130_fd_sc_hd__a21o_1
XTAP_TAPCELL_ROW_68_1414 VGND VPWR sky130_fd_sc_hd__tapvpwrvgnd_1
XFILLER_66_462 VPWR VGND VPWR VGND sky130_ef_sc_hd__decap_12
X_08663_ cpuregs\[16\]\[10\] cpuregs\[17\]\[10\] cpuregs\[18\]\[10\] cpuregs\[19\]\[10\]
+ net278 net273 VGND VGND VPWR VPWR _04355_ sky130_fd_sc_hd__mux4_1
X_05875_ _02060_ _02419_ VGND VGND VPWR VPWR _02432_ sky130_fd_sc_hd__and2_1
XFILLER_93_281 VGND VGND VPWR VPWR sky130_fd_sc_hd__fill_1
XTAP_TAPCELL_ROW_68_1425 VGND VPWR sky130_fd_sc_hd__tapvpwrvgnd_1
XFILLER_121_27 VGND VGND VPWR VPWR sky130_fd_sc_hd__decap_4
XFILLER_81_443 VGND VGND VPWR VPWR sky130_fd_sc_hd__decap_4
X_07614_ cpuregs\[20\]\[31\] _02712_ net245 VGND VGND VPWR VPWR _00547_ sky130_fd_sc_hd__mux2_1
XFILLER_54_657 VGND VGND VPWR VPWR sky130_fd_sc_hd__decap_6
X_08594_ cpuregs\[8\]\[6\] cpuregs\[9\]\[6\] cpuregs\[10\]\[6\] cpuregs\[11\]\[6\]
+ net278 net273 VGND VGND VPWR VPWR _04290_ sky130_fd_sc_hd__mux4_1
XPHY_EDGE_ROW_138_Right_138 VGND VGND VPWR VPWR sky130_fd_sc_hd__decap_3
X_07545_ _02704_ cpuregs\[16\]\[29\] _03570_ VGND VGND VPWR VPWR _00481_ sky130_fd_sc_hd__mux2_1
XTAP_TAPCELL_ROW_81_1625 VGND VPWR sky130_fd_sc_hd__tapvpwrvgnd_1
Xclkbuf_leaf_127_clk clknet_4_8_0_clk VGND VGND VPWR VPWR clknet_leaf_127_clk sky130_fd_sc_hd__clkbuf_8
X_07476_ cpuregs\[15\]\[27\] _02696_ net246 VGND VGND VPWR VPWR _00415_ sky130_fd_sc_hd__mux2_1
X_09215_ is_alu_reg_imm _04751_ _04747_ instr_jalr VGND VGND VPWR VPWR _04798_ sky130_fd_sc_hd__a211o_1
XFILLER_50_874 VGND VGND VPWR VPWR sky130_fd_sc_hd__decap_3
XFILLER_22_587 VGND VGND VPWR VPWR sky130_fd_sc_hd__fill_1
X_06427_ decoded_imm\[4\] net197 VGND VGND VPWR VPWR _02861_ sky130_fd_sc_hd__or2_1
XFILLER_148_773 VPWR VGND VPWR VGND sky130_ef_sc_hd__decap_12
XFILLER_147_261 VPWR VGND VPWR VGND sky130_ef_sc_hd__decap_12
X_09146_ net34 is_alu_reg_reg _04773_ VGND VGND VPWR VPWR _04774_ sky130_fd_sc_hd__and3_1
X_06358_ decoded_imm\[2\] net193 VGND VGND VPWR VPWR _02794_ sky130_fd_sc_hd__or2_1
XFILLER_108_637 VGND VGND VPWR VPWR sky130_fd_sc_hd__fill_1
X_05309_ count_cycle\[19\] _01588_ net256 _01904_ VGND VGND VPWR VPWR _01905_ sky130_fd_sc_hd__o211a_1
X_09077_ mem_rdata_q\[2\] net23 _01609_ VGND VGND VPWR VPWR _01096_ sky130_fd_sc_hd__mux2_1
X_06289_ cpuregs\[4\]\[0\] cpuregs\[5\]\[0\] cpuregs\[6\]\[0\] cpuregs\[7\]\[0\] net264
+ net262 VGND VGND VPWR VPWR _02727_ sky130_fd_sc_hd__mux4_1
XTAP_TAPCELL_ROW_112_2124 VGND VPWR sky130_fd_sc_hd__tapvpwrvgnd_1
XFILLER_107_147 VGND VGND VPWR VPWR sky130_fd_sc_hd__decap_4
XTAP_TAPCELL_ROW_79_1598 VGND VPWR sky130_fd_sc_hd__tapvpwrvgnd_1
X_08028_ _03807_ _03820_ _03845_ _03847_ VGND VGND VPWR VPWR _03848_ sky130_fd_sc_hd__a31o_1
XPHY_EDGE_ROW_15_Left_169 VGND VGND VPWR VPWR sky130_fd_sc_hd__decap_3
XFILLER_104_810 VGND VGND VPWR VPWR sky130_fd_sc_hd__fill_2
XTAP_TAPCELL_ROW_92_1798 VGND VPWR sky130_fd_sc_hd__tapvpwrvgnd_1
XFILLER_131_673 VGND VGND VPWR VPWR sky130_fd_sc_hd__decap_8
XFILLER_77_727 VGND VGND VPWR VPWR sky130_fd_sc_hd__fill_1
X_09979_ clknet_leaf_1_clk _00109_ VGND VGND VPWR VPWR cpuregs\[12\]\[9\] sky130_fd_sc_hd__dfxtp_1
XFILLER_18_805 VGND VGND VPWR VPWR sky130_fd_sc_hd__decap_6
XFILLER_72_421 VGND VGND VPWR VPWR sky130_fd_sc_hd__decap_4
XFILLER_17_337 VPWR VGND VPWR VGND sky130_ef_sc_hd__decap_12
XFILLER_18_849 VPWR VGND VPWR VGND sky130_ef_sc_hd__decap_12
XPHY_EDGE_ROW_24_Left_178 VGND VGND VPWR VPWR sky130_fd_sc_hd__decap_3
XFILLER_44_101 VPWR VGND VPWR VGND sky130_ef_sc_hd__decap_12
XFILLER_72_465 VGND VGND VPWR VPWR sky130_fd_sc_hd__decap_8
XTAP_TAPCELL_ROW_123_2297 VGND VPWR sky130_fd_sc_hd__tapvpwrvgnd_1
XPHY_EDGE_ROW_105_Right_105 VGND VGND VPWR VPWR sky130_fd_sc_hd__decap_3
XFILLER_60_616 VGND VGND VPWR VPWR sky130_fd_sc_hd__decap_8
X_10823_ clknet_leaf_100_clk _00888_ VGND VGND VPWR VPWR decoded_imm_j\[6\] sky130_fd_sc_hd__dfxtp_1
XFILLER_26_893 VPWR VGND VPWR VGND sky130_ef_sc_hd__decap_12
Xclkbuf_leaf_118_clk clknet_4_10_0_clk VGND VGND VPWR VPWR clknet_leaf_118_clk sky130_fd_sc_hd__clkbuf_8
XTAP_TAPCELL_ROW_99_1919 VGND VPWR sky130_fd_sc_hd__tapvpwrvgnd_1
XTAP_TAPCELL_ROW_99_1908 VGND VPWR sky130_fd_sc_hd__tapvpwrvgnd_1
X_10754_ clknet_leaf_133_clk alu_out\[7\] VGND VGND VPWR VPWR alu_out_q\[7\] sky130_fd_sc_hd__dfxtp_1
X_10685_ clknet_leaf_85_clk _00783_ VGND VGND VPWR VPWR net38 sky130_fd_sc_hd__dfxtp_1
XFILLER_139_762 VGND VGND VPWR VPWR sky130_fd_sc_hd__decap_3
XFILLER_138_250 VGND VGND VPWR VPWR sky130_fd_sc_hd__fill_2
XPHY_EDGE_ROW_33_Left_187 VGND VGND VPWR VPWR sky130_fd_sc_hd__decap_3
XFILLER_153_253 VPWR VGND VPWR VGND sky130_ef_sc_hd__decap_12
XFILLER_142_905 VGND VGND VPWR VPWR sky130_fd_sc_hd__decap_4
XFILLER_5_753 VPWR VGND VPWR VGND sky130_ef_sc_hd__decap_12
X_11306_ clknet_leaf_141_clk _01353_ VGND VGND VPWR VPWR cpuregs\[5\]\[3\] sky130_fd_sc_hd__dfxtp_1
XFILLER_141_415 VPWR VGND VPWR VGND sky130_ef_sc_hd__decap_12
XFILLER_113_128 VGND VGND VPWR VPWR sky130_fd_sc_hd__fill_1
XFILLER_107_692 VPWR VGND VPWR VGND sky130_ef_sc_hd__decap_12
XFILLER_5_797 VPWR VGND VPWR VGND sky130_ef_sc_hd__decap_12
XFILLER_4_274 VPWR VGND VPWR VGND sky130_ef_sc_hd__decap_12
X_11237_ clknet_leaf_30_clk _01284_ VGND VGND VPWR VPWR cpuregs\[3\]\[30\] sky130_fd_sc_hd__dfxtp_1
X_11168_ clknet_leaf_68_clk _01215_ VGND VGND VPWR VPWR cpuregs\[23\]\[25\] sky130_fd_sc_hd__dfxtp_1
XFILLER_122_662 VGND VGND VPWR VPWR sky130_fd_sc_hd__fill_2
X_10119_ clknet_leaf_80_clk _00249_ VGND VGND VPWR VPWR cpuregs\[28\]\[21\] sky130_fd_sc_hd__dfxtp_1
XFILLER_95_546 VGND VGND VPWR VPWR sky130_fd_sc_hd__decap_6
XTAP_TAPCELL_ROW_143_2618 VGND VPWR sky130_fd_sc_hd__tapvpwrvgnd_1
X_11099_ clknet_leaf_24_clk _01156_ VGND VGND VPWR VPWR cpuregs\[24\]\[30\] sky130_fd_sc_hd__dfxtp_1
XFILLER_64_900 VGND VGND VPWR VPWR sky130_fd_sc_hd__fill_2
XFILLER_48_451 VGND VGND VPWR VPWR sky130_fd_sc_hd__decap_6
XPHY_EDGE_ROW_42_Left_196 VGND VGND VPWR VPWR sky130_fd_sc_hd__decap_3
X_05660_ _02240_ _02241_ _02130_ VGND VGND VPWR VPWR _02243_ sky130_fd_sc_hd__o21a_1
XFILLER_51_605 VGND VGND VPWR VPWR sky130_fd_sc_hd__decap_8
XFILLER_91_785 VGND VGND VPWR VPWR sky130_fd_sc_hd__fill_1
XFILLER_90_251 VGND VGND VPWR VPWR sky130_fd_sc_hd__fill_1
X_05591_ _02172_ _02173_ VGND VGND VPWR VPWR _02174_ sky130_fd_sc_hd__and2b_1
XFILLER_23_318 VGND VGND VPWR VPWR sky130_fd_sc_hd__fill_1
Xclkbuf_leaf_109_clk clknet_4_11_0_clk VGND VGND VPWR VPWR clknet_leaf_109_clk sky130_fd_sc_hd__clkbuf_8
X_07330_ cpuregs\[21\]\[14\] _02641_ net248 VGND VGND VPWR VPWR _00274_ sky130_fd_sc_hd__mux2_1
XTAP_TAPCELL_ROW_63_1344 VGND VPWR sky130_fd_sc_hd__tapvpwrvgnd_1
XTAP_TAPCELL_ROW_63_1333 VGND VPWR sky130_fd_sc_hd__tapvpwrvgnd_1
XTAP_TAPCELL_ROW_34_869 VGND VPWR sky130_fd_sc_hd__tapvpwrvgnd_1
X_09000_ _04665_ _04666_ _04669_ _04670_ _01558_ _01559_ VGND VGND VPWR VPWR _04674_
+ sky130_fd_sc_hd__mux4_1
X_07261_ cpuregs\[2\]\[12\] _02633_ net250 VGND VGND VPWR VPWR _00208_ sky130_fd_sc_hd__mux2_1
XTAP_TAPCELL_ROW_14_560 VGND VPWR sky130_fd_sc_hd__tapvpwrvgnd_1
XFILLER_31_373 VPWR VGND VPWR VGND sky130_ef_sc_hd__decap_12
X_06212_ _02662_ cpuregs\[11\]\[19\] _02582_ VGND VGND VPWR VPWR _00056_ sky130_fd_sc_hd__mux2_1
X_07192_ cpuregs\[30\]\[10\] _02624_ net252 VGND VGND VPWR VPWR _00142_ sky130_fd_sc_hd__mux2_1
XFILLER_117_434 VGND VGND VPWR VPWR sky130_fd_sc_hd__decap_3
XFILLER_8_580 VGND VGND VPWR VPWR sky130_fd_sc_hd__decap_8
X_06143_ _02583_ _02604_ _02605_ _02606_ VGND VGND VPWR VPWR _02607_ sky130_fd_sc_hd__a22o_4
XFILLER_105_629 VGND VGND VPWR VPWR sky130_fd_sc_hd__fill_1
X_06074_ _00010_ _02545_ _00011_ VGND VGND VPWR VPWR _02546_ sky130_fd_sc_hd__a21o_1
XFILLER_116_27 VGND VGND VPWR VPWR sky130_fd_sc_hd__fill_1
XFILLER_99_841 VGND VGND VPWR VPWR sky130_fd_sc_hd__decap_6
X_05025_ _01549_ _01606_ VGND VGND VPWR VPWR _01648_ sky130_fd_sc_hd__nor2_1
X_09902_ clknet_leaf_126_clk _00037_ VGND VGND VPWR VPWR cpuregs\[11\]\[0\] sky130_fd_sc_hd__dfxtp_1
XFILLER_113_673 VGND VGND VPWR VPWR sky130_fd_sc_hd__decap_6
XFILLER_113_662 VGND VGND VPWR VPWR sky130_fd_sc_hd__decap_3
XFILLER_100_301 VGND VGND VPWR VPWR sky130_fd_sc_hd__decap_6
X_09833_ _02612_ cpuregs\[10\]\[7\] _04876_ VGND VGND VPWR VPWR _01517_ sky130_fd_sc_hd__mux2_1
XFILLER_101_868 VGND VGND VPWR VPWR sky130_fd_sc_hd__decap_4
X_06976_ _03381_ _03382_ _03388_ _03389_ _01579_ _01581_ VGND VGND VPWR VPWR _03390_
+ sky130_fd_sc_hd__mux4_1
XFILLER_132_15 VPWR VGND VPWR VGND sky130_ef_sc_hd__decap_12
XFILLER_67_771 VPWR VGND VPWR VGND sky130_ef_sc_hd__decap_12
X_09764_ _02598_ cpuregs\[7\]\[4\] _04874_ VGND VGND VPWR VPWR _01418_ sky130_fd_sc_hd__mux2_1
XFILLER_100_389 VGND VGND VPWR VPWR sky130_fd_sc_hd__fill_2
X_08715_ cpuregs\[20\]\[13\] cpuregs\[21\]\[13\] cpuregs\[22\]\[13\] cpuregs\[23\]\[13\]
+ net277 net271 VGND VGND VPWR VPWR _04404_ sky130_fd_sc_hd__mux4_1
X_05927_ mem_wordsize\[1\] net97 net233 _01672_ VGND VGND VPWR VPWR net127 sky130_fd_sc_hd__a22o_1
X_09695_ _02588_ cpuregs\[5\]\[1\] _04872_ VGND VGND VPWR VPWR _01351_ sky130_fd_sc_hd__mux2_1
XFILLER_27_613 VGND VGND VPWR VPWR sky130_fd_sc_hd__decap_3
Xrebuffer20 net405 VGND VGND VPWR VPWR net406 sky130_fd_sc_hd__dlygate4sd1_1
X_05858_ _02398_ _02416_ _02089_ VGND VGND VPWR VPWR _02417_ sky130_fd_sc_hd__a21oi_1
Xrebuffer31 net416 VGND VGND VPWR VPWR net417 sky130_fd_sc_hd__dlymetal6s2s_1
XFILLER_92_19 VGND VGND VPWR VPWR sky130_fd_sc_hd__decap_8
XFILLER_82_763 VGND VGND VPWR VPWR sky130_fd_sc_hd__fill_1
Xrebuffer64 _04073_ VGND VGND VPWR VPWR net450 sky130_fd_sc_hd__dlygate4sd1_1
Xrebuffer42 net429 VGND VGND VPWR VPWR net428 sky130_fd_sc_hd__dlygate4sd1_1
Xrebuffer53 net440 VGND VGND VPWR VPWR net439 sky130_fd_sc_hd__dlygate4sd1_1
XFILLER_54_454 VGND VGND VPWR VPWR sky130_fd_sc_hd__decap_8
X_08646_ cpuregs\[24\]\[9\] cpuregs\[25\]\[9\] cpuregs\[26\]\[9\] cpuregs\[27\]\[9\]
+ net278 net273 VGND VGND VPWR VPWR _04339_ sky130_fd_sc_hd__mux4_1
XFILLER_26_156 VGND VGND VPWR VPWR sky130_fd_sc_hd__decap_8
X_05789_ _02111_ _02348_ _02354_ VGND VGND VPWR VPWR _02355_ sky130_fd_sc_hd__o21a_1
X_08577_ _04264_ _04265_ _01558_ VGND VGND VPWR VPWR _04274_ sky130_fd_sc_hd__mux2_1
XFILLER_23_841 VPWR VGND VPWR VGND sky130_ef_sc_hd__decap_12
XFILLER_25_57 VGND VGND VPWR VPWR sky130_fd_sc_hd__decap_3
X_07528_ _02633_ cpuregs\[16\]\[12\] _03570_ VGND VGND VPWR VPWR _00464_ sky130_fd_sc_hd__mux2_1
X_07459_ cpuregs\[15\]\[10\] _02624_ net246 VGND VGND VPWR VPWR _00398_ sky130_fd_sc_hd__mux2_1
XTAP_TAPCELL_ROW_12_519 VGND VPWR sky130_fd_sc_hd__tapvpwrvgnd_1
XFILLER_22_373 VGND VGND VPWR VPWR sky130_fd_sc_hd__fill_1
XFILLER_41_23 VPWR VGND VPWR VGND sky130_ef_sc_hd__decap_12
XFILLER_136_710 VGND VGND VPWR VPWR sky130_fd_sc_hd__decap_4
XFILLER_108_401 VPWR VGND VPWR VGND sky130_ef_sc_hd__decap_12
X_10470_ clknet_leaf_84_clk _00600_ VGND VGND VPWR VPWR count_instr\[19\] sky130_fd_sc_hd__dfxtp_1
X_09129_ instr_slti _04748_ _04761_ _04765_ VGND VGND VPWR VPWR _00862_ sky130_fd_sc_hd__a22o_1
XFILLER_151_702 VGND VGND VPWR VPWR sky130_fd_sc_hd__decap_3
XFILLER_124_905 VGND VGND VPWR VPWR sky130_fd_sc_hd__decap_4
XTAP_TAPCELL_ROW_94_1838 VGND VPWR sky130_fd_sc_hd__tapvpwrvgnd_1
Xrebuffer198 net585 VGND VGND VPWR VPWR net584 sky130_fd_sc_hd__dlygate4sd1_1
Xrebuffer187 net574 VGND VGND VPWR VPWR net573 sky130_fd_sc_hd__dlygate4sd1_1
XFILLER_123_415 VPWR VGND VPWR VGND sky130_ef_sc_hd__decap_12
XFILLER_2_701 VPWR VGND VPWR VGND sky130_ef_sc_hd__decap_12
XFILLER_104_640 VGND VGND VPWR VPWR sky130_fd_sc_hd__decap_4
XFILLER_9_3 VPWR VGND VPWR VGND sky130_ef_sc_hd__decap_12
X_11022_ clknet_leaf_46_clk _01084_ VGND VGND VPWR VPWR cpuregs\[19\]\[22\] sky130_fd_sc_hd__dfxtp_1
XFILLER_103_194 VGND VGND VPWR VPWR sky130_fd_sc_hd__decap_8
XTAP_TAPCELL_ROW_125_2326 VGND VPWR sky130_fd_sc_hd__tapvpwrvgnd_1
XFILLER_66_53 VPWR VGND VPWR VGND sky130_ef_sc_hd__decap_12
XTAP_TAPCELL_ROW_125_2337 VGND VPWR sky130_fd_sc_hd__tapvpwrvgnd_1
XFILLER_92_527 VGND VGND VPWR VPWR sky130_fd_sc_hd__decap_4
XFILLER_85_590 VGND VGND VPWR VPWR sky130_fd_sc_hd__fill_1
XFILLER_66_97 VPWR VGND VPWR VGND sky130_ef_sc_hd__decap_12
XFILLER_57_281 VGND VGND VPWR VPWR sky130_fd_sc_hd__decap_6
XFILLER_17_101 VGND VGND VPWR VPWR sky130_fd_sc_hd__fill_1
XFILLER_45_432 VGND VGND VPWR VPWR sky130_fd_sc_hd__fill_2
XFILLER_122_81 VGND VGND VPWR VPWR sky130_fd_sc_hd__decap_3
XFILLER_82_41 VGND VGND VPWR VPWR sky130_fd_sc_hd__decap_8
XFILLER_17_167 VGND VGND VPWR VPWR sky130_fd_sc_hd__fill_1
XFILLER_33_605 VGND VGND VPWR VPWR sky130_fd_sc_hd__decap_8
XFILLER_45_487 VGND VGND VPWR VPWR sky130_fd_sc_hd__decap_4
XTAP_TAPCELL_ROW_103_1978 VGND VPWR sky130_fd_sc_hd__tapvpwrvgnd_1
X_10806_ clknet_leaf_99_clk _00871_ VGND VGND VPWR VPWR instr_sub sky130_fd_sc_hd__dfxtp_4
XFILLER_60_457 VGND VGND VPWR VPWR sky130_fd_sc_hd__decap_8
XTAP_TAPCELL_ROW_45_1052 VGND VPWR sky130_fd_sc_hd__tapvpwrvgnd_1
X_10737_ clknet_leaf_55_clk _00834_ VGND VGND VPWR VPWR net223 sky130_fd_sc_hd__dfxtp_4
XFILLER_9_333 VGND VGND VPWR VPWR sky130_fd_sc_hd__decap_3
XTAP_TAPCELL_ROW_31_828 VGND VPWR sky130_fd_sc_hd__tapvpwrvgnd_1
X_10668_ clknet_leaf_64_clk _04896_ VGND VGND VPWR VPWR reg_out\[26\] sky130_fd_sc_hd__dfxtp_1
XTAP_TAPCELL_ROW_153_2791 VGND VPWR sky130_fd_sc_hd__tapvpwrvgnd_1
Xoutput107 net107 VGND VGND VPWR VPWR mem_la_wdata[19] sky130_fd_sc_hd__buf_2
XTAP_TAPCELL_ROW_153_2780 VGND VPWR sky130_fd_sc_hd__tapvpwrvgnd_1
X_10599_ clknet_leaf_89_clk _00729_ VGND VGND VPWR VPWR count_cycle\[22\] sky130_fd_sc_hd__dfxtp_1
Xoutput118 net118 VGND VGND VPWR VPWR mem_la_wdata[29] sky130_fd_sc_hd__buf_2
XFILLER_5_561 VPWR VGND VPWR VGND sky130_ef_sc_hd__decap_12
Xoutput129 net129 VGND VGND VPWR VPWR mem_la_write sky130_fd_sc_hd__buf_2
XFILLER_114_459 VGND VGND VPWR VPWR sky130_fd_sc_hd__decap_4
XFILLER_99_159 VGND VGND VPWR VPWR sky130_fd_sc_hd__decap_8
XFILLER_96_822 VGND VGND VPWR VPWR sky130_fd_sc_hd__fill_1
XPHY_EDGE_ROW_50_Left_204 VGND VGND VPWR VPWR sky130_fd_sc_hd__decap_3
X_06830_ cpuregs\[28\]\[19\] cpuregs\[29\]\[19\] cpuregs\[30\]\[19\] cpuregs\[31\]\[19\]
+ net267 _00013_ VGND VGND VPWR VPWR _03249_ sky130_fd_sc_hd__mux4_1
XFILLER_95_343 VGND VGND VPWR VPWR sky130_fd_sc_hd__fill_1
XFILLER_83_505 VGND VGND VPWR VPWR sky130_fd_sc_hd__fill_2
XFILLER_110_698 VGND VGND VPWR VPWR sky130_fd_sc_hd__fill_2
XFILLER_95_387 VGND VGND VPWR VPWR sky130_fd_sc_hd__fill_2
X_06761_ _03178_ _03181_ _03182_ _00016_ _01580_ VGND VGND VPWR VPWR _03183_ sky130_fd_sc_hd__a221o_1
X_08500_ net84 net53 _04208_ VGND VGND VPWR VPWR _00798_ sky130_fd_sc_hd__mux2_1
X_09480_ cpuregs\[24\]\[18\] _02657_ net241 VGND VGND VPWR VPWR _01144_ sky130_fd_sc_hd__mux2_1
X_06692_ cpuregs\[0\]\[14\] cpuregs\[1\]\[14\] cpuregs\[2\]\[14\] cpuregs\[3\]\[14\]
+ net265 net260 VGND VGND VPWR VPWR _03116_ sky130_fd_sc_hd__mux4_1
X_05712_ instr_sub _02191_ VGND VGND VPWR VPWR _02287_ sky130_fd_sc_hd__nand2_1
XFILLER_48_281 VGND VGND VPWR VPWR sky130_fd_sc_hd__fill_1
XTAP_TAPCELL_ROW_19_630 VGND VPWR sky130_fd_sc_hd__tapvpwrvgnd_1
XTAP_TAPCELL_ROW_19_641 VGND VPWR sky130_fd_sc_hd__tapvpwrvgnd_1
XFILLER_36_421 VGND VGND VPWR VPWR sky130_fd_sc_hd__decap_3
X_08431_ _04167_ count_cycle\[63\] _01549_ VGND VGND VPWR VPWR _04169_ sky130_fd_sc_hd__a21o_1
XFILLER_102_29 VPWR VGND VPWR VGND sky130_ef_sc_hd__decap_12
X_05643_ net226 net194 VGND VGND VPWR VPWR _02226_ sky130_fd_sc_hd__nand2b_1
XFILLER_23_104 VGND VGND VPWR VPWR sky130_fd_sc_hd__decap_8
X_05574_ _02146_ _02149_ _02152_ _02156_ VGND VGND VPWR VPWR _02157_ sky130_fd_sc_hd__or4_1
X_08362_ _04124_ _04125_ VGND VGND VPWR VPWR _00744_ sky130_fd_sc_hd__nor2_1
X_08293_ count_cycle\[13\] net409 _04080_ VGND VGND VPWR VPWR _00720_ sky130_fd_sc_hd__o21a_1
X_07313_ cpuregs\[28\]\[31\] _02712_ net249 VGND VGND VPWR VPWR _00259_ sky130_fd_sc_hd__mux2_1
XFILLER_137_518 VPWR VGND VPWR VGND sky130_ef_sc_hd__decap_12
X_07244_ cpuregs\[13\]\[28\] _02699_ net251 VGND VGND VPWR VPWR _00192_ sky130_fd_sc_hd__mux2_1
XFILLER_118_721 VGND VGND VPWR VPWR sky130_fd_sc_hd__fill_1
XFILLER_11_15 VPWR VGND VPWR VGND sky130_ef_sc_hd__decap_12
XFILLER_127_15 VPWR VGND VPWR VGND sky130_ef_sc_hd__decap_12
X_07175_ cpuregs\[12\]\[29\] _02704_ net253 VGND VGND VPWR VPWR _00129_ sky130_fd_sc_hd__mux2_1
XFILLER_145_573 VPWR VGND VPWR VGND sky130_ef_sc_hd__decap_12
XTAP_TAPCELL_ROW_76_1546 VGND VPWR sky130_fd_sc_hd__tapvpwrvgnd_1
X_06126_ _02591_ _02592_ _02584_ VGND VGND VPWR VPWR _02593_ sky130_fd_sc_hd__mux2_8
X_06057_ cpuregs\[16\]\[2\] cpuregs\[17\]\[2\] cpuregs\[18\]\[2\] cpuregs\[19\]\[2\]
+ net279 _00008_ VGND VGND VPWR VPWR _02530_ sky130_fd_sc_hd__mux4_1
X_05008_ instr_slt instr_slti instr_blt VGND VGND VPWR VPWR _00002_ sky130_fd_sc_hd__or3_1
XFILLER_86_321 VGND VGND VPWR VPWR sky130_fd_sc_hd__fill_1
XFILLER_143_69 VPWR VGND VPWR VGND sky130_ef_sc_hd__decap_12
X_09816_ _02678_ cpuregs\[8\]\[23\] _04875_ VGND VGND VPWR VPWR _01469_ sky130_fd_sc_hd__mux2_1
XFILLER_86_365 VPWR VGND VPWR VGND sky130_ef_sc_hd__decap_12
XFILLER_86_343 VGND VGND VPWR VPWR sky130_fd_sc_hd__fill_1
X_09747_ _02665_ cpuregs\[6\]\[20\] _04873_ VGND VGND VPWR VPWR _01402_ sky130_fd_sc_hd__mux2_1
XTAP_TAPCELL_ROW_107_2045 VGND VPWR sky130_fd_sc_hd__tapvpwrvgnd_1
X_06959_ _03159_ _03162_ _03164_ _03268_ _03371_ VGND VGND VPWR VPWR _03373_ sky130_fd_sc_hd__a311o_1
XFILLER_28_911 VGND VGND VPWR VPWR sky130_fd_sc_hd__fill_1
XFILLER_100_197 VGND VGND VPWR VPWR sky130_fd_sc_hd__fill_2
XFILLER_55_752 VGND VGND VPWR VPWR sky130_fd_sc_hd__fill_1
XFILLER_39_281 VGND VGND VPWR VPWR sky130_fd_sc_hd__decap_4
X_09678_ cpuregs\[4\]\[17\] _02654_ net238 VGND VGND VPWR VPWR _01335_ sky130_fd_sc_hd__mux2_1
XFILLER_55_785 VGND VGND VPWR VPWR sky130_fd_sc_hd__decap_3
XFILLER_42_402 VPWR VGND VPWR VGND sky130_ef_sc_hd__decap_12
XTAP_TAPCELL_ROW_120_2256 VGND VPWR sky130_fd_sc_hd__tapvpwrvgnd_1
XTAP_TAPCELL_ROW_120_2245 VGND VPWR sky130_fd_sc_hd__tapvpwrvgnd_1
XFILLER_70_755 VGND VGND VPWR VPWR sky130_fd_sc_hd__fill_1
X_08629_ cpuregs\[0\]\[8\] cpuregs\[1\]\[8\] cpuregs\[2\]\[8\] cpuregs\[3\]\[8\] net278
+ net273 VGND VGND VPWR VPWR _04323_ sky130_fd_sc_hd__mux4_1
XFILLER_23_660 VPWR VGND VPWR VGND sky130_ef_sc_hd__decap_12
XFILLER_146_3 VPWR VGND VPWR VGND sky130_ef_sc_hd__decap_12
XFILLER_11_833 VGND VGND VPWR VPWR sky130_fd_sc_hd__decap_6
X_10522_ clknet_leaf_131_clk _00652_ VGND VGND VPWR VPWR reg_pc\[8\] sky130_fd_sc_hd__dfxtp_1
XFILLER_11_877 VPWR VGND VPWR VGND sky130_ef_sc_hd__decap_12
XFILLER_10_376 VGND VGND VPWR VPWR sky130_fd_sc_hd__decap_8
XFILLER_10_365 VGND VGND VPWR VPWR sky130_fd_sc_hd__fill_2
X_10453_ clknet_leaf_108_clk _00583_ VGND VGND VPWR VPWR count_instr\[2\] sky130_fd_sc_hd__dfxtp_1
XFILLER_124_713 VPWR VGND VPWR VGND sky130_ef_sc_hd__decap_12
XFILLER_109_798 VPWR VGND VPWR VGND sky130_ef_sc_hd__decap_12
XPHY_EDGE_ROW_107_Left_261 VGND VGND VPWR VPWR sky130_fd_sc_hd__decap_3
X_10384_ clknet_leaf_24_clk _00514_ VGND VGND VPWR VPWR cpuregs\[25\]\[30\] sky130_fd_sc_hd__dfxtp_1
XFILLER_124_757 VGND VGND VPWR VPWR sky130_fd_sc_hd__fill_1
XFILLER_123_223 VGND VGND VPWR VPWR sky130_fd_sc_hd__fill_1
XFILLER_112_908 VGND VGND VPWR VPWR sky130_fd_sc_hd__fill_1
XFILLER_124_779 VPWR VGND VPWR VGND sky130_ef_sc_hd__decap_12
XFILLER_111_407 VGND VGND VPWR VPWR sky130_fd_sc_hd__fill_2
XFILLER_78_855 VGND VGND VPWR VPWR sky130_fd_sc_hd__fill_1
X_11005_ clknet_leaf_142_clk _01067_ VGND VGND VPWR VPWR cpuregs\[19\]\[5\] sky130_fd_sc_hd__dfxtp_1
XFILLER_93_825 VGND VGND VPWR VPWR sky130_fd_sc_hd__decap_3
XFILLER_78_899 VGND VGND VPWR VPWR sky130_fd_sc_hd__decap_8
XTAP_TAPCELL_ROW_36_909 VGND VPWR sky130_fd_sc_hd__tapvpwrvgnd_1
XPHY_EDGE_ROW_116_Left_270 VGND VGND VPWR VPWR sky130_fd_sc_hd__decap_3
XFILLER_92_379 VGND VGND VPWR VPWR sky130_fd_sc_hd__decap_8
XFILLER_80_519 VGND VGND VPWR VPWR sky130_fd_sc_hd__fill_1
XFILLER_46_785 VGND VGND VPWR VPWR sky130_fd_sc_hd__decap_8
XFILLER_60_265 VGND VGND VPWR VPWR sky130_fd_sc_hd__fill_2
XTAP_TAPCELL_ROW_138_2539 VGND VPWR sky130_fd_sc_hd__tapvpwrvgnd_1
XFILLER_60_276 VGND VGND VPWR VPWR sky130_fd_sc_hd__decap_4
Xclkbuf_leaf_40_clk clknet_4_5_0_clk VGND VGND VPWR VPWR clknet_leaf_40_clk sky130_fd_sc_hd__clkbuf_8
XFILLER_13_181 VGND VGND VPWR VPWR sky130_fd_sc_hd__decap_6
X_05290_ reg_pc\[18\] decoded_imm\[18\] VGND VGND VPWR VPWR _01887_ sky130_fd_sc_hd__nand2_1
XFILLER_127_595 VGND VGND VPWR VPWR sky130_fd_sc_hd__decap_8
XFILLER_6_881 VPWR VGND VPWR VGND sky130_ef_sc_hd__decap_12
XTAP_TAPCELL_ROW_58_1265 VGND VPWR sky130_fd_sc_hd__tapvpwrvgnd_1
XTAP_TAPCELL_ROW_58_1254 VGND VPWR sky130_fd_sc_hd__tapvpwrvgnd_1
XFILLER_5_391 VGND VGND VPWR VPWR sky130_fd_sc_hd__fill_1
X_08980_ cpuregs\[0\]\[27\] cpuregs\[1\]\[27\] cpuregs\[2\]\[27\] cpuregs\[3\]\[27\]
+ net275 net271 VGND VGND VPWR VPWR _04655_ sky130_fd_sc_hd__mux4_1
XFILLER_114_278 VPWR VGND VPWR VGND sky130_ef_sc_hd__decap_12
XFILLER_130_738 VGND VGND VPWR VPWR sky130_fd_sc_hd__fill_2
X_07931_ instr_jal _03757_ _03758_ VGND VGND VPWR VPWR _03759_ sky130_fd_sc_hd__or3_1
X_07862_ reg_pc\[19\] _01624_ _01628_ _03706_ VGND VGND VPWR VPWR _00663_ sky130_fd_sc_hd__a22o_1
XTAP_TAPCELL_ROW_71_1465 VGND VPWR sky130_fd_sc_hd__tapvpwrvgnd_1
XFILLER_68_332 VPWR VGND VPWR VGND sky130_ef_sc_hd__decap_12
X_06813_ _03224_ _03231_ _03232_ _01581_ _01580_ VGND VGND VPWR VPWR _03233_ sky130_fd_sc_hd__a221o_1
XFILLER_110_484 VGND VGND VPWR VPWR sky130_fd_sc_hd__fill_1
XFILLER_95_173 VGND VGND VPWR VPWR sky130_fd_sc_hd__fill_1
XFILLER_95_162 VGND VGND VPWR VPWR sky130_fd_sc_hd__decap_6
X_09601_ _02612_ cpuregs\[3\]\[7\] _04868_ VGND VGND VPWR VPWR _01261_ sky130_fd_sc_hd__mux2_1
XFILLER_3_93 VPWR VGND VPWR VGND sky130_ef_sc_hd__decap_12
X_07793_ _03664_ count_instr\[51\] count_instr\[52\] VGND VGND VPWR VPWR _03668_ sky130_fd_sc_hd__and3_1
X_09532_ cpuregs\[23\]\[4\] _02598_ _04866_ VGND VGND VPWR VPWR _01194_ sky130_fd_sc_hd__mux2_1
X_06744_ _03159_ _03162_ _03164_ _03157_ VGND VGND VPWR VPWR _03166_ sky130_fd_sc_hd__a31o_1
XFILLER_92_880 VGND VGND VPWR VPWR sky130_fd_sc_hd__fill_1
XFILLER_91_390 VGND VGND VPWR VPWR sky130_fd_sc_hd__fill_2
X_06675_ cpuregs\[8\]\[13\] cpuregs\[9\]\[13\] cpuregs\[10\]\[13\] cpuregs\[11\]\[13\]
+ net265 net260 VGND VGND VPWR VPWR _03100_ sky130_fd_sc_hd__mux4_1
XFILLER_64_582 VGND VGND VPWR VPWR sky130_fd_sc_hd__decap_6
X_09463_ cpuregs\[24\]\[1\] _02588_ net243 VGND VGND VPWR VPWR _01127_ sky130_fd_sc_hd__mux2_1
X_08414_ count_cycle\[56\] _04154_ count_cycle\[57\] VGND VGND VPWR VPWR _04158_ sky130_fd_sc_hd__and3_1
X_05626_ _02056_ _02207_ _02208_ VGND VGND VPWR VPWR _02209_ sky130_fd_sc_hd__o21ai_1
X_09394_ decoded_imm\[1\] _04746_ _04860_ _04861_ VGND VGND VPWR VPWR _01029_ sky130_fd_sc_hd__o22a_1
X_08345_ count_cycle\[31\] _04113_ net34 VGND VGND VPWR VPWR _04115_ sky130_fd_sc_hd__o21ai_1
XFILLER_52_799 VGND VGND VPWR VPWR sky130_fd_sc_hd__fill_2
X_05557_ net197 net123 VGND VGND VPWR VPWR _02140_ sky130_fd_sc_hd__nor2_1
Xclkbuf_leaf_31_clk clknet_4_5_0_clk VGND VGND VPWR VPWR clknet_leaf_31_clk sky130_fd_sc_hd__clkbuf_8
XFILLER_138_849 VPWR VGND VPWR VGND sky130_ef_sc_hd__decap_12
X_05488_ _02067_ _02070_ VGND VGND VPWR VPWR _02071_ sky130_fd_sc_hd__nor2_1
X_08276_ count_cycle\[7\] net397 _01549_ VGND VGND VPWR VPWR _04070_ sky130_fd_sc_hd__a21oi_1
XFILLER_118_7 VPWR VGND VPWR VGND sky130_ef_sc_hd__decap_12
X_07227_ cpuregs\[13\]\[11\] _02630_ net251 VGND VGND VPWR VPWR _00175_ sky130_fd_sc_hd__mux2_1
XFILLER_152_307 VGND VGND VPWR VPWR sky130_fd_sc_hd__fill_1
XFILLER_146_893 VPWR VGND VPWR VGND sky130_ef_sc_hd__decap_12
XFILLER_145_370 VPWR VGND VPWR VGND sky130_ef_sc_hd__decap_12
XFILLER_98_18 VGND VGND VPWR VPWR sky130_fd_sc_hd__decap_8
X_07158_ cpuregs\[12\]\[12\] _02633_ net253 VGND VGND VPWR VPWR _00112_ sky130_fd_sc_hd__mux2_1
XFILLER_3_317 VGND VGND VPWR VPWR sky130_fd_sc_hd__fill_1
XFILLER_105_223 VGND VGND VPWR VPWR sky130_fd_sc_hd__fill_1
X_06109_ latched_rd\[2\] latched_rd\[4\] latched_rd\[3\] VGND VGND VPWR VPWR _02579_
+ sky130_fd_sc_hd__or3b_1
X_07089_ _00015_ _03495_ _03498_ _02735_ VGND VGND VPWR VPWR _03499_ sky130_fd_sc_hd__o211a_1
XFILLER_121_727 VGND VGND VPWR VPWR sky130_fd_sc_hd__fill_1
Xclkbuf_leaf_98_clk clknet_4_9_0_clk VGND VGND VPWR VPWR clknet_leaf_98_clk sky130_fd_sc_hd__clkbuf_8
XFILLER_101_440 VGND VGND VPWR VPWR sky130_fd_sc_hd__fill_2
XFILLER_101_473 VGND VGND VPWR VPWR sky130_fd_sc_hd__decap_3
XTAP_TAPCELL_ROW_89_1748 VGND VPWR sky130_fd_sc_hd__tapvpwrvgnd_1
XFILLER_87_696 VGND VGND VPWR VPWR sky130_fd_sc_hd__fill_1
XFILLER_47_44 VPWR VGND VPWR VGND sky130_ef_sc_hd__decap_12
XFILLER_101_495 VGND VGND VPWR VPWR sky130_fd_sc_hd__decap_8
XTAP_TAPCELL_ROW_89_1759 VGND VPWR sky130_fd_sc_hd__tapvpwrvgnd_1
XFILLER_86_195 VGND VGND VPWR VPWR sky130_fd_sc_hd__fill_1
XTAP_TAPCELL_ROW_2_361 VGND VPWR sky130_fd_sc_hd__tapvpwrvgnd_1
XFILLER_82_390 VGND VGND VPWR VPWR sky130_fd_sc_hd__fill_1
XFILLER_63_32 VPWR VGND VPWR VGND sky130_ef_sc_hd__decap_12
XFILLER_28_796 VPWR VGND VPWR VGND sky130_ef_sc_hd__decap_12
XFILLER_70_552 VGND VGND VPWR VPWR sky130_fd_sc_hd__decap_6
XTAP_TAPCELL_ROW_100_1926 VGND VPWR sky130_fd_sc_hd__tapvpwrvgnd_1
XFILLER_30_405 VPWR VGND VPWR VGND sky130_ef_sc_hd__decap_12
XTAP_TAPCELL_ROW_42_1000 VGND VPWR sky130_fd_sc_hd__tapvpwrvgnd_1
XFILLER_42_276 VGND VGND VPWR VPWR sky130_fd_sc_hd__decap_3
XTAP_TAPCELL_ROW_42_1011 VGND VPWR sky130_fd_sc_hd__tapvpwrvgnd_1
XTAP_TAPCELL_ROW_100_1937 VGND VPWR sky130_fd_sc_hd__tapvpwrvgnd_1
Xclkbuf_leaf_22_clk clknet_4_6_0_clk VGND VGND VPWR VPWR clknet_leaf_22_clk sky130_fd_sc_hd__clkbuf_8
XFILLER_8_27 VGND VGND VPWR VPWR sky130_fd_sc_hd__fill_1
XTAP_TAPCELL_ROW_41_989 VGND VPWR sky130_fd_sc_hd__tapvpwrvgnd_1
X_11485_ clknet_leaf_70_clk _01529_ VGND VGND VPWR VPWR cpuregs\[10\]\[19\] sky130_fd_sc_hd__dfxtp_1
XFILLER_109_540 VGND VGND VPWR VPWR sky130_fd_sc_hd__decap_8
X_10505_ clknet_leaf_83_clk _00635_ VGND VGND VPWR VPWR count_instr\[54\] sky130_fd_sc_hd__dfxtp_1
XFILLER_10_195 VGND VGND VPWR VPWR sky130_fd_sc_hd__fill_1
XFILLER_6_133 VGND VGND VPWR VPWR sky130_fd_sc_hd__decap_6
XTAP_TAPCELL_ROW_133_2458 VGND VPWR sky130_fd_sc_hd__tapvpwrvgnd_1
X_10436_ clknet_leaf_53_clk _00566_ VGND VGND VPWR VPWR cpuregs\[17\]\[18\] sky130_fd_sc_hd__dfxtp_1
XFILLER_6_177 VPWR VGND VPWR VGND sky130_ef_sc_hd__decap_12
XFILLER_124_554 VGND VGND VPWR VPWR sky130_fd_sc_hd__decap_8
XFILLER_97_405 VPWR VGND VPWR VGND sky130_ef_sc_hd__decap_12
X_10367_ clknet_leaf_26_clk _00497_ VGND VGND VPWR VPWR cpuregs\[25\]\[13\] sky130_fd_sc_hd__dfxtp_1
XFILLER_97_449 VGND VGND VPWR VPWR sky130_fd_sc_hd__decap_4
XFILLER_69_129 VGND VGND VPWR VPWR sky130_fd_sc_hd__decap_8
XFILLER_3_895 VGND VGND VPWR VPWR sky130_fd_sc_hd__fill_1
X_10298_ clknet_leaf_136_clk _00428_ VGND VGND VPWR VPWR cpuregs\[26\]\[8\] sky130_fd_sc_hd__dfxtp_1
XFILLER_111_259 VGND VGND VPWR VPWR sky130_fd_sc_hd__decap_4
Xclkbuf_leaf_89_clk clknet_4_14_0_clk VGND VGND VPWR VPWR clknet_leaf_89_clk sky130_fd_sc_hd__clkbuf_8
XFILLER_78_652 VGND VGND VPWR VPWR sky130_fd_sc_hd__decap_8
XTAP_TAPCELL_ROW_53_1173 VGND VPWR sky130_fd_sc_hd__tapvpwrvgnd_1
XFILLER_78_696 VGND VGND VPWR VPWR sky130_fd_sc_hd__decap_4
XFILLER_66_825 VGND VGND VPWR VPWR sky130_fd_sc_hd__fill_1
XTAP_TAPCELL_ROW_53_1184 VGND VPWR sky130_fd_sc_hd__tapvpwrvgnd_1
XFILLER_38_505 VGND VGND VPWR VPWR sky130_fd_sc_hd__decap_3
XFILLER_38_527 VGND VGND VPWR VPWR sky130_fd_sc_hd__decap_4
XFILLER_93_633 VGND VGND VPWR VPWR sky130_fd_sc_hd__fill_1
XFILLER_65_335 VGND VGND VPWR VPWR sky130_fd_sc_hd__fill_1
XTAP_TAPCELL_ROW_0_309 VGND VPWR sky130_fd_sc_hd__tapvpwrvgnd_1
XFILLER_80_305 VGND VGND VPWR VPWR sky130_fd_sc_hd__decap_3
XFILLER_18_251 VGND VGND VPWR VPWR sky130_fd_sc_hd__fill_1
XFILLER_19_785 VPWR VGND VPWR VGND sky130_ef_sc_hd__decap_12
XFILLER_46_560 VGND VGND VPWR VPWR sky130_fd_sc_hd__fill_1
XFILLER_74_880 VGND VGND VPWR VPWR sky130_fd_sc_hd__decap_4
XFILLER_18_262 VGND VGND VPWR VPWR sky130_fd_sc_hd__decap_4
XTAP_TAPCELL_ROW_29_791 VGND VPWR sky130_fd_sc_hd__tapvpwrvgnd_1
X_06460_ _02883_ _02884_ _02890_ _02889_ net258 _01580_ VGND VGND VPWR VPWR _02893_
+ sky130_fd_sc_hd__mux4_1
XFILLER_34_766 VGND VGND VPWR VPWR sky130_fd_sc_hd__fill_1
X_05411_ count_cycle\[27\] _01588_ _01674_ _01998_ VGND VGND VPWR VPWR _01999_ sky130_fd_sc_hd__o211a_1
XFILLER_34_799 VPWR VGND VPWR VGND sky130_ef_sc_hd__decap_12
X_08130_ _03899_ _03909_ _03941_ VGND VGND VPWR VPWR _03942_ sky130_fd_sc_hd__nand3_1
Xclkbuf_leaf_13_clk clknet_4_1_0_clk VGND VGND VPWR VPWR clknet_leaf_13_clk sky130_fd_sc_hd__clkbuf_8
X_06391_ cpuregs\[12\]\[3\] cpuregs\[13\]\[3\] cpuregs\[14\]\[3\] cpuregs\[15\]\[3\]
+ net264 net262 VGND VGND VPWR VPWR _02826_ sky130_fd_sc_hd__mux4_1
XFILLER_119_337 VPWR VGND VPWR VGND sky130_ef_sc_hd__decap_12
X_05342_ _01922_ _01925_ _01933_ _01543_ VGND VGND VPWR VPWR _01935_ sky130_fd_sc_hd__a31o_1
X_05273_ instr_rdcycleh count_cycle\[48\] net257 _01871_ VGND VGND VPWR VPWR _01872_
+ sky130_fd_sc_hd__a211o_1
X_08061_ _03877_ _03878_ net34 VGND VGND VPWR VPWR _00690_ sky130_fd_sc_hd__o21a_1
XFILLER_146_189 VGND VGND VPWR VPWR sky130_fd_sc_hd__decap_6
XFILLER_134_329 VGND VGND VPWR VPWR sky130_fd_sc_hd__decap_6
XFILLER_134_318 VGND VGND VPWR VPWR sky130_fd_sc_hd__fill_2
XFILLER_128_893 VPWR VGND VPWR VGND sky130_ef_sc_hd__decap_12
X_07012_ decoded_imm\[26\] net189 VGND VGND VPWR VPWR _03424_ sky130_fd_sc_hd__xnor2_1
Xpicorv32_310 VGND VGND VPWR VPWR picorv32_310/HI eoi[29] sky130_fd_sc_hd__conb_1
Xpicorv32_343 VGND VGND VPWR VPWR picorv32_343/HI pcpi_insn[26] sky130_fd_sc_hd__conb_1
Xpicorv32_321 VGND VGND VPWR VPWR picorv32_321/HI pcpi_insn[4] sky130_fd_sc_hd__conb_1
XFILLER_143_841 VPWR VGND VPWR VGND sky130_ef_sc_hd__decap_12
Xpicorv32_332 VGND VGND VPWR VPWR picorv32_332/HI pcpi_insn[15] sky130_fd_sc_hd__conb_1
XTAP_TAPCELL_ROW_73_1505 VGND VPWR sky130_fd_sc_hd__tapvpwrvgnd_1
Xpicorv32_354 VGND VGND VPWR VPWR picorv32_354/HI trace_data[4] sky130_fd_sc_hd__conb_1
Xpicorv32_365 VGND VGND VPWR VPWR picorv32_365/HI trace_data[15] sky130_fd_sc_hd__conb_1
XFILLER_0_309 VPWR VGND VPWR VGND sky130_ef_sc_hd__decap_12
Xpicorv32_376 VGND VGND VPWR VPWR picorv32_376/HI trace_data[26] sky130_fd_sc_hd__conb_1
X_08963_ net270 _04633_ net269 VGND VGND VPWR VPWR _04639_ sky130_fd_sc_hd__o21a_1
XFILLER_88_427 VPWR VGND VPWR VGND sky130_ef_sc_hd__decap_12
XFILLER_124_27 VGND VGND VPWR VPWR sky130_fd_sc_hd__fill_1
XFILLER_69_652 VGND VGND VPWR VPWR sky130_fd_sc_hd__fill_1
X_07914_ decoded_imm_j\[4\] _03691_ VGND VGND VPWR VPWR _03743_ sky130_fd_sc_hd__or2_1
X_08894_ decoded_imm\[22\] _01654_ _01586_ VGND VGND VPWR VPWR _04574_ sky130_fd_sc_hd__a21o_1
XFILLER_57_825 VGND VGND VPWR VPWR sky130_fd_sc_hd__decap_8
XFILLER_29_505 VGND VGND VPWR VPWR sky130_fd_sc_hd__decap_4
X_07845_ _02625_ reg_next_pc\[11\] _02482_ VGND VGND VPWR VPWR _03698_ sky130_fd_sc_hd__mux2_4
XFILLER_140_15 VPWR VGND VPWR VGND sky130_ef_sc_hd__decap_12
X_07776_ count_instr\[45\] _03654_ count_instr\[46\] VGND VGND VPWR VPWR _03657_ sky130_fd_sc_hd__a21o_1
X_04988_ instr_lbu instr_lw instr_lb VGND VGND VPWR VPWR _01616_ sky130_fd_sc_hd__or3_1
XFILLER_56_357 VGND VGND VPWR VPWR sky130_fd_sc_hd__decap_6
X_09515_ cpuregs\[31\]\[20\] _02665_ _04865_ VGND VGND VPWR VPWR _01178_ sky130_fd_sc_hd__mux2_1
X_06727_ net258 _03144_ _00016_ VGND VGND VPWR VPWR _03150_ sky130_fd_sc_hd__o21a_1
XFILLER_17_69 VPWR VGND VPWR VGND sky130_ef_sc_hd__decap_12
X_09446_ _02654_ cpuregs\[19\]\[17\] _04863_ VGND VGND VPWR VPWR _01079_ sky130_fd_sc_hd__mux2_1
XTAP_TAPCELL_ROW_84_1678 VGND VPWR sky130_fd_sc_hd__tapvpwrvgnd_1
XFILLER_52_563 VGND VGND VPWR VPWR sky130_fd_sc_hd__fill_1
XFILLER_24_243 VGND VGND VPWR VPWR sky130_fd_sc_hd__decap_8
X_06658_ decoded_imm\[13\] net175 VGND VGND VPWR VPWR _03083_ sky130_fd_sc_hd__or2_1
X_05609_ net202 _01574_ _02138_ _02191_ _02176_ VGND VGND VPWR VPWR _02192_ sky130_fd_sc_hd__a221o_1
X_09377_ instr_jal decoded_imm_j\[7\] _04823_ mem_rdata_q\[27\] _04747_ VGND VGND
+ VPWR VPWR _04851_ sky130_fd_sc_hd__a221o_1
X_06589_ cpuregs\[28\]\[10\] cpuregs\[29\]\[10\] cpuregs\[30\]\[10\] cpuregs\[31\]\[10\]
+ net264 net259 VGND VGND VPWR VPWR _03017_ sky130_fd_sc_hd__mux4_1
XFILLER_33_57 VGND VGND VPWR VPWR sky130_fd_sc_hd__decap_6
XFILLER_40_769 VGND VGND VPWR VPWR sky130_fd_sc_hd__decap_8
XFILLER_149_57 VPWR VGND VPWR VGND sky130_ef_sc_hd__decap_12
X_08328_ _04098_ count_cycle\[24\] count_cycle\[25\] count_cycle\[23\] VGND VGND VPWR
+ VPWR _04104_ sky130_fd_sc_hd__and4_1
XFILLER_137_134 VGND VGND VPWR VPWR sky130_fd_sc_hd__fill_2
X_08259_ _01549_ net454 VGND VGND VPWR VPWR _00707_ sky130_fd_sc_hd__nor2_1
XFILLER_137_167 VGND VGND VPWR VPWR sky130_fd_sc_hd__fill_1
XTAP_TAPCELL_ROW_115_2177 VGND VPWR sky130_fd_sc_hd__tapvpwrvgnd_1
XTAP_TAPCELL_ROW_115_2166 VGND VPWR sky130_fd_sc_hd__tapvpwrvgnd_1
X_11270_ clknet_leaf_16_clk _01317_ VGND VGND VPWR VPWR cpuregs\[22\]\[31\] sky130_fd_sc_hd__dfxtp_1
XFILLER_3_125 VPWR VGND VPWR VGND sky130_ef_sc_hd__decap_12
X_10221_ clknet_leaf_35_clk _00351_ VGND VGND VPWR VPWR cpuregs\[14\]\[27\] sky130_fd_sc_hd__dfxtp_1
XFILLER_3_169 VPWR VGND VPWR VGND sky130_ef_sc_hd__decap_12
X_10152_ clknet_leaf_46_clk _00282_ VGND VGND VPWR VPWR cpuregs\[21\]\[22\] sky130_fd_sc_hd__dfxtp_1
XTAP_TAPCELL_ROW_7_442 VGND VPWR sky130_fd_sc_hd__tapvpwrvgnd_1
XFILLER_0_832 VGND VGND VPWR VPWR sky130_fd_sc_hd__decap_4
X_10083_ clknet_leaf_23_clk _00213_ VGND VGND VPWR VPWR cpuregs\[2\]\[17\] sky130_fd_sc_hd__dfxtp_1
XFILLER_95_909 VGND VGND VPWR VPWR sky130_fd_sc_hd__decap_3
XFILLER_94_419 VGND VGND VPWR VPWR sky130_fd_sc_hd__fill_1
XFILLER_101_292 VGND VGND VPWR VPWR sky130_fd_sc_hd__decap_8
XFILLER_101_281 VGND VGND VPWR VPWR sky130_fd_sc_hd__fill_2
XFILLER_47_335 VGND VGND VPWR VPWR sky130_fd_sc_hd__fill_1
XFILLER_114_93 VGND VGND VPWR VPWR sky130_fd_sc_hd__fill_1
XFILLER_63_839 VGND VGND VPWR VPWR sky130_fd_sc_hd__fill_1
XFILLER_62_305 VGND VGND VPWR VPWR sky130_fd_sc_hd__decap_3
XFILLER_74_53 VGND VGND VPWR VPWR sky130_fd_sc_hd__decap_8
XFILLER_56_880 VGND VGND VPWR VPWR sky130_fd_sc_hd__fill_1
X_10985_ clknet_leaf_23_clk _01047_ VGND VGND VPWR VPWR cpuregs\[18\]\[17\] sky130_fd_sc_hd__dfxtp_1
XFILLER_16_755 VGND VGND VPWR VPWR sky130_fd_sc_hd__fill_1
XTAP_TAPCELL_ROW_26_750 VGND VPWR sky130_fd_sc_hd__tapvpwrvgnd_1
XFILLER_71_894 VGND VGND VPWR VPWR sky130_fd_sc_hd__fill_2
XFILLER_15_254 VPWR VGND VPWR VGND sky130_ef_sc_hd__decap_12
XFILLER_15_298 VGND VGND VPWR VPWR sky130_fd_sc_hd__fill_1
XFILLER_90_85 VPWR VGND VPWR VGND sky130_ef_sc_hd__decap_12
X_11606_ net108 VGND VGND VPWR VPWR net214 sky130_fd_sc_hd__clkbuf_1
XFILLER_125_841 VPWR VGND VPWR VGND sky130_ef_sc_hd__decap_12
X_11468_ clknet_leaf_127_clk _01512_ VGND VGND VPWR VPWR cpuregs\[10\]\[2\] sky130_fd_sc_hd__dfxtp_1
XFILLER_140_811 VGND VGND VPWR VPWR sky130_fd_sc_hd__fill_1
XFILLER_112_502 VGND VGND VPWR VPWR sky130_fd_sc_hd__fill_1
X_11399_ clknet_leaf_32_clk _01443_ VGND VGND VPWR VPWR cpuregs\[7\]\[29\] sky130_fd_sc_hd__dfxtp_1
XTAP_TAPCELL_ROW_55_1213 VGND VPWR sky130_fd_sc_hd__tapvpwrvgnd_1
X_10419_ clknet_leaf_116_clk _00549_ VGND VGND VPWR VPWR cpuregs\[17\]\[1\] sky130_fd_sc_hd__dfxtp_1
XFILLER_112_524 VGND VGND VPWR VPWR sky130_fd_sc_hd__decap_8
XFILLER_151_181 VPWR VGND VPWR VGND sky130_ef_sc_hd__decap_12
XFILLER_66_611 VGND VGND VPWR VPWR sky130_fd_sc_hd__decap_8
X_05960_ net193 _02483_ _01582_ VGND VGND VPWR VPWR net86 sky130_fd_sc_hd__mux2_1
XFILLER_24_3 VPWR VGND VPWR VGND sky130_ef_sc_hd__decap_12
Xclkbuf_leaf_2_clk clknet_4_0_0_clk VGND VGND VPWR VPWR clknet_leaf_2_clk sky130_fd_sc_hd__clkbuf_8
XPHY_EDGE_ROW_119_Right_119 VGND VGND VPWR VPWR sky130_fd_sc_hd__decap_3
X_05891_ _02057_ _02065_ VGND VGND VPWR VPWR _02446_ sky130_fd_sc_hd__or2_1
X_04911_ instr_bne VGND VGND VPWR VPWR _01544_ sky130_fd_sc_hd__inv_2
XFILLER_39_869 VPWR VGND VPWR VGND sky130_ef_sc_hd__decap_12
XFILLER_93_474 VPWR VGND VPWR VGND sky130_ef_sc_hd__decap_12
X_07630_ _02641_ cpuregs\[17\]\[14\] _03574_ VGND VGND VPWR VPWR _00562_ sky130_fd_sc_hd__mux2_1
XFILLER_54_806 VGND VGND VPWR VPWR sky130_fd_sc_hd__decap_6
X_07561_ cpuregs\[25\]\[12\] _02633_ _03571_ VGND VGND VPWR VPWR _00496_ sky130_fd_sc_hd__mux2_1
XFILLER_54_839 VGND VGND VPWR VPWR sky130_fd_sc_hd__decap_4
X_09300_ net158 net120 _04206_ VGND VGND VPWR VPWR _00986_ sky130_fd_sc_hd__mux2_1
X_06512_ net258 _02941_ _01581_ VGND VGND VPWR VPWR _02943_ sky130_fd_sc_hd__o21a_1
XTAP_TAPCELL_ROW_24_709 VGND VPWR sky130_fd_sc_hd__tapvpwrvgnd_1
XTAP_TAPCELL_ROW_66_1386 VGND VPWR sky130_fd_sc_hd__tapvpwrvgnd_1
X_07492_ cpuregs\[26\]\[10\] _02624_ _03568_ VGND VGND VPWR VPWR _00430_ sky130_fd_sc_hd__mux2_1
XFILLER_34_574 VPWR VGND VPWR VGND sky130_ef_sc_hd__decap_12
XFILLER_148_911 VGND VGND VPWR VPWR sky130_fd_sc_hd__fill_1
X_09231_ cpuregs\[1\]\[10\] _02624_ net244 VGND VGND VPWR VPWR _00928_ sky130_fd_sc_hd__mux2_1
X_06443_ _02806_ _02808_ _02863_ _02872_ _02873_ VGND VGND VPWR VPWR _02876_ sky130_fd_sc_hd__o2111ai_4
X_09162_ mem_rdata_q\[19\] mem_rdata_q\[18\] mem_rdata_q\[0\] mem_rdata_q\[1\] VGND
+ VGND VPWR VPWR _04780_ sky130_fd_sc_hd__or4bb_1
XFILLER_9_81 VPWR VGND VPWR VGND sky130_ef_sc_hd__decap_12
X_06374_ _02806_ _02807_ _02793_ _02797_ VGND VGND VPWR VPWR _02809_ sky130_fd_sc_hd__o211a_1
X_08113_ _03925_ _03926_ net34 VGND VGND VPWR VPWR _00694_ sky130_fd_sc_hd__o21a_1
X_05325_ cpu_state\[6\] _01860_ _01915_ _01919_ VGND VGND VPWR VPWR _01920_ sky130_fd_sc_hd__a31o_1
XFILLER_119_178 VGND VGND VPWR VPWR sky130_fd_sc_hd__decap_4
X_09093_ _01549_ _04746_ VGND VGND VPWR VPWR _04748_ sky130_fd_sc_hd__nor2_8
X_08044_ _03701_ _03839_ VGND VGND VPWR VPWR _03863_ sky130_fd_sc_hd__nor2_1
X_05256_ latched_is_lb latched_is_lh VGND VGND VPWR VPWR _01856_ sky130_fd_sc_hd__or2_4
X_05187_ _01779_ _01782_ _01790_ VGND VGND VPWR VPWR _01792_ sky130_fd_sc_hd__a21oi_1
XFILLER_135_15 VPWR VGND VPWR VGND sky130_ef_sc_hd__decap_12
XFILLER_131_833 VGND VGND VPWR VPWR sky130_fd_sc_hd__decap_6
XFILLER_115_384 VGND VGND VPWR VPWR sky130_fd_sc_hd__decap_8
X_09995_ clknet_leaf_49_clk _00125_ VGND VGND VPWR VPWR cpuregs\[12\]\[25\] sky130_fd_sc_hd__dfxtp_1
XFILLER_131_877 VPWR VGND VPWR VGND sky130_ef_sc_hd__decap_12
XFILLER_130_321 VPWR VGND VPWR VGND sky130_ef_sc_hd__decap_12
XTAP_TAPCELL_ROW_110_2085 VGND VPWR sky130_fd_sc_hd__tapvpwrvgnd_1
X_08946_ _04617_ _04621_ _04622_ net269 _00010_ VGND VGND VPWR VPWR _04623_ sky130_fd_sc_hd__a221o_1
XFILLER_130_365 VGND VGND VPWR VPWR sky130_fd_sc_hd__decap_3
XTAP_TAPCELL_ROW_110_2096 VGND VPWR sky130_fd_sc_hd__tapvpwrvgnd_1
XTAP_TAPCELL_ROW_4_401 VGND VPWR sky130_fd_sc_hd__tapvpwrvgnd_1
XFILLER_130_398 VGND VGND VPWR VPWR sky130_fd_sc_hd__decap_4
X_08877_ _04556_ _04557_ _04266_ _04554_ VGND VGND VPWR VPWR _04558_ sky130_fd_sc_hd__o211a_1
XFILLER_111_590 VGND VGND VPWR VPWR sky130_fd_sc_hd__fill_1
XFILLER_56_121 VGND VGND VPWR VPWR sky130_fd_sc_hd__decap_3
XTAP_TAPCELL_ROW_86_1707 VGND VPWR sky130_fd_sc_hd__tapvpwrvgnd_1
X_07828_ _02591_ reg_next_pc\[3\] _02482_ VGND VGND VPWR VPWR _03689_ sky130_fd_sc_hd__mux2_2
XFILLER_151_69 VPWR VGND VPWR VGND sky130_ef_sc_hd__decap_12
XFILLER_72_625 VGND VGND VPWR VPWR sky130_fd_sc_hd__decap_6
XFILLER_71_113 VGND VGND VPWR VPWR sky130_fd_sc_hd__decap_6
X_07759_ count_instr\[39\] _03644_ _03646_ VGND VGND VPWR VPWR _00620_ sky130_fd_sc_hd__o21a_1
XFILLER_60_809 VGND VGND VPWR VPWR sky130_fd_sc_hd__decap_3
XFILLER_53_861 VPWR VGND VPWR VGND sky130_ef_sc_hd__decap_12
X_10770_ clknet_leaf_66_clk alu_out\[23\] VGND VGND VPWR VPWR alu_out_q\[23\] sky130_fd_sc_hd__dfxtp_1
XFILLER_44_45 VGND VGND VPWR VPWR sky130_fd_sc_hd__fill_1
XFILLER_12_224 VGND VGND VPWR VPWR sky130_fd_sc_hd__decap_4
X_09429_ _02586_ cpuregs\[19\]\[0\] _04863_ VGND VGND VPWR VPWR _01062_ sky130_fd_sc_hd__mux2_1
XFILLER_40_544 VPWR VGND VPWR VGND sky130_ef_sc_hd__decap_12
XTAP_TAPCELL_ROW_117_2206 VGND VPWR sky130_fd_sc_hd__tapvpwrvgnd_1
XFILLER_9_729 VGND VGND VPWR VPWR sky130_fd_sc_hd__fill_1
XFILLER_153_413 VGND VGND VPWR VPWR sky130_fd_sc_hd__decap_3
XFILLER_20_290 VGND VGND VPWR VPWR sky130_fd_sc_hd__decap_4
X_11322_ clknet_leaf_70_clk _01369_ VGND VGND VPWR VPWR cpuregs\[5\]\[19\] sky130_fd_sc_hd__dfxtp_1
XTAP_TAPCELL_ROW_130_2417 VGND VPWR sky130_fd_sc_hd__tapvpwrvgnd_1
XTAP_TAPCELL_ROW_130_2406 VGND VPWR sky130_fd_sc_hd__tapvpwrvgnd_1
XFILLER_126_649 VGND VGND VPWR VPWR sky130_fd_sc_hd__fill_1
XFILLER_119_690 VPWR VGND VPWR VGND sky130_ef_sc_hd__decap_12
XFILLER_60_99 VGND VGND VPWR VPWR sky130_fd_sc_hd__fill_1
XFILLER_4_401 VPWR VGND VPWR VGND sky130_ef_sc_hd__decap_12
XFILLER_107_874 VGND VGND VPWR VPWR sky130_fd_sc_hd__fill_1
X_11253_ clknet_leaf_28_clk _01300_ VGND VGND VPWR VPWR cpuregs\[22\]\[14\] sky130_fd_sc_hd__dfxtp_1
XFILLER_5_39 VPWR VGND VPWR VGND sky130_ef_sc_hd__decap_12
XFILLER_4_445 VPWR VGND VPWR VGND sky130_ef_sc_hd__decap_12
X_10204_ clknet_leaf_13_clk _00334_ VGND VGND VPWR VPWR cpuregs\[14\]\[10\] sky130_fd_sc_hd__dfxtp_1
X_11184_ clknet_leaf_146_clk _01231_ VGND VGND VPWR VPWR cpuregs\[29\]\[9\] sky130_fd_sc_hd__dfxtp_1
XFILLER_121_376 VPWR VGND VPWR VGND sky130_ef_sc_hd__decap_12
XFILLER_94_205 VGND VGND VPWR VPWR sky130_fd_sc_hd__fill_2
XFILLER_79_279 VGND VGND VPWR VPWR sky130_fd_sc_hd__fill_1
XFILLER_0_673 VPWR VGND VPWR VGND sky130_ef_sc_hd__decap_12
X_10135_ clknet_leaf_140_clk _00265_ VGND VGND VPWR VPWR cpuregs\[21\]\[5\] sky130_fd_sc_hd__dfxtp_1
XFILLER_94_249 VGND VGND VPWR VPWR sky130_fd_sc_hd__decap_3
XFILLER_94_227 VGND VGND VPWR VPWR sky130_fd_sc_hd__fill_1
XTAP_TAPCELL_ROW_50_1132 VGND VPWR sky130_fd_sc_hd__tapvpwrvgnd_1
X_10066_ clknet_leaf_125_clk _00196_ VGND VGND VPWR VPWR cpuregs\[2\]\[0\] sky130_fd_sc_hd__dfxtp_1
XTAP_TAPCELL_ROW_128_2379 VGND VPWR sky130_fd_sc_hd__tapvpwrvgnd_1
XFILLER_75_452 VGND VGND VPWR VPWR sky130_fd_sc_hd__fill_2
XFILLER_75_496 VGND VGND VPWR VPWR sky130_fd_sc_hd__decap_3
XFILLER_63_625 VGND VGND VPWR VPWR sky130_fd_sc_hd__fill_1
XFILLER_48_699 VGND VGND VPWR VPWR sky130_fd_sc_hd__fill_1
XFILLER_62_135 VGND VGND VPWR VPWR sky130_fd_sc_hd__decap_4
X_10968_ clknet_leaf_127_clk _01030_ VGND VGND VPWR VPWR cpuregs\[18\]\[0\] sky130_fd_sc_hd__dfxtp_1
XFILLER_31_511 VGND VGND VPWR VPWR sky130_fd_sc_hd__fill_1
XTAP_TAPCELL_ROW_48_1094 VGND VPWR sky130_fd_sc_hd__tapvpwrvgnd_1
X_10899_ clknet_leaf_143_clk _00961_ VGND VGND VPWR VPWR net162 sky130_fd_sc_hd__dfxtp_1
XFILLER_8_773 VPWR VGND VPWR VGND sky130_ef_sc_hd__decap_12
X_05110_ _01719_ _01720_ cpu_state\[3\] VGND VGND VPWR VPWR _01721_ sky130_fd_sc_hd__and3b_1
XFILLER_144_446 VGND VGND VPWR VPWR sky130_fd_sc_hd__fill_1
XFILLER_116_137 VGND VGND VPWR VPWR sky130_fd_sc_hd__decap_3
X_06090_ cpuregs\[0\]\[4\] cpuregs\[1\]\[4\] cpuregs\[2\]\[4\] cpuregs\[3\]\[4\] net278
+ net273 VGND VGND VPWR VPWR _02561_ sky130_fd_sc_hd__mux4_1
X_05041_ _01637_ _01640_ cpu_state\[4\] VGND VGND VPWR VPWR _01660_ sky130_fd_sc_hd__o21a_2
XFILLER_98_533 VGND VGND VPWR VPWR sky130_fd_sc_hd__decap_8
XFILLER_98_522 VGND VGND VPWR VPWR sky130_fd_sc_hd__fill_2
XFILLER_140_641 VGND VGND VPWR VPWR sky130_fd_sc_hd__decap_3
X_08800_ _04476_ _04477_ _04481_ _04482_ _01558_ _01559_ VGND VGND VPWR VPWR _04485_
+ sky130_fd_sc_hd__mux4_1
X_09780_ _02665_ cpuregs\[7\]\[20\] _04874_ VGND VGND VPWR VPWR _01434_ sky130_fd_sc_hd__mux2_1
XFILLER_140_674 VGND VGND VPWR VPWR sky130_fd_sc_hd__fill_2
XFILLER_113_877 VPWR VGND VPWR VGND sky130_ef_sc_hd__decap_12
X_06992_ net192 net254 VGND VGND VPWR VPWR _03405_ sky130_fd_sc_hd__or2_1
XFILLER_100_516 VPWR VGND VPWR VGND sky130_ef_sc_hd__decap_12
XPHY_EDGE_ROW_7_Right_7 VGND VGND VPWR VPWR sky130_fd_sc_hd__decap_3
X_05943_ net108 net211 _01665_ VGND VGND VPWR VPWR net105 sky130_fd_sc_hd__mux2_1
XFILLER_85_249 VGND VGND VPWR VPWR sky130_fd_sc_hd__decap_8
X_08731_ _04418_ _04419_ _04266_ _04416_ VGND VGND VPWR VPWR _04420_ sky130_fd_sc_hd__o211a_1
XTAP_TAPCELL_ROW_68_1415 VGND VPWR sky130_fd_sc_hd__tapvpwrvgnd_1
X_08662_ _01558_ _04353_ VGND VGND VPWR VPWR _04354_ sky130_fd_sc_hd__or2_1
X_05874_ _02052_ _02425_ _02207_ VGND VGND VPWR VPWR _02431_ sky130_fd_sc_hd__o21ai_1
X_07613_ cpuregs\[20\]\[30\] _02709_ net245 VGND VGND VPWR VPWR _00546_ sky130_fd_sc_hd__mux2_1
XTAP_TAPCELL_ROW_68_1426 VGND VPWR sky130_fd_sc_hd__tapvpwrvgnd_1
XFILLER_66_474 VGND VGND VPWR VPWR sky130_fd_sc_hd__fill_2
XFILLER_53_113 VGND VGND VPWR VPWR sky130_fd_sc_hd__fill_1
XFILLER_27_839 VGND VGND VPWR VPWR sky130_fd_sc_hd__fill_1
XFILLER_54_669 VGND VGND VPWR VPWR sky130_fd_sc_hd__decap_4
X_08593_ _01558_ _04288_ VGND VGND VPWR VPWR _04289_ sky130_fd_sc_hd__or2_1
X_07544_ _02699_ cpuregs\[16\]\[28\] _03570_ VGND VGND VPWR VPWR _00480_ sky130_fd_sc_hd__mux2_1
XTAP_TAPCELL_ROW_81_1626 VGND VPWR sky130_fd_sc_hd__tapvpwrvgnd_1
XFILLER_35_861 VGND VGND VPWR VPWR sky130_fd_sc_hd__decap_3
XFILLER_41_319 VGND VGND VPWR VPWR sky130_fd_sc_hd__fill_1
X_07475_ cpuregs\[15\]\[26\] _02691_ net246 VGND VGND VPWR VPWR _00414_ sky130_fd_sc_hd__mux2_1
XFILLER_62_680 VPWR VGND VPWR VGND sky130_ef_sc_hd__decap_12
XFILLER_14_15 VPWR VGND VPWR VGND sky130_ef_sc_hd__decap_12
X_09214_ is_slli_srli_srai _04747_ _04797_ is_alu_reg_imm VGND VGND VPWR VPWR _00913_
+ sky130_fd_sc_hd__a22o_1
X_06426_ reg_pc\[4\] _02751_ _02859_ _02735_ _02715_ VGND VGND VPWR VPWR _02860_ sky130_fd_sc_hd__a221o_1
XFILLER_148_752 VGND VGND VPWR VPWR sky130_fd_sc_hd__decap_4
XFILLER_148_785 VPWR VGND VPWR VGND sky130_ef_sc_hd__decap_12
XFILLER_148_763 VGND VGND VPWR VPWR sky130_fd_sc_hd__fill_1
XFILLER_135_402 VGND VGND VPWR VPWR sky130_fd_sc_hd__decap_3
X_09145_ mem_rdata_q\[31\] mem_rdata_q\[29\] _04769_ mem_rdata_q\[30\] VGND VGND VPWR
+ VPWR _04773_ sky130_fd_sc_hd__and4bb_1
X_06357_ decoded_imm\[2\] net193 VGND VGND VPWR VPWR _02793_ sky130_fd_sc_hd__nand2_2
XFILLER_147_273 VGND VGND VPWR VPWR sky130_fd_sc_hd__decap_6
X_05308_ count_instr\[51\] instr_rdinstrh net257 _01903_ VGND VGND VPWR VPWR _01904_
+ sky130_fd_sc_hd__a211o_1
X_09076_ _01097_ _01095_ _01094_ VGND VGND VPWR VPWR _04738_ sky130_fd_sc_hd__nand3b_1
X_06288_ cpuregs\[0\]\[0\] cpuregs\[1\]\[0\] cpuregs\[2\]\[0\] cpuregs\[3\]\[0\] net264
+ net262 VGND VGND VPWR VPWR _02726_ sky130_fd_sc_hd__mux4_1
XFILLER_123_608 VGND VGND VPWR VPWR sky130_fd_sc_hd__decap_8
XTAP_TAPCELL_ROW_112_2125 VGND VPWR sky130_fd_sc_hd__tapvpwrvgnd_1
X_05239_ reg_pc\[14\] decoded_imm\[14\] VGND VGND VPWR VPWR _01840_ sky130_fd_sc_hd__or2_1
XTAP_TAPCELL_ROW_79_1599 VGND VPWR sky130_fd_sc_hd__tapvpwrvgnd_1
XTAP_TAPCELL_ROW_79_1588 VGND VPWR sky130_fd_sc_hd__tapvpwrvgnd_1
X_08027_ decoded_imm_j\[12\] _03699_ _03846_ VGND VGND VPWR VPWR _03847_ sky130_fd_sc_hd__a21o_1
XFILLER_2_905 VGND VGND VPWR VPWR sky130_fd_sc_hd__decap_4
XFILLER_89_522 VPWR VGND VPWR VGND sky130_ef_sc_hd__decap_12
XFILLER_104_866 VGND VGND VPWR VPWR sky130_fd_sc_hd__fill_2
XFILLER_89_555 VGND VGND VPWR VPWR sky130_fd_sc_hd__decap_4
XFILLER_1_437 VGND VGND VPWR VPWR sky130_fd_sc_hd__fill_2
XFILLER_104_888 VGND VGND VPWR VPWR sky130_fd_sc_hd__decap_4
XFILLER_103_376 VPWR VGND VPWR VGND sky130_ef_sc_hd__decap_12
XTAP_TAPCELL_ROW_92_1799 VGND VPWR sky130_fd_sc_hd__tapvpwrvgnd_1
XFILLER_77_717 VGND VGND VPWR VPWR sky130_fd_sc_hd__fill_2
X_09978_ clknet_leaf_136_clk _00108_ VGND VGND VPWR VPWR cpuregs\[12\]\[8\] sky130_fd_sc_hd__dfxtp_1
X_08929_ _01558_ _04599_ _04598_ _01560_ VGND VGND VPWR VPWR _04607_ sky130_fd_sc_hd__o211a_1
XFILLER_55_11 VPWR VGND VPWR VGND sky130_ef_sc_hd__decap_12
XFILLER_91_219 VGND VGND VPWR VPWR sky130_fd_sc_hd__decap_4
XFILLER_44_113 VGND VGND VPWR VPWR sky130_fd_sc_hd__decap_8
XFILLER_45_614 VGND VGND VPWR VPWR sky130_fd_sc_hd__fill_2
XFILLER_55_66 VGND VGND VPWR VPWR sky130_fd_sc_hd__fill_2
XFILLER_55_55 VGND VGND VPWR VPWR sky130_fd_sc_hd__fill_1
XFILLER_17_349 VGND VGND VPWR VPWR sky130_fd_sc_hd__decap_4
XFILLER_45_669 VGND VGND VPWR VPWR sky130_fd_sc_hd__decap_3
XTAP_TAPCELL_ROW_123_2298 VGND VPWR sky130_fd_sc_hd__tapvpwrvgnd_1
X_10822_ clknet_leaf_129_clk _00887_ VGND VGND VPWR VPWR decoded_imm_j\[5\] sky130_fd_sc_hd__dfxtp_1
XFILLER_13_500 VGND VGND VPWR VPWR sky130_fd_sc_hd__decap_4
XFILLER_26_861 VGND VGND VPWR VPWR sky130_fd_sc_hd__decap_6
XFILLER_44_157 VGND VGND VPWR VPWR sky130_fd_sc_hd__fill_1
XFILLER_111_61 VGND VGND VPWR VPWR sky130_fd_sc_hd__fill_1
X_10753_ clknet_leaf_134_clk alu_out\[6\] VGND VGND VPWR VPWR alu_out_q\[6\] sky130_fd_sc_hd__dfxtp_1
XFILLER_25_393 VPWR VGND VPWR VGND sky130_ef_sc_hd__decap_12
XTAP_TAPCELL_ROW_99_1909 VGND VPWR sky130_fd_sc_hd__tapvpwrvgnd_1
XFILLER_40_363 VGND VGND VPWR VPWR sky130_fd_sc_hd__fill_1
XFILLER_41_886 VGND VGND VPWR VPWR sky130_fd_sc_hd__decap_3
XFILLER_139_741 VGND VGND VPWR VPWR sky130_fd_sc_hd__decap_4
X_10684_ clknet_leaf_105_clk _00782_ VGND VGND VPWR VPWR net37 sky130_fd_sc_hd__dfxtp_1
XFILLER_9_559 VGND VGND VPWR VPWR sky130_fd_sc_hd__fill_1
XFILLER_40_374 VGND VGND VPWR VPWR sky130_fd_sc_hd__decap_8
XFILLER_41_897 VGND VGND VPWR VPWR sky130_fd_sc_hd__decap_8
XFILLER_139_785 VPWR VGND VPWR VGND sky130_ef_sc_hd__decap_12
XFILLER_139_774 VGND VGND VPWR VPWR sky130_fd_sc_hd__decap_8
XFILLER_153_221 VGND VGND VPWR VPWR sky130_fd_sc_hd__decap_3
XFILLER_126_457 VGND VGND VPWR VPWR sky130_fd_sc_hd__fill_1
X_11305_ clknet_leaf_120_clk _01352_ VGND VGND VPWR VPWR cpuregs\[5\]\[2\] sky130_fd_sc_hd__dfxtp_1
XFILLER_5_765 VPWR VGND VPWR VGND sky130_ef_sc_hd__decap_12
XFILLER_153_265 VPWR VGND VPWR VGND sky130_ef_sc_hd__decap_12
XFILLER_141_427 VPWR VGND VPWR VGND sky130_ef_sc_hd__decap_12
XFILLER_107_671 VGND VGND VPWR VPWR sky130_fd_sc_hd__fill_1
XFILLER_4_253 VGND VGND VPWR VPWR sky130_fd_sc_hd__decap_6
XFILLER_122_641 VGND VGND VPWR VPWR sky130_fd_sc_hd__decap_3
X_11236_ clknet_leaf_36_clk _01283_ VGND VGND VPWR VPWR cpuregs\[3\]\[29\] sky130_fd_sc_hd__dfxtp_1
XFILLER_4_286 VPWR VGND VPWR VGND sky130_ef_sc_hd__decap_12
XFILLER_20_91 VGND VGND VPWR VPWR sky130_fd_sc_hd__fill_1
X_11167_ clknet_leaf_69_clk _01214_ VGND VGND VPWR VPWR cpuregs\[23\]\[24\] sky130_fd_sc_hd__dfxtp_1
X_10118_ clknet_leaf_74_clk _00248_ VGND VGND VPWR VPWR cpuregs\[28\]\[20\] sky130_fd_sc_hd__dfxtp_1
XFILLER_110_836 VGND VGND VPWR VPWR sky130_fd_sc_hd__decap_3
XFILLER_95_558 VGND VGND VPWR VPWR sky130_fd_sc_hd__fill_2
XFILLER_67_238 VGND VGND VPWR VPWR sky130_fd_sc_hd__fill_1
XTAP_TAPCELL_ROW_143_2619 VGND VPWR sky130_fd_sc_hd__tapvpwrvgnd_1
X_11098_ clknet_leaf_34_clk _01155_ VGND VGND VPWR VPWR cpuregs\[24\]\[29\] sky130_fd_sc_hd__dfxtp_1
XFILLER_48_441 VGND VGND VPWR VPWR sky130_fd_sc_hd__decap_4
X_10049_ clknet_leaf_15_clk _00179_ VGND VGND VPWR VPWR cpuregs\[13\]\[15\] sky130_fd_sc_hd__dfxtp_1
XFILLER_35_113 VPWR VGND VPWR VGND sky130_ef_sc_hd__decap_12
XFILLER_63_488 VPWR VGND VPWR VGND sky130_ef_sc_hd__decap_12
X_05590_ _02130_ _02141_ _02160_ _02164_ VGND VGND VPWR VPWR _02173_ sky130_fd_sc_hd__and4b_1
XFILLER_149_505 VGND VGND VPWR VPWR sky130_fd_sc_hd__fill_1
XTAP_TAPCELL_ROW_63_1345 VGND VPWR sky130_fd_sc_hd__tapvpwrvgnd_1
XTAP_TAPCELL_ROW_63_1334 VGND VPWR sky130_fd_sc_hd__tapvpwrvgnd_1
XFILLER_16_382 VGND VGND VPWR VPWR sky130_fd_sc_hd__decap_4
XFILLER_91_3 VGND VGND VPWR VPWR sky130_fd_sc_hd__decap_3
XTAP_TAPCELL_ROW_14_550 VGND VPWR sky130_fd_sc_hd__tapvpwrvgnd_1
XTAP_TAPCELL_ROW_14_561 VGND VPWR sky130_fd_sc_hd__tapvpwrvgnd_1
X_07260_ cpuregs\[2\]\[11\] _02630_ net250 VGND VGND VPWR VPWR _00207_ sky130_fd_sc_hd__mux2_1
XFILLER_31_385 VGND VGND VPWR VPWR sky130_fd_sc_hd__decap_6
X_06211_ _02658_ _02661_ _02584_ VGND VGND VPWR VPWR _02662_ sky130_fd_sc_hd__mux2_8
X_07191_ cpuregs\[30\]\[9\] _02621_ net252 VGND VGND VPWR VPWR _00141_ sky130_fd_sc_hd__mux2_1
X_06142_ reg_pc\[6\] _02601_ _02584_ VGND VGND VPWR VPWR _02606_ sky130_fd_sc_hd__o21a_1
X_06073_ _02543_ _02544_ _01558_ VGND VGND VPWR VPWR _02545_ sky130_fd_sc_hd__mux2_1
X_05024_ _01643_ _01646_ VGND VGND VPWR VPWR _01647_ sky130_fd_sc_hd__nor2_1
X_09901_ cpuregs\[0\]\[31\] VGND VGND VPWR VPWR _01509_ sky130_fd_sc_hd__clkbuf_1
XFILLER_113_641 VGND VGND VPWR VPWR sky130_fd_sc_hd__fill_1
XFILLER_113_652 VGND VGND VPWR VPWR sky130_fd_sc_hd__decap_3
XFILLER_99_897 VGND VGND VPWR VPWR sky130_fd_sc_hd__decap_3
X_09832_ _02607_ cpuregs\[10\]\[6\] _04876_ VGND VGND VPWR VPWR _01516_ sky130_fd_sc_hd__mux2_1
XFILLER_86_525 VGND VGND VPWR VPWR sky130_fd_sc_hd__decap_6
XFILLER_58_249 VGND VGND VPWR VPWR sky130_fd_sc_hd__decap_3
X_09763_ _02593_ cpuregs\[7\]\[3\] _04874_ VGND VGND VPWR VPWR _01417_ sky130_fd_sc_hd__mux2_1
X_06975_ cpuregs\[0\]\[24\] cpuregs\[1\]\[24\] cpuregs\[2\]\[24\] cpuregs\[3\]\[24\]
+ net267 net261 VGND VGND VPWR VPWR _03389_ sky130_fd_sc_hd__mux4_1
XFILLER_132_27 VGND VGND VPWR VPWR sky130_fd_sc_hd__fill_1
XFILLER_100_346 VGND VGND VPWR VPWR sky130_fd_sc_hd__fill_2
X_08714_ net206 _01585_ _04402_ _04403_ VGND VGND VPWR VPWR _00818_ sky130_fd_sc_hd__o22a_1
XFILLER_67_783 VGND VGND VPWR VPWR sky130_fd_sc_hd__fill_1
X_05926_ mem_wordsize\[1\] net97 net233 mem_wordsize\[2\] VGND VGND VPWR VPWR _02474_
+ sky130_fd_sc_hd__a22o_1
Xrebuffer10 _04068_ VGND VGND VPWR VPWR net396 sky130_fd_sc_hd__dlygate4sd1_1
X_09694_ _02586_ cpuregs\[5\]\[0\] _04872_ VGND VGND VPWR VPWR _01350_ sky130_fd_sc_hd__mux2_1
Xrebuffer21 net405 VGND VGND VPWR VPWR net407 sky130_fd_sc_hd__dlygate4sd1_1
X_05857_ _02363_ _02415_ _02397_ _02379_ VGND VGND VPWR VPWR _02416_ sky130_fd_sc_hd__o2bb2a_1
Xrebuffer43 net430 VGND VGND VPWR VPWR net429 sky130_fd_sc_hd__dlygate4sd1_1
Xrebuffer54 net441 VGND VGND VPWR VPWR net440 sky130_fd_sc_hd__dlygate4sd1_1
Xrebuffer32 _03585_ VGND VGND VPWR VPWR net418 sky130_fd_sc_hd__dlygate4sd1_1
XFILLER_15_809 VPWR VGND VPWR VGND sky130_ef_sc_hd__decap_12
X_08645_ cpuregs\[28\]\[9\] cpuregs\[29\]\[9\] cpuregs\[30\]\[9\] cpuregs\[31\]\[9\]
+ net278 net273 VGND VGND VPWR VPWR _04338_ sky130_fd_sc_hd__mux4_1
XFILLER_82_786 VGND VGND VPWR VPWR sky130_fd_sc_hd__decap_6
XFILLER_81_252 VGND VGND VPWR VPWR sky130_fd_sc_hd__decap_6
Xrebuffer65 _04073_ VGND VGND VPWR VPWR net451 sky130_fd_sc_hd__dlygate4sd1_1
X_08576_ _01558_ _04270_ _01560_ VGND VGND VPWR VPWR _04273_ sky130_fd_sc_hd__o21a_1
X_05788_ instr_sub _02112_ VGND VGND VPWR VPWR _02354_ sky130_fd_sc_hd__nor2_1
X_07527_ _02630_ cpuregs\[16\]\[11\] _03570_ VGND VGND VPWR VPWR _00463_ sky130_fd_sc_hd__mux2_1
XFILLER_23_853 VPWR VGND VPWR VGND sky130_ef_sc_hd__decap_12
XFILLER_23_897 VPWR VGND VPWR VGND sky130_ef_sc_hd__decap_12
X_07458_ cpuregs\[15\]\[9\] _02621_ net246 VGND VGND VPWR VPWR _00397_ sky130_fd_sc_hd__mux2_1
X_07389_ cpuregs\[14\]\[7\] _02612_ net247 VGND VGND VPWR VPWR _00331_ sky130_fd_sc_hd__mux2_1
X_06409_ cpuregs\[24\]\[4\] cpuregs\[25\]\[4\] cpuregs\[26\]\[4\] cpuregs\[27\]\[4\]
+ net264 net262 VGND VGND VPWR VPWR _02843_ sky130_fd_sc_hd__mux4_1
XFILLER_41_35 VPWR VGND VPWR VGND sky130_ef_sc_hd__decap_12
XFILLER_108_413 VGND VGND VPWR VPWR sky130_fd_sc_hd__decap_6
X_09128_ instr_addi _04748_ _04749_ _04765_ VGND VGND VPWR VPWR _00861_ sky130_fd_sc_hd__a22o_1
XTAP_TAPCELL_ROW_94_1839 VGND VPWR sky130_fd_sc_hd__tapvpwrvgnd_1
XTAP_TAPCELL_ROW_94_1828 VGND VPWR sky130_fd_sc_hd__tapvpwrvgnd_1
Xrebuffer188 net575 VGND VGND VPWR VPWR net574 sky130_fd_sc_hd__dlygate4sd1_1
Xrebuffer199 _04068_ VGND VGND VPWR VPWR net585 sky130_fd_sc_hd__clkbuf_2
XFILLER_151_714 VPWR VGND VPWR VGND sky130_ef_sc_hd__decap_12
XFILLER_135_287 VGND VGND VPWR VPWR sky130_fd_sc_hd__fill_1
X_09059_ decoded_imm\[31\] _01654_ _01586_ VGND VGND VPWR VPWR _04730_ sky130_fd_sc_hd__a21o_1
XFILLER_2_713 VPWR VGND VPWR VGND sky130_ef_sc_hd__decap_12
XFILLER_2_757 VPWR VGND VPWR VGND sky130_ef_sc_hd__decap_12
XFILLER_1_223 VGND VGND VPWR VPWR sky130_fd_sc_hd__fill_1
X_11021_ clknet_leaf_76_clk _01083_ VGND VGND VPWR VPWR cpuregs\[19\]\[21\] sky130_fd_sc_hd__dfxtp_1
XFILLER_104_674 VGND VGND VPWR VPWR sky130_fd_sc_hd__fill_1
XFILLER_77_525 VGND VGND VPWR VPWR sky130_fd_sc_hd__fill_2
XFILLER_2_29 VPWR VGND VPWR VGND sky130_ef_sc_hd__decap_12
XFILLER_106_83 VGND VGND VPWR VPWR sky130_fd_sc_hd__fill_1
XFILLER_46_901 VGND VGND VPWR VPWR sky130_fd_sc_hd__fill_1
XTAP_TAPCELL_ROW_125_2338 VGND VPWR sky130_fd_sc_hd__tapvpwrvgnd_1
XTAP_TAPCELL_ROW_125_2327 VGND VPWR sky130_fd_sc_hd__tapvpwrvgnd_1
XFILLER_66_65 VPWR VGND VPWR VGND sky130_ef_sc_hd__decap_12
XFILLER_73_764 VPWR VGND VPWR VGND sky130_ef_sc_hd__decap_12
XFILLER_17_113 VPWR VGND VPWR VGND sky130_ef_sc_hd__decap_12
X_10805_ clknet_leaf_99_clk _00870_ VGND VGND VPWR VPWR instr_add sky130_fd_sc_hd__dfxtp_1
XTAP_TAPCELL_ROW_103_1979 VGND VPWR sky130_fd_sc_hd__tapvpwrvgnd_1
XFILLER_41_661 VGND VGND VPWR VPWR sky130_fd_sc_hd__fill_2
XTAP_TAPCELL_ROW_45_1053 VGND VPWR sky130_fd_sc_hd__tapvpwrvgnd_1
X_10736_ clknet_leaf_50_clk _00833_ VGND VGND VPWR VPWR net222 sky130_fd_sc_hd__dfxtp_4
XTAP_TAPCELL_ROW_31_829 VGND VPWR sky130_fd_sc_hd__tapvpwrvgnd_1
X_10667_ clknet_leaf_64_clk _04895_ VGND VGND VPWR VPWR reg_out\[25\] sky130_fd_sc_hd__dfxtp_1
XFILLER_9_356 VGND VGND VPWR VPWR sky130_fd_sc_hd__decap_4
XFILLER_40_182 VPWR VGND VPWR VGND sky130_ef_sc_hd__decap_12
XFILLER_9_389 VGND VGND VPWR VPWR sky130_fd_sc_hd__decap_3
XTAP_TAPCELL_ROW_153_2792 VGND VPWR sky130_fd_sc_hd__tapvpwrvgnd_1
XTAP_TAPCELL_ROW_153_2781 VGND VPWR sky130_fd_sc_hd__tapvpwrvgnd_1
X_10598_ clknet_leaf_89_clk _00728_ VGND VGND VPWR VPWR count_cycle\[21\] sky130_fd_sc_hd__dfxtp_1
XFILLER_5_573 VPWR VGND VPWR VGND sky130_ef_sc_hd__decap_12
Xoutput108 net108 VGND VGND VPWR VPWR mem_la_wdata[1] sky130_fd_sc_hd__buf_2
Xoutput119 net119 VGND VGND VPWR VPWR mem_la_wdata[2] sky130_fd_sc_hd__buf_2
XFILLER_99_127 VGND VGND VPWR VPWR sky130_fd_sc_hd__fill_2
XFILLER_141_279 VGND VGND VPWR VPWR sky130_fd_sc_hd__fill_1
X_11219_ clknet_leaf_6_clk _01266_ VGND VGND VPWR VPWR cpuregs\[3\]\[12\] sky130_fd_sc_hd__dfxtp_1
XFILLER_68_536 VGND VGND VPWR VPWR sky130_fd_sc_hd__fill_1
Xoutput90 net90 VGND VGND VPWR VPWR mem_la_addr[4] sky130_fd_sc_hd__buf_2
XFILLER_95_366 VGND VGND VPWR VPWR sky130_fd_sc_hd__decap_3
XFILLER_49_750 VGND VGND VPWR VPWR sky130_fd_sc_hd__decap_8
XFILLER_110_688 VGND VGND VPWR VPWR sky130_fd_sc_hd__fill_1
X_06760_ _03173_ _03174_ _01579_ VGND VGND VPWR VPWR _03182_ sky130_fd_sc_hd__mux2_1
X_06691_ cpuregs\[4\]\[14\] cpuregs\[5\]\[14\] cpuregs\[6\]\[14\] cpuregs\[7\]\[14\]
+ net265 net260 VGND VGND VPWR VPWR _03115_ sky130_fd_sc_hd__mux4_1
XFILLER_64_742 VPWR VGND VPWR VGND sky130_ef_sc_hd__decap_12
X_05711_ _02158_ _02281_ _02159_ VGND VGND VPWR VPWR _02286_ sky130_fd_sc_hd__a21boi_1
XTAP_TAPCELL_ROW_19_631 VGND VPWR sky130_fd_sc_hd__tapvpwrvgnd_1
X_08430_ _04167_ _04168_ VGND VGND VPWR VPWR _00769_ sky130_fd_sc_hd__nor2_1
X_05642_ net191 _01575_ _02075_ _02224_ VGND VGND VPWR VPWR _02225_ sky130_fd_sc_hd__a31o_1
XTAP_TAPCELL_ROW_19_642 VGND VPWR sky130_fd_sc_hd__tapvpwrvgnd_1
X_05573_ _02154_ _02155_ VGND VGND VPWR VPWR _02156_ sky130_fd_sc_hd__nor2_1
X_08361_ count_cycle\[37\] _04123_ net34 VGND VGND VPWR VPWR _04125_ sky130_fd_sc_hd__o21ai_1
X_07312_ cpuregs\[28\]\[30\] _02709_ net249 VGND VGND VPWR VPWR _00258_ sky130_fd_sc_hd__mux2_1
X_08292_ count_cycle\[13\] net411 _01549_ VGND VGND VPWR VPWR _04080_ sky130_fd_sc_hd__a21oi_1
X_07243_ cpuregs\[13\]\[27\] _02696_ net251 VGND VGND VPWR VPWR _00191_ sky130_fd_sc_hd__mux2_1
XFILLER_20_867 VGND VGND VPWR VPWR sky130_fd_sc_hd__fill_1
X_07174_ cpuregs\[12\]\[28\] _02699_ net253 VGND VGND VPWR VPWR _00128_ sky130_fd_sc_hd__mux2_1
XFILLER_118_777 VPWR VGND VPWR VGND sky130_ef_sc_hd__decap_12
XFILLER_11_27 VPWR VGND VPWR VGND sky130_ef_sc_hd__decap_12
XFILLER_145_585 VPWR VGND VPWR VGND sky130_ef_sc_hd__decap_12
XFILLER_127_27 VPWR VGND VPWR VGND sky130_ef_sc_hd__decap_12
XTAP_TAPCELL_ROW_76_1547 VGND VPWR sky130_fd_sc_hd__tapvpwrvgnd_1
X_06125_ reg_pc\[3\] reg_pc\[2\] VGND VGND VPWR VPWR _02592_ sky130_fd_sc_hd__xor2_1
X_06056_ _01558_ _02528_ VGND VGND VPWR VPWR _02529_ sky130_fd_sc_hd__or2_1
XFILLER_120_419 VGND VGND VPWR VPWR sky130_fd_sc_hd__fill_1
X_05007_ instr_jal _01589_ VGND VGND VPWR VPWR _00001_ sky130_fd_sc_hd__or2_1
XFILLER_143_15 VPWR VGND VPWR VGND sky130_ef_sc_hd__decap_12
X_09815_ _02675_ cpuregs\[8\]\[22\] _04875_ VGND VGND VPWR VPWR _01468_ sky130_fd_sc_hd__mux2_1
XFILLER_101_633 VGND VGND VPWR VPWR sky130_fd_sc_hd__fill_1
XFILLER_98_160 VGND VGND VPWR VPWR sky130_fd_sc_hd__decap_8
X_09746_ _02662_ cpuregs\[6\]\[19\] _04873_ VGND VGND VPWR VPWR _01401_ sky130_fd_sc_hd__mux2_1
X_06958_ _03322_ _03369_ _03371_ _03267_ VGND VGND VPWR VPWR _03372_ sky130_fd_sc_hd__o22a_1
XFILLER_86_377 VPWR VGND VPWR VGND sky130_ef_sc_hd__decap_12
XFILLER_39_260 VPWR VGND VPWR VGND sky130_ef_sc_hd__decap_12
XTAP_TAPCELL_ROW_107_2046 VGND VPWR sky130_fd_sc_hd__tapvpwrvgnd_1
X_05909_ _02070_ _02461_ VGND VGND VPWR VPWR _02462_ sky130_fd_sc_hd__nand2_1
X_09677_ cpuregs\[4\]\[16\] _02649_ net238 VGND VGND VPWR VPWR _01334_ sky130_fd_sc_hd__mux2_1
XTAP_TAPCELL_ROW_38_940 VGND VPWR sky130_fd_sc_hd__tapvpwrvgnd_1
X_06889_ cpuregs\[28\]\[21\] cpuregs\[29\]\[21\] cpuregs\[30\]\[21\] cpuregs\[31\]\[21\]
+ _00012_ _00013_ VGND VGND VPWR VPWR _03306_ sky130_fd_sc_hd__mux4_1
XFILLER_15_606 VGND VGND VPWR VPWR sky130_fd_sc_hd__fill_1
XFILLER_15_617 VPWR VGND VPWR VGND sky130_ef_sc_hd__decap_12
X_08628_ cpuregs\[4\]\[8\] cpuregs\[5\]\[8\] cpuregs\[6\]\[8\] cpuregs\[7\]\[8\] net278
+ net273 VGND VGND VPWR VPWR _04322_ sky130_fd_sc_hd__mux4_1
XFILLER_36_79 VGND VGND VPWR VPWR sky130_fd_sc_hd__decap_4
XTAP_TAPCELL_ROW_120_2246 VGND VPWR sky130_fd_sc_hd__tapvpwrvgnd_1
XFILLER_55_797 VPWR VGND VPWR VGND sky130_ef_sc_hd__decap_12
XFILLER_42_414 VGND VGND VPWR VPWR sky130_fd_sc_hd__decap_6
XTAP_TAPCELL_ROW_120_2257 VGND VPWR sky130_fd_sc_hd__tapvpwrvgnd_1
X_08559_ _01653_ _02556_ VGND VGND VPWR VPWR _04258_ sky130_fd_sc_hd__nand2_1
XFILLER_139_3 VPWR VGND VPWR VGND sky130_ef_sc_hd__decap_12
XFILLER_109_700 VGND VGND VPWR VPWR sky130_fd_sc_hd__fill_1
X_10521_ clknet_leaf_130_clk _00651_ VGND VGND VPWR VPWR reg_pc\[7\] sky130_fd_sc_hd__dfxtp_1
XFILLER_22_182 VGND VGND VPWR VPWR sky130_fd_sc_hd__fill_2
XFILLER_22_193 VGND VGND VPWR VPWR sky130_fd_sc_hd__decap_3
XFILLER_11_889 VGND VGND VPWR VPWR sky130_fd_sc_hd__decap_6
XFILLER_109_744 VGND VGND VPWR VPWR sky130_fd_sc_hd__fill_2
X_10452_ clknet_leaf_110_clk _00582_ VGND VGND VPWR VPWR count_instr\[1\] sky130_fd_sc_hd__dfxtp_2
X_10383_ clknet_leaf_34_clk _00513_ VGND VGND VPWR VPWR cpuregs\[25\]\[29\] sky130_fd_sc_hd__dfxtp_1
XFILLER_123_279 VGND VGND VPWR VPWR sky130_fd_sc_hd__fill_1
XFILLER_2_587 VGND VGND VPWR VPWR sky130_fd_sc_hd__fill_1
X_11004_ clknet_leaf_138_clk _01066_ VGND VGND VPWR VPWR cpuregs\[19\]\[4\] sky130_fd_sc_hd__dfxtp_1
XFILLER_78_867 VGND VGND VPWR VPWR sky130_fd_sc_hd__fill_1
XFILLER_77_388 VGND VGND VPWR VPWR sky130_fd_sc_hd__decap_4
XFILLER_37_208 VPWR VGND VPWR VGND sky130_ef_sc_hd__decap_12
XFILLER_18_477 VGND VGND VPWR VPWR sky130_fd_sc_hd__decap_8
XFILLER_34_904 VGND VGND VPWR VPWR sky130_fd_sc_hd__decap_4
XFILLER_73_583 VPWR VGND VPWR VGND sky130_ef_sc_hd__decap_12
X_10719_ clknet_leaf_17_clk _00816_ VGND VGND VPWR VPWR net204 sky130_fd_sc_hd__dfxtp_4
XFILLER_147_839 VGND VGND VPWR VPWR sky130_fd_sc_hd__fill_1
Xrebuffer1 cpu_state\[1\] VGND VGND VPWR VPWR net387 sky130_fd_sc_hd__dlygate4sd1_1
XTAP_TAPCELL_ROW_58_1266 VGND VPWR sky130_fd_sc_hd__tapvpwrvgnd_1
XTAP_TAPCELL_ROW_58_1255 VGND VPWR sky130_fd_sc_hd__tapvpwrvgnd_1
XFILLER_6_893 VPWR VGND VPWR VGND sky130_ef_sc_hd__decap_12
XFILLER_102_408 VPWR VGND VPWR VGND sky130_ef_sc_hd__decap_12
X_07930_ _03691_ _03692_ _03738_ VGND VGND VPWR VPWR _03758_ sky130_fd_sc_hd__and3_1
X_07861_ _02658_ reg_next_pc\[19\] net597 VGND VGND VPWR VPWR _03706_ sky130_fd_sc_hd__mux2_2
XFILLER_96_653 VGND VGND VPWR VPWR sky130_fd_sc_hd__fill_2
XTAP_TAPCELL_ROW_71_1466 VGND VPWR sky130_fd_sc_hd__tapvpwrvgnd_1
XFILLER_68_344 VGND VGND VPWR VPWR sky130_fd_sc_hd__fill_2
X_06812_ _03228_ _03229_ _01579_ VGND VGND VPWR VPWR _03232_ sky130_fd_sc_hd__mux2_1
X_07792_ count_instr\[51\] _03664_ count_instr\[52\] VGND VGND VPWR VPWR _03667_ sky130_fd_sc_hd__a21o_1
X_09600_ _02607_ cpuregs\[3\]\[6\] _04868_ VGND VGND VPWR VPWR _01260_ sky130_fd_sc_hd__mux2_1
X_06743_ _03157_ _03159_ _03162_ _03164_ VGND VGND VPWR VPWR _03165_ sky130_fd_sc_hd__nand4_1
X_09531_ cpuregs\[23\]\[3\] _02593_ _04866_ VGND VGND VPWR VPWR _01193_ sky130_fd_sc_hd__mux2_1
XFILLER_52_701 VGND VGND VPWR VPWR sky130_fd_sc_hd__decap_4
XFILLER_36_230 VGND VGND VPWR VPWR sky130_fd_sc_hd__decap_6
X_06674_ cpuregs\[12\]\[13\] cpuregs\[13\]\[13\] cpuregs\[14\]\[13\] cpuregs\[15\]\[13\]
+ net265 net260 VGND VGND VPWR VPWR _03099_ sky130_fd_sc_hd__mux4_1
XFILLER_52_745 VGND VGND VPWR VPWR sky130_fd_sc_hd__decap_3
X_09462_ cpuregs\[24\]\[0\] _02586_ net243 VGND VGND VPWR VPWR _01126_ sky130_fd_sc_hd__mux2_1
X_05625_ net221 net189 VGND VGND VPWR VPWR _02208_ sky130_fd_sc_hd__nand2b_1
X_08413_ count_cycle\[56\] _04154_ count_cycle\[57\] VGND VGND VPWR VPWR _04157_ sky130_fd_sc_hd__a21o_1
X_09393_ instr_jal decoded_imm_j\[1\] _04822_ mem_rdata_q\[8\] _04747_ VGND VGND VPWR
+ VPWR _04861_ sky130_fd_sc_hd__a221o_1
X_08344_ count_cycle\[29\] _04109_ count_cycle\[31\] count_cycle\[30\] VGND VGND VPWR
+ VPWR _04114_ sky130_fd_sc_hd__and4_4
X_05556_ net197 net123 VGND VGND VPWR VPWR _02139_ sky130_fd_sc_hd__and2_1
XFILLER_22_15 VPWR VGND VPWR VGND sky130_ef_sc_hd__decap_12
XFILLER_138_15 VPWR VGND VPWR VGND sky130_ef_sc_hd__decap_12
XFILLER_137_305 VGND VGND VPWR VPWR sky130_fd_sc_hd__decap_3
X_05487_ _02068_ _02069_ VGND VGND VPWR VPWR _02070_ sky130_fd_sc_hd__nor2_1
X_08275_ net396 _04069_ VGND VGND VPWR VPWR _00713_ sky130_fd_sc_hd__nor2_1
X_07226_ cpuregs\[13\]\[10\] _02624_ net251 VGND VGND VPWR VPWR _00174_ sky130_fd_sc_hd__mux2_1
XFILLER_146_861 VGND VGND VPWR VPWR sky130_fd_sc_hd__decap_6
X_07157_ cpuregs\[12\]\[11\] _02630_ net253 VGND VGND VPWR VPWR _00111_ sky130_fd_sc_hd__mux2_1
XFILLER_145_393 VGND VGND VPWR VPWR sky130_fd_sc_hd__decap_6
XFILLER_145_382 VGND VGND VPWR VPWR sky130_fd_sc_hd__decap_8
X_06108_ _02577_ _02578_ _02559_ VGND VGND VPWR VPWR _00006_ sky130_fd_sc_hd__a21oi_1
X_07088_ _03489_ _03496_ _03497_ _01581_ _01580_ VGND VGND VPWR VPWR _03498_ sky130_fd_sc_hd__a221o_1
X_06039_ mem_rdata_q\[19\] net11 _01609_ VGND VGND VPWR VPWR _01113_ sky130_fd_sc_hd__mux2_1
XFILLER_120_249 VGND VGND VPWR VPWR sky130_fd_sc_hd__decap_3
XFILLER_86_141 VGND VGND VPWR VPWR sky130_fd_sc_hd__decap_6
XFILLER_86_163 VGND VGND VPWR VPWR sky130_fd_sc_hd__decap_4
XTAP_TAPCELL_ROW_89_1749 VGND VPWR sky130_fd_sc_hd__tapvpwrvgnd_1
XFILLER_74_325 VGND VGND VPWR VPWR sky130_fd_sc_hd__fill_1
XFILLER_59_399 VPWR VGND VPWR VGND sky130_ef_sc_hd__decap_12
X_09729_ _02590_ cpuregs\[6\]\[2\] _04873_ VGND VGND VPWR VPWR _01384_ sky130_fd_sc_hd__mux2_1
XFILLER_47_539 VGND VGND VPWR VPWR sky130_fd_sc_hd__decap_3
XFILLER_55_561 VGND VGND VPWR VPWR sky130_fd_sc_hd__decap_6
XTAP_TAPCELL_ROW_2_362 VGND VPWR sky130_fd_sc_hd__tapvpwrvgnd_1
XFILLER_70_531 VGND VGND VPWR VPWR sky130_fd_sc_hd__fill_1
XFILLER_63_44 VPWR VGND VPWR VGND sky130_ef_sc_hd__decap_12
XFILLER_43_767 VGND VGND VPWR VPWR sky130_fd_sc_hd__decap_4
XTAP_TAPCELL_ROW_100_1927 VGND VPWR sky130_fd_sc_hd__tapvpwrvgnd_1
XFILLER_70_586 VGND VGND VPWR VPWR sky130_fd_sc_hd__fill_2
XFILLER_63_77 VGND VGND VPWR VPWR sky130_fd_sc_hd__decap_8
XFILLER_30_417 VGND VGND VPWR VPWR sky130_fd_sc_hd__decap_3
XTAP_TAPCELL_ROW_42_1001 VGND VPWR sky130_fd_sc_hd__tapvpwrvgnd_1
XTAP_TAPCELL_ROW_100_1938 VGND VPWR sky130_fd_sc_hd__tapvpwrvgnd_1
XFILLER_129_839 VGND VGND VPWR VPWR sky130_fd_sc_hd__fill_1
XFILLER_10_141 VGND VGND VPWR VPWR sky130_fd_sc_hd__decap_8
X_11484_ clknet_leaf_23_clk _01528_ VGND VGND VPWR VPWR cpuregs\[10\]\[18\] sky130_fd_sc_hd__dfxtp_1
X_10504_ clknet_leaf_83_clk _00634_ VGND VGND VPWR VPWR count_instr\[53\] sky130_fd_sc_hd__dfxtp_1
XTAP_TAPCELL_ROW_21_670 VGND VPWR sky130_fd_sc_hd__tapvpwrvgnd_1
XTAP_TAPCELL_ROW_133_2459 VGND VPWR sky130_fd_sc_hd__tapvpwrvgnd_1
X_10435_ clknet_leaf_53_clk _00565_ VGND VGND VPWR VPWR cpuregs\[17\]\[17\] sky130_fd_sc_hd__dfxtp_1
XFILLER_124_533 VGND VGND VPWR VPWR sky130_fd_sc_hd__decap_8
XFILLER_6_189 VGND VGND VPWR VPWR sky130_fd_sc_hd__decap_6
XFILLER_97_417 VPWR VGND VPWR VGND sky130_ef_sc_hd__decap_12
XFILLER_88_41 VPWR VGND VPWR VGND sky130_ef_sc_hd__decap_12
X_10366_ clknet_leaf_11_clk _00496_ VGND VGND VPWR VPWR cpuregs\[25\]\[12\] sky130_fd_sc_hd__dfxtp_1
XFILLER_3_841 VPWR VGND VPWR VGND sky130_ef_sc_hd__decap_12
XFILLER_88_85 VGND VGND VPWR VPWR sky130_fd_sc_hd__decap_4
XFILLER_2_351 VPWR VGND VPWR VGND sky130_ef_sc_hd__decap_12
X_10297_ clknet_leaf_145_clk _00427_ VGND VGND VPWR VPWR cpuregs\[26\]\[7\] sky130_fd_sc_hd__dfxtp_1
XFILLER_120_750 VGND VGND VPWR VPWR sky130_fd_sc_hd__decap_6
XTAP_TAPCELL_ROW_53_1174 VGND VPWR sky130_fd_sc_hd__tapvpwrvgnd_1
XFILLER_78_675 VGND VGND VPWR VPWR sky130_fd_sc_hd__decap_4
XTAP_TAPCELL_ROW_53_1185 VGND VPWR sky130_fd_sc_hd__tapvpwrvgnd_1
XFILLER_92_133 VGND VGND VPWR VPWR sky130_fd_sc_hd__decap_6
XFILLER_80_317 VGND VGND VPWR VPWR sky130_fd_sc_hd__fill_2
XFILLER_19_797 VPWR VGND VPWR VGND sky130_ef_sc_hd__decap_12
XFILLER_73_391 VGND VGND VPWR VPWR sky130_fd_sc_hd__fill_1
XTAP_TAPCELL_ROW_29_792 VGND VPWR sky130_fd_sc_hd__tapvpwrvgnd_1
X_05410_ count_instr\[59\] instr_rdinstrh _01587_ _01997_ VGND VGND VPWR VPWR _01998_
+ sky130_fd_sc_hd__a211o_1
X_06390_ net262 _02822_ _01579_ VGND VGND VPWR VPWR _02825_ sky130_fd_sc_hd__o21a_1
XFILLER_119_316 VGND VGND VPWR VPWR sky130_fd_sc_hd__decap_4
X_05341_ _01922_ _01925_ _01933_ VGND VGND VPWR VPWR _01934_ sky130_fd_sc_hd__a21oi_1
XFILLER_135_809 VPWR VGND VPWR VGND sky130_ef_sc_hd__decap_12
XFILLER_119_349 VGND VGND VPWR VPWR sky130_fd_sc_hd__fill_1
X_05272_ count_instr\[48\] instr_rdinstrh instr_rdinstr count_instr\[16\] VGND VGND
+ VPWR VPWR _01871_ sky130_fd_sc_hd__a22o_1
X_08060_ _01547_ reg_next_pc\[15\] _01645_ _03702_ VGND VGND VPWR VPWR _03878_ sky130_fd_sc_hd__a22o_1
Xpicorv32_311 VGND VGND VPWR VPWR picorv32_311/HI eoi[30] sky130_fd_sc_hd__conb_1
Xpicorv32_300 VGND VGND VPWR VPWR picorv32_300/HI eoi[19] sky130_fd_sc_hd__conb_1
XFILLER_128_861 VGND VGND VPWR VPWR sky130_fd_sc_hd__decap_6
X_07011_ net189 _02725_ VGND VGND VPWR VPWR _03423_ sky130_fd_sc_hd__and2_1
XFILLER_108_29 VPWR VGND VPWR VGND sky130_ef_sc_hd__decap_12
XTAP_TAPCELL_ROW_73_1506 VGND VPWR sky130_fd_sc_hd__tapvpwrvgnd_1
Xpicorv32_344 VGND VGND VPWR VPWR picorv32_344/HI pcpi_insn[27] sky130_fd_sc_hd__conb_1
Xpicorv32_333 VGND VGND VPWR VPWR picorv32_333/HI pcpi_insn[16] sky130_fd_sc_hd__conb_1
Xpicorv32_322 VGND VGND VPWR VPWR picorv32_322/HI pcpi_insn[5] sky130_fd_sc_hd__conb_1
XFILLER_143_853 VPWR VGND VPWR VGND sky130_ef_sc_hd__decap_12
XFILLER_142_330 VGND VGND VPWR VPWR sky130_fd_sc_hd__decap_8
Xpicorv32_377 VGND VGND VPWR VPWR picorv32_377/HI trace_data[27] sky130_fd_sc_hd__conb_1
Xpicorv32_366 VGND VGND VPWR VPWR picorv32_366/HI trace_data[16] sky130_fd_sc_hd__conb_1
Xpicorv32_355 VGND VGND VPWR VPWR picorv32_355/HI trace_data[5] sky130_fd_sc_hd__conb_1
XFILLER_143_897 VPWR VGND VPWR VGND sky130_ef_sc_hd__decap_12
XFILLER_142_363 VGND VGND VPWR VPWR sky130_fd_sc_hd__fill_1
X_08962_ cpuregs\[8\]\[26\] cpuregs\[9\]\[26\] cpuregs\[10\]\[26\] cpuregs\[11\]\[26\]
+ net276 net272 VGND VGND VPWR VPWR _04638_ sky130_fd_sc_hd__mux4_1
XFILLER_115_588 VPWR VGND VPWR VGND sky130_ef_sc_hd__decap_12
XFILLER_88_439 VGND VGND VPWR VPWR sky130_fd_sc_hd__fill_1
X_08893_ net269 _04569_ _04572_ _04266_ VGND VGND VPWR VPWR _04573_ sky130_fd_sc_hd__o211a_1
XFILLER_68_130 VGND VGND VPWR VPWR sky130_fd_sc_hd__decap_8
X_07913_ _03735_ _03736_ _03732_ VGND VGND VPWR VPWR _03742_ sky130_fd_sc_hd__o21ai_1
XFILLER_96_461 VPWR VGND VPWR VGND sky130_ef_sc_hd__decap_12
X_07844_ reg_pc\[10\] _01624_ _01628_ _03697_ VGND VGND VPWR VPWR _00654_ sky130_fd_sc_hd__a22o_1
XFILLER_110_271 VPWR VGND VPWR VGND sky130_ef_sc_hd__decap_12
XFILLER_84_645 VGND VGND VPWR VPWR sky130_fd_sc_hd__fill_1
XFILLER_84_634 VGND VGND VPWR VPWR sky130_fd_sc_hd__decap_8
XFILLER_83_122 VGND VGND VPWR VPWR sky130_fd_sc_hd__decap_6
XFILLER_56_325 VGND VGND VPWR VPWR sky130_fd_sc_hd__fill_1
XFILLER_83_144 VPWR VGND VPWR VGND sky130_ef_sc_hd__decap_12
X_07775_ count_instr\[45\] _03654_ _03656_ VGND VGND VPWR VPWR _00626_ sky130_fd_sc_hd__o21a_1
X_04987_ cpu_state\[6\] _01614_ VGND VGND VPWR VPWR _01615_ sky130_fd_sc_hd__nand2_1
XFILLER_17_15 VPWR VGND VPWR VGND sky130_ef_sc_hd__decap_12
XFILLER_37_561 VGND VGND VPWR VPWR sky130_fd_sc_hd__decap_4
XFILLER_140_27 VGND VGND VPWR VPWR sky130_fd_sc_hd__fill_1
X_09514_ cpuregs\[31\]\[19\] _02662_ _04865_ VGND VGND VPWR VPWR _01177_ sky130_fd_sc_hd__mux2_1
X_06726_ _03140_ _03141_ _03145_ _03146_ _01579_ _01581_ VGND VGND VPWR VPWR _03149_
+ sky130_fd_sc_hd__mux4_1
X_09445_ _02649_ cpuregs\[19\]\[16\] _04863_ VGND VGND VPWR VPWR _01078_ sky130_fd_sc_hd__mux2_1
XTAP_TAPCELL_ROW_84_1668 VGND VPWR sky130_fd_sc_hd__tapvpwrvgnd_1
X_06657_ decoded_imm\[13\] net175 VGND VGND VPWR VPWR _03082_ sky130_fd_sc_hd__nand2_1
XTAP_TAPCELL_ROW_84_1679 VGND VPWR sky130_fd_sc_hd__tapvpwrvgnd_1
XFILLER_80_873 VGND VGND VPWR VPWR sky130_fd_sc_hd__decap_6
X_05608_ net200 _01572_ _02190_ VGND VGND VPWR VPWR _02191_ sky130_fd_sc_hd__a21o_1
XFILLER_52_586 VGND VGND VPWR VPWR sky130_fd_sc_hd__fill_2
XPHY_EDGE_ROW_135_Left_289 VGND VGND VPWR VPWR sky130_fd_sc_hd__decap_3
X_06588_ cpuregs\[24\]\[10\] cpuregs\[25\]\[10\] cpuregs\[26\]\[10\] cpuregs\[27\]\[10\]
+ net263 net259 VGND VGND VPWR VPWR _03016_ sky130_fd_sc_hd__mux4_1
X_09376_ decoded_imm\[8\] _04746_ _04850_ VGND VGND VPWR VPWR _01022_ sky130_fd_sc_hd__o21a_1
X_08327_ _04102_ _04103_ VGND VGND VPWR VPWR _00731_ sky130_fd_sc_hd__nor2_1
X_05539_ net172 net204 VGND VGND VPWR VPWR _02122_ sky130_fd_sc_hd__nand2_1
XFILLER_149_69 VPWR VGND VPWR VGND sky130_ef_sc_hd__decap_12
X_08258_ net34 _04059_ VGND VGND VPWR VPWR _00706_ sky130_fd_sc_hd__and2_1
XFILLER_137_157 VGND VGND VPWR VPWR sky130_fd_sc_hd__fill_2
X_07209_ cpuregs\[30\]\[27\] _02696_ net252 VGND VGND VPWR VPWR _00159_ sky130_fd_sc_hd__mux2_1
X_10220_ clknet_leaf_40_clk _00350_ VGND VGND VPWR VPWR cpuregs\[14\]\[26\] sky130_fd_sc_hd__dfxtp_1
X_08189_ _01549_ _03996_ VGND VGND VPWR VPWR _00700_ sky130_fd_sc_hd__nor2_1
XTAP_TAPCELL_ROW_115_2178 VGND VPWR sky130_fd_sc_hd__tapvpwrvgnd_1
XTAP_TAPCELL_ROW_115_2167 VGND VPWR sky130_fd_sc_hd__tapvpwrvgnd_1
XFILLER_133_330 VGND VGND VPWR VPWR sky130_fd_sc_hd__decap_6
XFILLER_3_137 VPWR VGND VPWR VGND sky130_ef_sc_hd__decap_12
X_10151_ clknet_leaf_79_clk _00281_ VGND VGND VPWR VPWR cpuregs\[21\]\[21\] sky130_fd_sc_hd__dfxtp_1
XFILLER_79_439 VGND VGND VPWR VPWR sky130_fd_sc_hd__decap_8
XFILLER_0_811 VGND VGND VPWR VPWR sky130_fd_sc_hd__fill_1
XPHY_EDGE_ROW_144_Left_298 VGND VGND VPWR VPWR sky130_fd_sc_hd__decap_3
X_10082_ clknet_leaf_22_clk _00212_ VGND VGND VPWR VPWR cpuregs\[2\]\[16\] sky130_fd_sc_hd__dfxtp_1
XTAP_TAPCELL_ROW_7_443 VGND VPWR sky130_fd_sc_hd__tapvpwrvgnd_1
XFILLER_58_88 VGND VGND VPWR VPWR sky130_fd_sc_hd__decap_8
XFILLER_47_347 VPWR VGND VPWR VGND sky130_ef_sc_hd__decap_12
XFILLER_74_166 VGND VGND VPWR VPWR sky130_fd_sc_hd__decap_4
XFILLER_16_701 VGND VGND VPWR VPWR sky130_fd_sc_hd__decap_3
X_10984_ clknet_leaf_54_clk _01046_ VGND VGND VPWR VPWR cpuregs\[18\]\[16\] sky130_fd_sc_hd__dfxtp_1
XFILLER_90_626 VPWR VGND VPWR VGND sky130_ef_sc_hd__decap_12
XFILLER_15_211 VPWR VGND VPWR VGND sky130_ef_sc_hd__decap_12
XFILLER_55_391 VGND VGND VPWR VPWR sky130_fd_sc_hd__fill_1
XFILLER_16_745 VGND VGND VPWR VPWR sky130_fd_sc_hd__fill_1
XTAP_TAPCELL_ROW_26_740 VGND VPWR sky130_fd_sc_hd__tapvpwrvgnd_1
XFILLER_43_553 VGND VGND VPWR VPWR sky130_fd_sc_hd__fill_1
XFILLER_15_266 VPWR VGND VPWR VGND sky130_ef_sc_hd__decap_12
XTAP_TAPCELL_ROW_26_751 VGND VPWR sky130_fd_sc_hd__tapvpwrvgnd_1
XFILLER_8_911 VGND VGND VPWR VPWR sky130_fd_sc_hd__fill_1
X_11605_ net97 VGND VGND VPWR VPWR net203 sky130_fd_sc_hd__clkbuf_1
XFILLER_128_157 VGND VGND VPWR VPWR sky130_fd_sc_hd__decap_6
XFILLER_125_820 VPWR VGND VPWR VGND sky130_ef_sc_hd__decap_12
X_11467_ clknet_leaf_117_clk _01511_ VGND VGND VPWR VPWR cpuregs\[10\]\[1\] sky130_fd_sc_hd__dfxtp_1
XFILLER_143_149 VPWR VGND VPWR VGND sky130_ef_sc_hd__decap_12
X_11398_ clknet_leaf_38_clk _01442_ VGND VGND VPWR VPWR cpuregs\[7\]\[28\] sky130_fd_sc_hd__dfxtp_1
XFILLER_125_853 VPWR VGND VPWR VGND sky130_ef_sc_hd__decap_12
XFILLER_124_352 VGND VGND VPWR VPWR sky130_fd_sc_hd__decap_3
XTAP_TAPCELL_ROW_55_1214 VGND VPWR sky130_fd_sc_hd__tapvpwrvgnd_1
X_10418_ clknet_leaf_127_clk _00548_ VGND VGND VPWR VPWR cpuregs\[17\]\[0\] sky130_fd_sc_hd__dfxtp_1
X_10349_ clknet_leaf_35_clk _00479_ VGND VGND VPWR VPWR cpuregs\[16\]\[27\] sky130_fd_sc_hd__dfxtp_1
XFILLER_125_897 VPWR VGND VPWR VGND sky130_ef_sc_hd__decap_12
XFILLER_124_385 VGND VGND VPWR VPWR sky130_fd_sc_hd__decap_6
XFILLER_98_737 VGND VGND VPWR VPWR sky130_fd_sc_hd__decap_8
XFILLER_97_225 VGND VGND VPWR VPWR sky130_fd_sc_hd__decap_8
XFILLER_3_671 VGND VGND VPWR VPWR sky130_fd_sc_hd__fill_1
XFILLER_151_193 VPWR VGND VPWR VGND sky130_ef_sc_hd__decap_12
XFILLER_140_867 VGND VGND VPWR VPWR sky130_fd_sc_hd__fill_1
X_04910_ cpu_state\[3\] VGND VGND VPWR VPWR _01543_ sky130_fd_sc_hd__clkinv_4
XFILLER_120_580 VGND VGND VPWR VPWR sky130_fd_sc_hd__decap_8
X_05890_ _02077_ _02237_ _02240_ _02078_ _02444_ VGND VGND VPWR VPWR _02445_ sky130_fd_sc_hd__a221o_1
XFILLER_17_3 VPWR VGND VPWR VGND sky130_ef_sc_hd__decap_12
XFILLER_66_689 VGND VGND VPWR VPWR sky130_fd_sc_hd__decap_3
XFILLER_65_133 VGND VGND VPWR VPWR sky130_fd_sc_hd__decap_4
XFILLER_26_509 VGND VGND VPWR VPWR sky130_fd_sc_hd__fill_1
XFILLER_93_486 VPWR VGND VPWR VGND sky130_ef_sc_hd__decap_12
XFILLER_65_166 VGND VGND VPWR VPWR sky130_fd_sc_hd__fill_2
XFILLER_53_317 VGND VGND VPWR VPWR sky130_fd_sc_hd__fill_2
X_07560_ cpuregs\[25\]\[11\] _02630_ _03571_ VGND VGND VPWR VPWR _00495_ sky130_fd_sc_hd__mux2_1
XFILLER_19_561 VPWR VGND VPWR VGND sky130_ef_sc_hd__decap_12
X_06511_ _02933_ _02934_ _02937_ _02938_ _01579_ _01581_ VGND VGND VPWR VPWR _02942_
+ sky130_fd_sc_hd__mux4_1
XFILLER_19_594 VPWR VGND VPWR VGND sky130_ef_sc_hd__decap_12
XFILLER_34_531 VGND VGND VPWR VPWR sky130_fd_sc_hd__fill_1
XTAP_TAPCELL_ROW_66_1387 VGND VPWR sky130_fd_sc_hd__tapvpwrvgnd_1
X_09230_ cpuregs\[1\]\[9\] _02621_ net244 VGND VGND VPWR VPWR _00927_ sky130_fd_sc_hd__mux2_1
X_07491_ cpuregs\[26\]\[9\] _02621_ _03568_ VGND VGND VPWR VPWR _00429_ sky130_fd_sc_hd__mux2_1
XFILLER_34_586 VGND VGND VPWR VPWR sky130_fd_sc_hd__fill_2
XFILLER_61_383 VGND VGND VPWR VPWR sky130_fd_sc_hd__fill_1
XFILLER_21_225 VGND VGND VPWR VPWR sky130_fd_sc_hd__decap_8
X_06442_ _02862_ _02865_ _02874_ VGND VGND VPWR VPWR _02875_ sky130_fd_sc_hd__nand3_1
X_09161_ mem_rdata_q\[17\] mem_rdata_q\[16\] mem_rdata_q\[15\] mem_rdata_q\[2\] VGND
+ VGND VPWR VPWR _04779_ sky130_fd_sc_hd__or4_1
X_06373_ _02797_ _02793_ _02806_ _02807_ VGND VGND VPWR VPWR _02808_ sky130_fd_sc_hd__a211oi_4
XFILLER_119_113 VGND VGND VPWR VPWR sky130_fd_sc_hd__decap_4
XFILLER_108_809 VGND VGND VPWR VPWR sky130_fd_sc_hd__decap_3
X_08112_ _01547_ reg_next_pc\[19\] _01645_ _03706_ VGND VGND VPWR VPWR _03926_ sky130_fd_sc_hd__a22o_1
X_05324_ _01674_ _01917_ _01918_ net183 cpu_state\[4\] VGND VGND VPWR VPWR _01919_
+ sky130_fd_sc_hd__a32o_1
X_09092_ _01555_ decoder_pseudo_trigger VGND VGND VPWR VPWR _04747_ sky130_fd_sc_hd__or2_4
XFILLER_9_93 VPWR VGND VPWR VGND sky130_ef_sc_hd__decap_12
XFILLER_147_488 VPWR VGND VPWR VGND sky130_ef_sc_hd__decap_12
XFILLER_135_617 VGND VGND VPWR VPWR sky130_fd_sc_hd__fill_1
X_08043_ _03700_ _03701_ _03834_ VGND VGND VPWR VPWR _03862_ sky130_fd_sc_hd__and3_1
X_05255_ _01851_ _01852_ _01853_ _01543_ VGND VGND VPWR VPWR _01855_ sky130_fd_sc_hd__a31o_1
X_05186_ _01779_ _01782_ _01790_ VGND VGND VPWR VPWR _01791_ sky130_fd_sc_hd__and3_1
XFILLER_135_27 VPWR VGND VPWR VGND sky130_ef_sc_hd__decap_12
X_09994_ clknet_leaf_67_clk _00124_ VGND VGND VPWR VPWR cpuregs\[12\]\[24\] sky130_fd_sc_hd__dfxtp_1
XFILLER_142_182 VPWR VGND VPWR VGND sky130_ef_sc_hd__decap_12
XFILLER_130_333 VGND VGND VPWR VPWR sky130_fd_sc_hd__decap_6
XFILLER_103_536 VGND VGND VPWR VPWR sky130_fd_sc_hd__decap_3
X_08945_ _04613_ _04614_ _01558_ VGND VGND VPWR VPWR _04622_ sky130_fd_sc_hd__mux2_1
XFILLER_131_889 VGND VGND VPWR VPWR sky130_fd_sc_hd__decap_6
XTAP_TAPCELL_ROW_110_2097 VGND VPWR sky130_fd_sc_hd__tapvpwrvgnd_1
XTAP_TAPCELL_ROW_110_2086 VGND VPWR sky130_fd_sc_hd__tapvpwrvgnd_1
XFILLER_103_569 VGND VGND VPWR VPWR sky130_fd_sc_hd__fill_2
XFILLER_88_269 VGND VGND VPWR VPWR sky130_fd_sc_hd__fill_1
XFILLER_69_472 VGND VGND VPWR VPWR sky130_fd_sc_hd__decap_4
XTAP_TAPCELL_ROW_4_402 VGND VPWR sky130_fd_sc_hd__tapvpwrvgnd_1
XFILLER_151_15 VPWR VGND VPWR VGND sky130_ef_sc_hd__decap_12
X_08876_ net269 _04555_ _01559_ VGND VGND VPWR VPWR _04557_ sky130_fd_sc_hd__a21o_1
XFILLER_57_645 VGND VGND VPWR VPWR sky130_fd_sc_hd__decap_6
XTAP_TAPCELL_ROW_86_1708 VGND VPWR sky130_fd_sc_hd__tapvpwrvgnd_1
X_07827_ reg_pc\[2\] _01624_ _01628_ _03688_ VGND VGND VPWR VPWR _00646_ sky130_fd_sc_hd__a22o_1
X_07758_ count_instr\[39\] _03644_ _01549_ VGND VGND VPWR VPWR _03646_ sky130_fd_sc_hd__a21oi_1
XFILLER_38_881 VGND VGND VPWR VPWR sky130_fd_sc_hd__decap_8
XFILLER_44_306 VGND VGND VPWR VPWR sky130_fd_sc_hd__fill_2
XFILLER_44_339 VGND VGND VPWR VPWR sky130_fd_sc_hd__decap_4
X_06709_ decoded_imm\[15\] net177 VGND VGND VPWR VPWR _03132_ sky130_fd_sc_hd__nand2_1
X_07689_ count_instr\[14\] _03600_ _01549_ VGND VGND VPWR VPWR _03602_ sky130_fd_sc_hd__a21oi_1
XFILLER_71_169 VGND VGND VPWR VPWR sky130_fd_sc_hd__decap_6
XFILLER_53_873 VGND VGND VPWR VPWR sky130_fd_sc_hd__fill_1
XFILLER_52_361 VGND VGND VPWR VPWR sky130_fd_sc_hd__decap_3
X_09428_ _02581_ _03569_ VGND VGND VPWR VPWR _04863_ sky130_fd_sc_hd__or2_4
X_09359_ decoded_imm\[16\] _04746_ _04824_ _04841_ VGND VGND VPWR VPWR _01014_ sky130_fd_sc_hd__o22a_1
XFILLER_9_719 VGND VGND VPWR VPWR sky130_fd_sc_hd__decap_8
XFILLER_40_556 VGND VGND VPWR VPWR sky130_fd_sc_hd__decap_6
XTAP_TAPCELL_ROW_117_2207 VGND VPWR sky130_fd_sc_hd__tapvpwrvgnd_1
XFILLER_8_229 VGND VGND VPWR VPWR sky130_fd_sc_hd__fill_1
XFILLER_40_589 VGND VGND VPWR VPWR sky130_fd_sc_hd__fill_2
X_11321_ clknet_leaf_42_clk _01368_ VGND VGND VPWR VPWR cpuregs\[5\]\[18\] sky130_fd_sc_hd__dfxtp_1
XFILLER_121_3 VPWR VGND VPWR VGND sky130_ef_sc_hd__decap_12
XFILLER_60_78 VGND VGND VPWR VPWR sky130_fd_sc_hd__decap_6
XTAP_TAPCELL_ROW_130_2418 VGND VPWR sky130_fd_sc_hd__tapvpwrvgnd_1
XTAP_TAPCELL_ROW_130_2407 VGND VPWR sky130_fd_sc_hd__tapvpwrvgnd_1
XFILLER_125_105 VGND VGND VPWR VPWR sky130_fd_sc_hd__decap_6
XFILLER_4_413 VGND VGND VPWR VPWR sky130_fd_sc_hd__decap_6
XPHY_EDGE_ROW_152_Left_306 VGND VGND VPWR VPWR sky130_fd_sc_hd__decap_3
XFILLER_107_853 VGND VGND VPWR VPWR sky130_fd_sc_hd__fill_2
X_11252_ clknet_leaf_8_clk _01299_ VGND VGND VPWR VPWR cpuregs\[22\]\[13\] sky130_fd_sc_hd__dfxtp_1
XFILLER_4_457 VPWR VGND VPWR VGND sky130_ef_sc_hd__decap_12
XFILLER_134_683 VGND VGND VPWR VPWR sky130_fd_sc_hd__decap_4
XFILLER_134_661 VGND VGND VPWR VPWR sky130_fd_sc_hd__fill_1
XFILLER_107_897 VGND VGND VPWR VPWR sky130_fd_sc_hd__decap_8
XFILLER_106_374 VGND VGND VPWR VPWR sky130_fd_sc_hd__decap_6
X_10203_ clknet_leaf_0_clk _00333_ VGND VGND VPWR VPWR cpuregs\[14\]\[9\] sky130_fd_sc_hd__dfxtp_1
X_11183_ clknet_leaf_136_clk _01230_ VGND VGND VPWR VPWR cpuregs\[29\]\[8\] sky130_fd_sc_hd__dfxtp_1
XFILLER_133_193 VGND VGND VPWR VPWR sky130_fd_sc_hd__fill_1
XFILLER_122_867 VGND VGND VPWR VPWR sky130_fd_sc_hd__fill_1
XFILLER_121_333 VGND VGND VPWR VPWR sky130_fd_sc_hd__decap_3
XFILLER_79_225 VGND VGND VPWR VPWR sky130_fd_sc_hd__decap_6
XFILLER_0_630 VGND VGND VPWR VPWR sky130_fd_sc_hd__decap_3
X_10134_ clknet_leaf_137_clk _00264_ VGND VGND VPWR VPWR cpuregs\[21\]\[4\] sky130_fd_sc_hd__dfxtp_1
XFILLER_95_729 VGND VGND VPWR VPWR sky130_fd_sc_hd__fill_2
XFILLER_67_409 VGND VGND VPWR VPWR sky130_fd_sc_hd__fill_1
XFILLER_48_601 VPWR VGND VPWR VGND sky130_ef_sc_hd__decap_12
XFILLER_121_399 VGND VGND VPWR VPWR sky130_fd_sc_hd__fill_1
XFILLER_121_388 VGND VGND VPWR VPWR sky130_fd_sc_hd__decap_4
X_10065_ clknet_leaf_14_clk _00195_ VGND VGND VPWR VPWR cpuregs\[13\]\[31\] sky130_fd_sc_hd__dfxtp_1
XTAP_TAPCELL_ROW_50_1133 VGND VPWR sky130_fd_sc_hd__tapvpwrvgnd_1
XFILLER_0_685 VPWR VGND VPWR VGND sky130_ef_sc_hd__decap_12
XFILLER_47_111 VGND VGND VPWR VPWR sky130_fd_sc_hd__fill_1
XTAP_TAPCELL_ROW_145_2650 VGND VPWR sky130_fd_sc_hd__tapvpwrvgnd_1
XFILLER_141_81 VPWR VGND VPWR VGND sky130_ef_sc_hd__decap_12
XFILLER_90_456 VGND VGND VPWR VPWR sky130_fd_sc_hd__fill_1
XFILLER_50_309 VGND VGND VPWR VPWR sky130_fd_sc_hd__decap_8
XFILLER_16_553 VPWR VGND VPWR VGND sky130_ef_sc_hd__decap_12
X_10967_ clknet_leaf_128_clk _01029_ VGND VGND VPWR VPWR decoded_imm\[1\] sky130_fd_sc_hd__dfxtp_2
XFILLER_93_7 VGND VGND VPWR VPWR sky130_fd_sc_hd__fill_2
XTAP_TAPCELL_ROW_48_1095 VGND VPWR sky130_fd_sc_hd__tapvpwrvgnd_1
X_10898_ clknet_leaf_143_clk _00960_ VGND VGND VPWR VPWR net161 sky130_fd_sc_hd__dfxtp_1
XFILLER_16_597 VGND VGND VPWR VPWR sky130_fd_sc_hd__fill_1
XFILLER_31_534 VGND VGND VPWR VPWR sky130_fd_sc_hd__fill_1
XFILLER_129_433 VPWR VGND VPWR VGND sky130_ef_sc_hd__decap_12
XFILLER_12_781 VPWR VGND VPWR VGND sky130_ef_sc_hd__decap_12
XPHY_EDGE_ROW_152_Right_152 VGND VGND VPWR VPWR sky130_fd_sc_hd__decap_3
XFILLER_8_785 VPWR VGND VPWR VGND sky130_ef_sc_hd__decap_12
XFILLER_7_251 VPWR VGND VPWR VGND sky130_ef_sc_hd__decap_12
X_05040_ instr_sh _01619_ _01627_ mem_wordsize\[2\] _01659_ VGND VGND VPWR VPWR _00026_
+ sky130_fd_sc_hd__a221o_1
XFILLER_124_182 VPWR VGND VPWR VGND sky130_ef_sc_hd__decap_12
XFILLER_113_889 VGND VGND VPWR VPWR sky130_fd_sc_hd__decap_6
XFILLER_112_377 VGND VGND VPWR VPWR sky130_fd_sc_hd__fill_1
X_06991_ net187 _02721_ _03327_ _01641_ VGND VGND VPWR VPWR _03404_ sky130_fd_sc_hd__o211a_1
XFILLER_100_528 VGND VGND VPWR VPWR sky130_fd_sc_hd__decap_4
X_05942_ net97 net210 _01665_ VGND VGND VPWR VPWR net104 sky130_fd_sc_hd__mux2_4
X_08730_ net269 _04417_ _01559_ VGND VGND VPWR VPWR _04419_ sky130_fd_sc_hd__a21o_1
X_05873_ net255 _02428_ _02430_ VGND VGND VPWR VPWR alu_out\[25\] sky130_fd_sc_hd__a21o_1
XFILLER_66_442 VGND VGND VPWR VPWR sky130_fd_sc_hd__decap_3
X_08661_ cpuregs\[20\]\[10\] cpuregs\[21\]\[10\] cpuregs\[22\]\[10\] cpuregs\[23\]\[10\]
+ net278 net273 VGND VGND VPWR VPWR _04353_ sky130_fd_sc_hd__mux4_1
X_07612_ cpuregs\[20\]\[29\] _02704_ net245 VGND VGND VPWR VPWR _00545_ sky130_fd_sc_hd__mux2_1
XFILLER_94_784 VGND VGND VPWR VPWR sky130_fd_sc_hd__fill_2
XFILLER_81_401 VGND VGND VPWR VPWR sky130_fd_sc_hd__fill_1
XTAP_TAPCELL_ROW_68_1427 VGND VPWR sky130_fd_sc_hd__tapvpwrvgnd_1
XTAP_TAPCELL_ROW_68_1416 VGND VPWR sky130_fd_sc_hd__tapvpwrvgnd_1
XFILLER_53_103 VGND VGND VPWR VPWR sky130_fd_sc_hd__decap_8
XFILLER_19_391 VGND VGND VPWR VPWR sky130_fd_sc_hd__fill_1
X_08592_ cpuregs\[12\]\[6\] cpuregs\[13\]\[6\] cpuregs\[14\]\[6\] cpuregs\[15\]\[6\]
+ net278 net273 VGND VGND VPWR VPWR _04288_ sky130_fd_sc_hd__mux4_1
X_07543_ _02696_ cpuregs\[16\]\[27\] _03570_ VGND VGND VPWR VPWR _00479_ sky130_fd_sc_hd__mux2_1
XFILLER_53_169 VGND VGND VPWR VPWR sky130_fd_sc_hd__decap_8
X_07474_ cpuregs\[15\]\[25\] _02688_ net246 VGND VGND VPWR VPWR _00413_ sky130_fd_sc_hd__mux2_1
XTAP_TAPCELL_ROW_81_1627 VGND VPWR sky130_fd_sc_hd__tapvpwrvgnd_1
XFILLER_62_692 VGND VGND VPWR VPWR sky130_fd_sc_hd__fill_2
XFILLER_14_27 VGND VGND VPWR VPWR sky130_fd_sc_hd__fill_1
XFILLER_139_219 VGND VGND VPWR VPWR sky130_fd_sc_hd__decap_4
X_09213_ _04796_ _04769_ VGND VGND VPWR VPWR _04797_ sky130_fd_sc_hd__and2b_1
X_06425_ _00016_ _02841_ _02845_ _02858_ VGND VGND VPWR VPWR _02859_ sky130_fd_sc_hd__a31o_1
X_09144_ instr_add _04748_ _04749_ _04772_ VGND VGND VPWR VPWR _00870_ sky130_fd_sc_hd__a22o_1
XFILLER_22_589 VGND VGND VPWR VPWR sky130_fd_sc_hd__decap_4
X_06356_ _02791_ _02735_ _02714_ VGND VGND VPWR VPWR _02792_ sky130_fd_sc_hd__and3b_1
XFILLER_148_797 VPWR VGND VPWR VGND sky130_ef_sc_hd__decap_12
X_05307_ count_instr\[19\] instr_rdinstr count_cycle\[51\] instr_rdcycleh VGND VGND
+ VPWR VPWR _01903_ sky130_fd_sc_hd__a22o_1
X_09075_ mem_rdata_q\[3\] net26 _01609_ VGND VGND VPWR VPWR _01097_ sky130_fd_sc_hd__mux2_1
X_06287_ mem_do_rdata cpu_state\[6\] _01614_ _02713_ _02723_ VGND VGND VPWR VPWR _02725_
+ sky130_fd_sc_hd__a311o_4
XFILLER_30_15 VPWR VGND VPWR VGND sky130_ef_sc_hd__decap_12
XFILLER_146_15 VPWR VGND VPWR VGND sky130_ef_sc_hd__decap_12
XTAP_TAPCELL_ROW_112_2126 VGND VPWR sky130_fd_sc_hd__tapvpwrvgnd_1
XTAP_TAPCELL_ROW_96_1870 VGND VPWR sky130_fd_sc_hd__tapvpwrvgnd_1
XTAP_TAPCELL_ROW_79_1589 VGND VPWR sky130_fd_sc_hd__tapvpwrvgnd_1
X_05238_ cpu_state\[4\] net175 _01834_ _01836_ _01839_ VGND VGND VPWR VPWR _04882_
+ sky130_fd_sc_hd__a2111o_1
X_08026_ decoded_imm_j\[12\] _03699_ _03817_ VGND VGND VPWR VPWR _03846_ sky130_fd_sc_hd__o21a_1
XFILLER_150_406 VPWR VGND VPWR VGND sky130_ef_sc_hd__decap_12
XFILLER_1_405 VPWR VGND VPWR VGND sky130_ef_sc_hd__decap_12
XFILLER_89_534 VPWR VGND VPWR VGND sky130_ef_sc_hd__decap_12
X_05169_ count_instr\[40\] instr_rdinstrh net257 _01775_ VGND VGND VPWR VPWR _01776_
+ sky130_fd_sc_hd__a211o_1
XFILLER_131_664 VGND VGND VPWR VPWR sky130_fd_sc_hd__decap_8
XFILLER_131_653 VGND VGND VPWR VPWR sky130_fd_sc_hd__fill_2
XFILLER_130_141 VPWR VGND VPWR VGND sky130_ef_sc_hd__decap_12
XFILLER_89_589 VGND VGND VPWR VPWR sky130_fd_sc_hd__decap_3
XFILLER_77_729 VPWR VGND VPWR VGND sky130_ef_sc_hd__decap_12
X_09977_ clknet_leaf_146_clk _00107_ VGND VGND VPWR VPWR cpuregs\[12\]\[7\] sky130_fd_sc_hd__dfxtp_1
XFILLER_39_57 VGND VGND VPWR VPWR sky130_fd_sc_hd__decap_4
X_08928_ _04595_ _04596_ _01558_ VGND VGND VPWR VPWR _04606_ sky130_fd_sc_hd__mux2_1
XFILLER_103_388 VGND VGND VPWR VPWR sky130_fd_sc_hd__decap_4
X_08859_ decoded_imm\[20\] _01654_ _01586_ VGND VGND VPWR VPWR _04541_ sky130_fd_sc_hd__a21o_1
XFILLER_55_23 VPWR VGND VPWR VGND sky130_ef_sc_hd__decap_12
XTAP_TAPCELL_ROW_123_2299 VGND VPWR sky130_fd_sc_hd__tapvpwrvgnd_1
XFILLER_55_89 VPWR VGND VPWR VGND sky130_ef_sc_hd__decap_12
XFILLER_32_309 VGND VGND VPWR VPWR sky130_fd_sc_hd__decap_3
X_10821_ clknet_leaf_118_clk _00886_ VGND VGND VPWR VPWR decoded_imm_j\[4\] sky130_fd_sc_hd__dfxtp_2
XFILLER_25_372 VGND VGND VPWR VPWR sky130_fd_sc_hd__fill_2
XFILLER_25_383 VGND VGND VPWR VPWR sky130_fd_sc_hd__decap_8
X_10752_ clknet_leaf_134_clk alu_out\[5\] VGND VGND VPWR VPWR alu_out_q\[5\] sky130_fd_sc_hd__dfxtp_1
XFILLER_71_55 VGND VGND VPWR VPWR sky130_fd_sc_hd__fill_1
XFILLER_52_191 VGND VGND VPWR VPWR sky130_fd_sc_hd__decap_4
XFILLER_9_505 VPWR VGND VPWR VGND sky130_ef_sc_hd__decap_12
X_10683_ clknet_leaf_105_clk _00781_ VGND VGND VPWR VPWR net36 sky130_fd_sc_hd__dfxtp_1
XFILLER_71_66 VGND VGND VPWR VPWR sky130_fd_sc_hd__decap_6
XFILLER_138_230 VGND VGND VPWR VPWR sky130_fd_sc_hd__decap_8
XFILLER_139_797 VPWR VGND VPWR VGND sky130_ef_sc_hd__decap_12
X_11304_ clknet_leaf_115_clk _01351_ VGND VGND VPWR VPWR cpuregs\[5\]\[1\] sky130_fd_sc_hd__dfxtp_1
XFILLER_4_221 VPWR VGND VPWR VGND sky130_ef_sc_hd__decap_12
XFILLER_153_277 VGND VGND VPWR VPWR sky130_fd_sc_hd__decap_3
X_11235_ clknet_leaf_38_clk _01282_ VGND VGND VPWR VPWR cpuregs\[3\]\[28\] sky130_fd_sc_hd__dfxtp_1
XFILLER_5_777 VGND VGND VPWR VPWR sky130_fd_sc_hd__decap_6
XFILLER_141_439 VGND VGND VPWR VPWR sky130_fd_sc_hd__decap_8
XFILLER_122_631 VGND VGND VPWR VPWR sky130_fd_sc_hd__decap_4
XFILLER_4_298 VGND VGND VPWR VPWR sky130_fd_sc_hd__decap_8
X_11166_ clknet_leaf_52_clk _01213_ VGND VGND VPWR VPWR cpuregs\[23\]\[23\] sky130_fd_sc_hd__dfxtp_1
X_11097_ clknet_leaf_42_clk _01154_ VGND VGND VPWR VPWR cpuregs\[24\]\[28\] sky130_fd_sc_hd__dfxtp_1
X_10117_ clknet_leaf_73_clk _00247_ VGND VGND VPWR VPWR cpuregs\[28\]\[19\] sky130_fd_sc_hd__dfxtp_1
XFILLER_96_96 VGND VGND VPWR VPWR sky130_fd_sc_hd__decap_3
XFILLER_0_471 VGND VGND VPWR VPWR sky130_fd_sc_hd__fill_1
X_10048_ clknet_leaf_27_clk _00178_ VGND VGND VPWR VPWR cpuregs\[13\]\[14\] sky130_fd_sc_hd__dfxtp_1
XFILLER_48_475 VGND VGND VPWR VPWR sky130_fd_sc_hd__fill_1
XFILLER_35_103 VGND VGND VPWR VPWR sky130_fd_sc_hd__decap_8
XFILLER_35_125 VGND VGND VPWR VPWR sky130_fd_sc_hd__decap_6
XFILLER_90_253 VGND VGND VPWR VPWR sky130_fd_sc_hd__decap_6
XFILLER_35_169 VGND VGND VPWR VPWR sky130_fd_sc_hd__decap_4
XTAP_TAPCELL_ROW_63_1335 VGND VPWR sky130_fd_sc_hd__tapvpwrvgnd_1
XFILLER_50_139 VGND VGND VPWR VPWR sky130_fd_sc_hd__fill_1
XFILLER_17_895 VGND VGND VPWR VPWR sky130_fd_sc_hd__fill_1
XTAP_TAPCELL_ROW_63_1346 VGND VPWR sky130_fd_sc_hd__tapvpwrvgnd_1
XFILLER_31_353 VGND VGND VPWR VPWR sky130_fd_sc_hd__decap_4
X_06210_ _02659_ _02660_ VGND VGND VPWR VPWR _02661_ sky130_fd_sc_hd__nor2_1
XTAP_TAPCELL_ROW_14_551 VGND VPWR sky130_fd_sc_hd__tapvpwrvgnd_1
XTAP_TAPCELL_ROW_14_562 VGND VPWR sky130_fd_sc_hd__tapvpwrvgnd_1
XFILLER_145_701 VGND VGND VPWR VPWR sky130_fd_sc_hd__decap_3
X_07190_ cpuregs\[30\]\[8\] _02616_ net252 VGND VGND VPWR VPWR _00140_ sky130_fd_sc_hd__mux2_1
XFILLER_145_745 VGND VGND VPWR VPWR sky130_fd_sc_hd__fill_1
XFILLER_129_285 VGND VGND VPWR VPWR sky130_fd_sc_hd__fill_1
X_06141_ reg_pc\[6\] _02601_ VGND VGND VPWR VPWR _02605_ sky130_fd_sc_hd__nand2_1
XFILLER_145_767 VPWR VGND VPWR VGND sky130_ef_sc_hd__decap_12
X_06072_ cpuregs\[8\]\[3\] cpuregs\[9\]\[3\] cpuregs\[10\]\[3\] cpuregs\[11\]\[3\]
+ net278 net273 VGND VGND VPWR VPWR _02544_ sky130_fd_sc_hd__mux4_1
XFILLER_132_417 VGND VGND VPWR VPWR sky130_fd_sc_hd__decap_3
X_09900_ cpuregs\[0\]\[30\] VGND VGND VPWR VPWR _01508_ sky130_fd_sc_hd__clkbuf_1
X_05023_ instr_jal net405 _01628_ _01644_ _01645_ VGND VGND VPWR VPWR _01646_ sky130_fd_sc_hd__a311o_1
XFILLER_6_83 VGND VGND VPWR VPWR sky130_fd_sc_hd__fill_1
XFILLER_116_29 VPWR VGND VPWR VGND sky130_ef_sc_hd__decap_12
XFILLER_112_141 VPWR VGND VPWR VGND sky130_ef_sc_hd__decap_12
X_09831_ _02603_ cpuregs\[10\]\[5\] _04876_ VGND VGND VPWR VPWR _01515_ sky130_fd_sc_hd__mux2_1
X_06974_ cpuregs\[4\]\[24\] cpuregs\[5\]\[24\] cpuregs\[6\]\[24\] cpuregs\[7\]\[24\]
+ net267 net261 VGND VGND VPWR VPWR _03388_ sky130_fd_sc_hd__mux4_1
XFILLER_101_837 VGND VGND VPWR VPWR sky130_fd_sc_hd__decap_3
XFILLER_98_397 VGND VGND VPWR VPWR sky130_fd_sc_hd__decap_8
XFILLER_86_548 VGND VGND VPWR VPWR sky130_fd_sc_hd__fill_1
XFILLER_58_228 VGND VGND VPWR VPWR sky130_fd_sc_hd__decap_6
X_09762_ _02590_ cpuregs\[7\]\[2\] _04874_ VGND VGND VPWR VPWR _01416_ sky130_fd_sc_hd__mux2_1
X_08713_ decoded_imm\[12\] _01654_ _01586_ VGND VGND VPWR VPWR _04403_ sky130_fd_sc_hd__a21o_1
X_05925_ net612 net171 _01665_ _01668_ VGND VGND VPWR VPWR net133 sky130_fd_sc_hd__a211o_1
XFILLER_94_581 VGND VGND VPWR VPWR sky130_fd_sc_hd__fill_1
Xrebuffer11 _04068_ VGND VGND VPWR VPWR net397 sky130_fd_sc_hd__dlygate4sd1_1
XFILLER_54_412 VGND VGND VPWR VPWR sky130_fd_sc_hd__fill_1
X_09693_ _03557_ _04870_ VGND VGND VPWR VPWR _04872_ sky130_fd_sc_hd__or2_4
X_05856_ _02092_ _02096_ _02102_ _02106_ VGND VGND VPWR VPWR _02415_ sky130_fd_sc_hd__and4_1
Xrebuffer44 net431 VGND VGND VPWR VPWR net430 sky130_fd_sc_hd__dlygate4sd1_1
Xrebuffer55 net442 VGND VGND VPWR VPWR net441 sky130_fd_sc_hd__dlygate4sd1_1
Xrebuffer33 _03579_ VGND VGND VPWR VPWR net419 sky130_fd_sc_hd__dlygate4sd1_1
X_08644_ net270 _04336_ VGND VGND VPWR VPWR _04337_ sky130_fd_sc_hd__or2_1
Xrebuffer22 net404 VGND VGND VPWR VPWR net408 sky130_fd_sc_hd__dlygate4sd1_1
X_05787_ _02351_ _02353_ VGND VGND VPWR VPWR alu_out\[16\] sky130_fd_sc_hd__or2_1
Xrebuffer66 net565 VGND VGND VPWR VPWR net452 sky130_fd_sc_hd__clkbuf_2
XFILLER_14_309 VPWR VGND VPWR VGND sky130_ef_sc_hd__decap_12
X_08575_ _00009_ _04271_ VGND VGND VPWR VPWR _04272_ sky130_fd_sc_hd__or2_1
XFILLER_25_15 VPWR VGND VPWR VGND sky130_ef_sc_hd__decap_12
X_07526_ _02624_ cpuregs\[16\]\[10\] _03570_ VGND VGND VPWR VPWR _00462_ sky130_fd_sc_hd__mux2_1
XFILLER_23_821 VPWR VGND VPWR VGND sky130_ef_sc_hd__decap_12
XFILLER_41_106 VGND VGND VPWR VPWR sky130_fd_sc_hd__fill_1
XFILLER_41_128 VGND VGND VPWR VPWR sky130_fd_sc_hd__fill_1
XFILLER_50_651 VGND VGND VPWR VPWR sky130_fd_sc_hd__fill_1
XFILLER_23_865 VPWR VGND VPWR VGND sky130_ef_sc_hd__decap_12
XTAP_TAPCELL_ROW_33_860 VGND VPWR sky130_fd_sc_hd__tapvpwrvgnd_1
X_07457_ cpuregs\[15\]\[8\] _02616_ net246 VGND VGND VPWR VPWR _00396_ sky130_fd_sc_hd__mux2_1
XFILLER_6_508 VGND VGND VPWR VPWR sky130_fd_sc_hd__fill_1
X_06408_ cpuregs\[28\]\[4\] cpuregs\[29\]\[4\] cpuregs\[30\]\[4\] cpuregs\[31\]\[4\]
+ net264 net262 VGND VGND VPWR VPWR _02842_ sky130_fd_sc_hd__mux4_1
X_07388_ cpuregs\[14\]\[6\] _02607_ net247 VGND VGND VPWR VPWR _00330_ sky130_fd_sc_hd__mux2_1
XFILLER_41_47 VGND VGND VPWR VPWR sky130_fd_sc_hd__decap_8
XFILLER_135_200 VGND VGND VPWR VPWR sky130_fd_sc_hd__fill_1
X_09127_ net34 is_alu_reg_imm _04746_ VGND VGND VPWR VPWR _04765_ sky130_fd_sc_hd__and3_2
X_06339_ net262 _02774_ _02773_ net258 VGND VGND VPWR VPWR _02775_ sky130_fd_sc_hd__o211a_1
XTAP_TAPCELL_ROW_94_1829 VGND VPWR sky130_fd_sc_hd__tapvpwrvgnd_1
Xrebuffer189 net576 VGND VGND VPWR VPWR net575 sky130_fd_sc_hd__dlygate4sd1_1
X_09058_ _04726_ _04728_ _04266_ _04725_ VGND VGND VPWR VPWR _04729_ sky130_fd_sc_hd__o211a_1
XFILLER_151_726 VGND VGND VPWR VPWR sky130_fd_sc_hd__fill_2
X_08009_ decoded_imm_j\[12\] _03699_ VGND VGND VPWR VPWR _03830_ sky130_fd_sc_hd__xor2_1
XFILLER_104_631 VGND VGND VPWR VPWR sky130_fd_sc_hd__fill_1
XFILLER_2_725 VPWR VGND VPWR VGND sky130_ef_sc_hd__decap_12
X_11020_ clknet_leaf_76_clk _01082_ VGND VGND VPWR VPWR cpuregs\[19\]\[20\] sky130_fd_sc_hd__dfxtp_1
XFILLER_2_769 VPWR VGND VPWR VGND sky130_ef_sc_hd__decap_12
XFILLER_103_163 VGND VGND VPWR VPWR sky130_fd_sc_hd__decap_4
XFILLER_1_279 VGND VGND VPWR VPWR sky130_fd_sc_hd__fill_1
XTAP_TAPCELL_ROW_125_2339 VGND VPWR sky130_fd_sc_hd__tapvpwrvgnd_1
XTAP_TAPCELL_ROW_125_2328 VGND VPWR sky130_fd_sc_hd__tapvpwrvgnd_1
XFILLER_92_518 VGND VGND VPWR VPWR sky130_fd_sc_hd__fill_1
XFILLER_73_721 VGND VGND VPWR VPWR sky130_fd_sc_hd__decap_3
XFILLER_66_77 VGND VGND VPWR VPWR sky130_fd_sc_hd__decap_6
XFILLER_73_743 VGND VGND VPWR VPWR sky130_fd_sc_hd__decap_6
XFILLER_17_125 VPWR VGND VPWR VGND sky130_ef_sc_hd__decap_12
XFILLER_82_21 VGND VGND VPWR VPWR sky130_fd_sc_hd__decap_6
XFILLER_73_776 VGND VGND VPWR VPWR sky130_fd_sc_hd__decap_8
XFILLER_72_253 VGND VGND VPWR VPWR sky130_fd_sc_hd__decap_8
XFILLER_17_169 VPWR VGND VPWR VGND sky130_ef_sc_hd__decap_12
X_10804_ clknet_leaf_99_clk _00869_ VGND VGND VPWR VPWR instr_srli sky130_fd_sc_hd__dfxtp_1
XFILLER_14_810 VGND VGND VPWR VPWR sky130_fd_sc_hd__fill_2
XFILLER_32_139 VGND VGND VPWR VPWR sky130_fd_sc_hd__fill_1
XTAP_TAPCELL_ROW_45_1054 VGND VPWR sky130_fd_sc_hd__tapvpwrvgnd_1
X_10735_ clknet_leaf_51_clk _00832_ VGND VGND VPWR VPWR net221 sky130_fd_sc_hd__dfxtp_2
XFILLER_15_81 VPWR VGND VPWR VGND sky130_ef_sc_hd__decap_12
XFILLER_41_673 VPWR VGND VPWR VGND sky130_ef_sc_hd__decap_12
XFILLER_139_561 VPWR VGND VPWR VGND sky130_ef_sc_hd__decap_12
X_10666_ clknet_leaf_63_clk _04894_ VGND VGND VPWR VPWR reg_out\[24\] sky130_fd_sc_hd__dfxtp_1
XTAP_TAPCELL_ROW_11_510 VGND VPWR sky130_fd_sc_hd__tapvpwrvgnd_1
XFILLER_40_194 VGND VGND VPWR VPWR sky130_fd_sc_hd__fill_2
XFILLER_139_594 VGND VGND VPWR VPWR sky130_fd_sc_hd__decap_6
XTAP_TAPCELL_ROW_153_2782 VGND VPWR sky130_fd_sc_hd__tapvpwrvgnd_1
X_10597_ clknet_leaf_89_clk _00727_ VGND VGND VPWR VPWR count_cycle\[20\] sky130_fd_sc_hd__dfxtp_1
XFILLER_5_541 VPWR VGND VPWR VGND sky130_ef_sc_hd__decap_12
XTAP_TAPCELL_ROW_153_2793 VGND VPWR sky130_fd_sc_hd__tapvpwrvgnd_1
Xoutput109 net109 VGND VGND VPWR VPWR mem_la_wdata[20] sky130_fd_sc_hd__buf_2
XFILLER_99_117 VGND VGND VPWR VPWR sky130_fd_sc_hd__fill_1
XFILLER_126_299 VGND VGND VPWR VPWR sky130_fd_sc_hd__decap_8
XFILLER_5_585 VGND VGND VPWR VPWR sky130_fd_sc_hd__fill_1
XFILLER_141_258 VGND VGND VPWR VPWR sky130_fd_sc_hd__fill_1
XFILLER_68_504 VGND VGND VPWR VPWR sky130_fd_sc_hd__decap_8
X_11218_ clknet_leaf_150_clk _01265_ VGND VGND VPWR VPWR cpuregs\[3\]\[11\] sky130_fd_sc_hd__dfxtp_1
Xoutput80 net80 VGND VGND VPWR VPWR mem_la_addr[24] sky130_fd_sc_hd__buf_2
XFILLER_150_781 VPWR VGND VPWR VGND sky130_ef_sc_hd__decap_12
XFILLER_96_846 VPWR VGND VPWR VGND sky130_ef_sc_hd__decap_12
Xoutput91 net91 VGND VGND VPWR VPWR mem_la_addr[5] sky130_fd_sc_hd__buf_2
X_11149_ clknet_leaf_4_clk _01196_ VGND VGND VPWR VPWR cpuregs\[23\]\[6\] sky130_fd_sc_hd__dfxtp_1
X_06690_ _01621_ _03109_ _03110_ _03113_ _02715_ VGND VGND VPWR VPWR _03114_ sky130_fd_sc_hd__o311a_1
XFILLER_64_754 VGND VGND VPWR VPWR sky130_fd_sc_hd__fill_2
X_05710_ _02159_ _02284_ _02285_ VGND VGND VPWR VPWR alu_out\[7\] sky130_fd_sc_hd__a21o_1
XTAP_TAPCELL_ROW_19_632 VGND VPWR sky130_fd_sc_hd__tapvpwrvgnd_1
X_05641_ net224 net192 VGND VGND VPWR VPWR _02224_ sky130_fd_sc_hd__and2b_1
XTAP_TAPCELL_ROW_19_643 VGND VPWR sky130_fd_sc_hd__tapvpwrvgnd_1
X_08360_ _04119_ count_cycle\[36\] count_cycle\[37\] count_cycle\[35\] VGND VGND VPWR
+ VPWR _04124_ sky130_fd_sc_hd__and4_1
XFILLER_17_670 VGND VGND VPWR VPWR sky130_fd_sc_hd__fill_2
X_07311_ cpuregs\[28\]\[29\] _02704_ net249 VGND VGND VPWR VPWR _00257_ sky130_fd_sc_hd__mux2_1
X_05572_ net174 net206 VGND VGND VPWR VPWR _02155_ sky130_fd_sc_hd__nor2_1
XFILLER_51_459 VPWR VGND VPWR VGND sky130_ef_sc_hd__decap_12
X_08291_ _04078_ _04079_ VGND VGND VPWR VPWR _00719_ sky130_fd_sc_hd__nor2_1
XFILLER_20_813 VPWR VGND VPWR VGND sky130_ef_sc_hd__decap_12
X_07242_ cpuregs\[13\]\[26\] _02691_ net251 VGND VGND VPWR VPWR _00190_ sky130_fd_sc_hd__mux2_1
X_07173_ cpuregs\[12\]\[27\] _02696_ net253 VGND VGND VPWR VPWR _00127_ sky130_fd_sc_hd__mux2_1
XFILLER_11_39 VPWR VGND VPWR VGND sky130_ef_sc_hd__decap_12
X_06124_ reg_out\[3\] alu_out_q\[3\] latched_stalu VGND VGND VPWR VPWR _02591_ sky130_fd_sc_hd__mux2_2
XFILLER_127_39 VPWR VGND VPWR VGND sky130_ef_sc_hd__decap_12
XFILLER_118_789 VPWR VGND VPWR VGND sky130_ef_sc_hd__decap_12
XFILLER_117_277 VGND VGND VPWR VPWR sky130_fd_sc_hd__decap_3
XTAP_TAPCELL_ROW_76_1548 VGND VPWR sky130_fd_sc_hd__tapvpwrvgnd_1
XFILLER_145_597 VGND VGND VPWR VPWR sky130_fd_sc_hd__decap_3
X_06055_ cpuregs\[20\]\[2\] cpuregs\[21\]\[2\] cpuregs\[22\]\[2\] cpuregs\[23\]\[2\]
+ net279 _00008_ VGND VGND VPWR VPWR _02528_ sky130_fd_sc_hd__mux4_1
X_05006_ instr_sb _01619_ _01627_ mem_wordsize\[1\] _01632_ VGND VGND VPWR VPWR _00025_
+ sky130_fd_sc_hd__a221o_1
XFILLER_143_27 VPWR VGND VPWR VGND sky130_ef_sc_hd__decap_12
X_09814_ _02670_ cpuregs\[8\]\[21\] _04875_ VGND VGND VPWR VPWR _01467_ sky130_fd_sc_hd__mux2_1
XFILLER_113_461 VGND VGND VPWR VPWR sky130_fd_sc_hd__fill_1
XFILLER_99_684 VGND VGND VPWR VPWR sky130_fd_sc_hd__fill_2
XFILLER_113_494 VGND VGND VPWR VPWR sky130_fd_sc_hd__decap_4
X_09745_ _02657_ cpuregs\[6\]\[18\] _04873_ VGND VGND VPWR VPWR _01400_ sky130_fd_sc_hd__mux2_1
XTAP_TAPCELL_ROW_107_2036 VGND VPWR sky130_fd_sc_hd__tapvpwrvgnd_1
X_06957_ _03295_ _03296_ _03369_ _03272_ VGND VGND VPWR VPWR _03371_ sky130_fd_sc_hd__or4b_1
XFILLER_86_389 VGND VGND VPWR VPWR sky130_fd_sc_hd__decap_6
X_06888_ cpuregs\[24\]\[21\] cpuregs\[25\]\[21\] cpuregs\[26\]\[21\] cpuregs\[27\]\[21\]
+ _00012_ _00013_ VGND VGND VPWR VPWR _03305_ sky130_fd_sc_hd__mux4_1
XTAP_TAPCELL_ROW_107_2047 VGND VPWR sky130_fd_sc_hd__tapvpwrvgnd_1
X_05908_ _02459_ _02460_ instr_sub VGND VGND VPWR VPWR _02461_ sky130_fd_sc_hd__mux2_1
X_09676_ cpuregs\[4\]\[15\] _02646_ net238 VGND VGND VPWR VPWR _01333_ sky130_fd_sc_hd__mux2_1
XTAP_TAPCELL_ROW_38_941 VGND VPWR sky130_fd_sc_hd__tapvpwrvgnd_1
XFILLER_39_272 VGND VGND VPWR VPWR sky130_fd_sc_hd__decap_8
X_05839_ _02399_ _02396_ instr_sub VGND VGND VPWR VPWR _02400_ sky130_fd_sc_hd__mux2_1
XFILLER_54_253 VPWR VGND VPWR VGND sky130_ef_sc_hd__decap_12
X_08627_ cpuregs\[24\]\[8\] cpuregs\[25\]\[8\] cpuregs\[26\]\[8\] cpuregs\[27\]\[8\]
+ net278 net273 VGND VGND VPWR VPWR _04321_ sky130_fd_sc_hd__mux4_1
XTAP_TAPCELL_ROW_120_2247 VGND VPWR sky130_fd_sc_hd__tapvpwrvgnd_1
XFILLER_15_629 VGND VGND VPWR VPWR sky130_fd_sc_hd__decap_6
XTAP_TAPCELL_ROW_120_2258 VGND VPWR sky130_fd_sc_hd__tapvpwrvgnd_1
XFILLER_70_768 VGND VGND VPWR VPWR sky130_fd_sc_hd__fill_1
XFILLER_14_139 VGND VGND VPWR VPWR sky130_fd_sc_hd__fill_1
X_08558_ net119 _04257_ _01585_ VGND VGND VPWR VPWR _00808_ sky130_fd_sc_hd__mux2_1
X_07509_ cpuregs\[26\]\[27\] _02696_ _03568_ VGND VGND VPWR VPWR _00447_ sky130_fd_sc_hd__mux2_1
X_08489_ net73 net42 _04208_ VGND VGND VPWR VPWR _00787_ sky130_fd_sc_hd__mux2_1
XFILLER_23_673 VPWR VGND VPWR VGND sky130_ef_sc_hd__decap_12
XFILLER_50_492 VPWR VGND VPWR VGND sky130_ef_sc_hd__decap_12
X_10520_ clknet_leaf_130_clk _00650_ VGND VGND VPWR VPWR reg_pc\[6\] sky130_fd_sc_hd__dfxtp_2
X_10451_ clknet_leaf_110_clk _00581_ VGND VGND VPWR VPWR count_instr\[0\] sky130_fd_sc_hd__dfxtp_2
XFILLER_7_839 VGND VGND VPWR VPWR sky130_fd_sc_hd__fill_1
XFILLER_136_542 VGND VGND VPWR VPWR sky130_fd_sc_hd__decap_8
XFILLER_136_520 VPWR VGND VPWR VGND sky130_ef_sc_hd__decap_12
XFILLER_151_501 VGND VGND VPWR VPWR sky130_fd_sc_hd__decap_3
XTAP_TAPCELL_ROW_135_2490 VGND VPWR sky130_fd_sc_hd__tapvpwrvgnd_1
X_10382_ clknet_leaf_42_clk _00512_ VGND VGND VPWR VPWR cpuregs\[25\]\[28\] sky130_fd_sc_hd__dfxtp_1
XFILLER_123_225 VPWR VGND VPWR VGND sky130_ef_sc_hd__decap_12
XFILLER_2_533 VPWR VGND VPWR VGND sky130_ef_sc_hd__decap_12
X_11003_ clknet_leaf_141_clk _01065_ VGND VGND VPWR VPWR cpuregs\[19\]\[3\] sky130_fd_sc_hd__dfxtp_1
XFILLER_78_879 VGND VGND VPWR VPWR sky130_fd_sc_hd__decap_4
XFILLER_77_345 VGND VGND VPWR VPWR sky130_fd_sc_hd__fill_1
XFILLER_77_334 VGND VGND VPWR VPWR sky130_fd_sc_hd__fill_2
XFILLER_73_595 VGND VGND VPWR VPWR sky130_fd_sc_hd__decap_8
X_10718_ clknet_leaf_17_clk _00815_ VGND VGND VPWR VPWR net234 sky130_fd_sc_hd__dfxtp_2
XFILLER_9_143 VGND VGND VPWR VPWR sky130_fd_sc_hd__fill_1
XFILLER_41_470 VGND VGND VPWR VPWR sky130_fd_sc_hd__decap_4
XFILLER_146_306 VGND VGND VPWR VPWR sky130_fd_sc_hd__fill_2
X_10649_ clknet_leaf_131_clk _04907_ VGND VGND VPWR VPWR reg_out\[7\] sky130_fd_sc_hd__dfxtp_1
Xrebuffer2 net387 VGND VGND VPWR VPWR net388 sky130_fd_sc_hd__dlygate4sd1_1
XFILLER_6_861 VGND VGND VPWR VPWR sky130_fd_sc_hd__decap_6
XFILLER_142_512 VPWR VGND VPWR VGND sky130_ef_sc_hd__decap_12
XFILLER_115_737 VGND VGND VPWR VPWR sky130_fd_sc_hd__decap_3
XFILLER_114_214 VPWR VGND VPWR VGND sky130_ef_sc_hd__decap_12
XTAP_TAPCELL_ROW_58_1267 VGND VPWR sky130_fd_sc_hd__tapvpwrvgnd_1
XTAP_TAPCELL_ROW_58_1256 VGND VPWR sky130_fd_sc_hd__tapvpwrvgnd_1
XFILLER_114_247 VGND VGND VPWR VPWR sky130_fd_sc_hd__decap_4
XFILLER_5_393 VPWR VGND VPWR VGND sky130_ef_sc_hd__decap_12
XPHY_EDGE_ROW_39_Left_193 VGND VGND VPWR VPWR sky130_fd_sc_hd__decap_3
XFILLER_123_770 VPWR VGND VPWR VGND sky130_ef_sc_hd__decap_12
XFILLER_110_431 VGND VGND VPWR VPWR sky130_fd_sc_hd__fill_1
X_07860_ reg_pc\[18\] _01624_ _01628_ _03705_ VGND VGND VPWR VPWR _00662_ sky130_fd_sc_hd__a22o_1
XFILLER_96_643 VGND VGND VPWR VPWR sky130_fd_sc_hd__fill_1
XTAP_TAPCELL_ROW_71_1467 VGND VPWR sky130_fd_sc_hd__tapvpwrvgnd_1
XFILLER_69_868 VGND VGND VPWR VPWR sky130_fd_sc_hd__decap_3
XFILLER_3_51 VGND VGND VPWR VPWR sky130_fd_sc_hd__decap_4
X_06811_ _00014_ _03225_ _00016_ VGND VGND VPWR VPWR _03231_ sky130_fd_sc_hd__o21a_1
XFILLER_110_475 VGND VGND VPWR VPWR sky130_fd_sc_hd__fill_1
XFILLER_95_153 VGND VGND VPWR VPWR sky130_fd_sc_hd__fill_1
X_07791_ count_instr\[51\] _03664_ _03666_ VGND VGND VPWR VPWR _00632_ sky130_fd_sc_hd__o21a_1
XFILLER_83_315 VGND VGND VPWR VPWR sky130_fd_sc_hd__fill_1
XFILLER_68_378 VGND VGND VPWR VPWR sky130_fd_sc_hd__fill_1
XFILLER_83_337 VGND VGND VPWR VPWR sky130_fd_sc_hd__decap_8
X_06742_ _03033_ _03059_ _03163_ VGND VGND VPWR VPWR _03164_ sky130_fd_sc_hd__o21ai_2
X_09530_ cpuregs\[23\]\[2\] _02590_ _04866_ VGND VGND VPWR VPWR _01192_ sky130_fd_sc_hd__mux2_1
XFILLER_25_905 VGND VGND VPWR VPWR sky130_fd_sc_hd__decap_3
X_09461_ latched_rd\[1\] latched_rd\[0\] _03565_ VGND VGND VPWR VPWR _04864_ sky130_fd_sc_hd__nor3b_4
XFILLER_36_253 VGND VGND VPWR VPWR sky130_fd_sc_hd__decap_8
X_06673_ cpuregs\[0\]\[13\] cpuregs\[1\]\[13\] cpuregs\[2\]\[13\] cpuregs\[3\]\[13\]
+ net265 net260 VGND VGND VPWR VPWR _03098_ sky130_fd_sc_hd__mux4_1
X_05624_ _01566_ net220 _02206_ VGND VGND VPWR VPWR _02207_ sky130_fd_sc_hd__o21a_1
X_08412_ count_cycle\[56\] _04154_ _04156_ VGND VGND VPWR VPWR _00763_ sky130_fd_sc_hd__o21a_1
X_09392_ mem_rdata_q\[21\] _04791_ VGND VGND VPWR VPWR _04860_ sky130_fd_sc_hd__and2_1
XFILLER_149_111 VGND VGND VPWR VPWR sky130_fd_sc_hd__fill_1
X_08343_ _04113_ net34 _04112_ VGND VGND VPWR VPWR _00737_ sky130_fd_sc_hd__and3b_1
X_05555_ _02133_ _02137_ VGND VGND VPWR VPWR _02138_ sky130_fd_sc_hd__nor2_1
X_08274_ count_cycle\[6\] _04067_ net34 VGND VGND VPWR VPWR _04069_ sky130_fd_sc_hd__o21ai_1
XFILLER_20_610 VGND VGND VPWR VPWR sky130_fd_sc_hd__decap_8
X_05486_ net194 net226 VGND VGND VPWR VPWR _02069_ sky130_fd_sc_hd__nor2_1
XFILLER_22_27 VGND VGND VPWR VPWR sky130_fd_sc_hd__fill_1
X_07225_ cpuregs\[13\]\[9\] _02621_ net251 VGND VGND VPWR VPWR _00173_ sky130_fd_sc_hd__mux2_1
XFILLER_138_27 VGND VGND VPWR VPWR sky130_fd_sc_hd__fill_1
XFILLER_118_531 VGND VGND VPWR VPWR sky130_fd_sc_hd__fill_1
XFILLER_20_698 VGND VGND VPWR VPWR sky130_fd_sc_hd__fill_2
XFILLER_152_309 VPWR VGND VPWR VGND sky130_ef_sc_hd__decap_12
X_07156_ cpuregs\[12\]\[10\] _02624_ net253 VGND VGND VPWR VPWR _00110_ sky130_fd_sc_hd__mux2_1
X_07087_ _03493_ _03494_ _01579_ VGND VGND VPWR VPWR _03497_ sky130_fd_sc_hd__mux2_1
XFILLER_105_225 VGND VGND VPWR VPWR sky130_fd_sc_hd__fill_2
X_06107_ is_slli_srli_srai decoded_imm_j\[4\] cpu_state\[4\] VGND VGND VPWR VPWR _02578_
+ sky130_fd_sc_hd__a21oi_1
X_06038_ decoded_imm_j\[18\] _01112_ _02513_ VGND VGND VPWR VPWR _00035_ sky130_fd_sc_hd__mux2_1
XFILLER_120_206 VGND VGND VPWR VPWR sky130_fd_sc_hd__decap_8
XFILLER_101_464 VGND VGND VPWR VPWR sky130_fd_sc_hd__fill_1
XFILLER_86_197 VGND VGND VPWR VPWR sky130_fd_sc_hd__decap_6
XFILLER_86_175 VPWR VGND VPWR VGND sky130_ef_sc_hd__decap_12
X_07989_ _03697_ _03796_ VGND VGND VPWR VPWR _03812_ sky130_fd_sc_hd__nand2_1
X_09728_ _02588_ cpuregs\[6\]\[1\] _04873_ VGND VGND VPWR VPWR _01383_ sky130_fd_sc_hd__mux2_1
XPHY_EDGE_ROW_29_Right_29 VGND VGND VPWR VPWR sky130_fd_sc_hd__decap_3
XFILLER_47_57 VGND VGND VPWR VPWR sky130_fd_sc_hd__fill_2
XTAP_TAPCELL_ROW_2_363 VGND VPWR sky130_fd_sc_hd__tapvpwrvgnd_1
XFILLER_16_905 VGND VGND VPWR VPWR sky130_fd_sc_hd__decap_4
XFILLER_70_510 VGND VGND VPWR VPWR sky130_fd_sc_hd__decap_8
XFILLER_55_584 VPWR VGND VPWR VGND sky130_ef_sc_hd__decap_12
XFILLER_15_404 VGND VGND VPWR VPWR sky130_fd_sc_hd__decap_6
X_09659_ latched_rd\[3\] latched_rd\[4\] latched_rd\[2\] VGND VGND VPWR VPWR _04870_
+ sky130_fd_sc_hd__or3b_4
XFILLER_151_3 VPWR VGND VPWR VGND sky130_ef_sc_hd__decap_12
XFILLER_43_746 VGND VGND VPWR VPWR sky130_fd_sc_hd__decap_4
XTAP_TAPCELL_ROW_42_1002 VGND VPWR sky130_fd_sc_hd__tapvpwrvgnd_1
XTAP_TAPCELL_ROW_100_1939 VGND VPWR sky130_fd_sc_hd__tapvpwrvgnd_1
XTAP_TAPCELL_ROW_100_1928 VGND VPWR sky130_fd_sc_hd__tapvpwrvgnd_1
XFILLER_8_29 VPWR VGND VPWR VGND sky130_ef_sc_hd__decap_12
XTAP_TAPCELL_ROW_137_2530 VGND VPWR sky130_fd_sc_hd__tapvpwrvgnd_1
XFILLER_128_306 VGND VGND VPWR VPWR sky130_fd_sc_hd__fill_2
XPHY_EDGE_ROW_38_Right_38 VGND VGND VPWR VPWR sky130_fd_sc_hd__decap_3
X_10503_ clknet_leaf_84_clk _00633_ VGND VGND VPWR VPWR count_instr\[52\] sky130_fd_sc_hd__dfxtp_1
X_11483_ clknet_leaf_24_clk _01527_ VGND VGND VPWR VPWR cpuregs\[10\]\[17\] sky130_fd_sc_hd__dfxtp_1
XTAP_TAPCELL_ROW_21_660 VGND VPWR sky130_fd_sc_hd__tapvpwrvgnd_1
XTAP_TAPCELL_ROW_21_671 VGND VPWR sky130_fd_sc_hd__tapvpwrvgnd_1
XTAP_TAPCELL_ROW_150_2730 VGND VPWR sky130_fd_sc_hd__tapvpwrvgnd_1
X_10434_ clknet_leaf_54_clk _00564_ VGND VGND VPWR VPWR cpuregs\[17\]\[16\] sky130_fd_sc_hd__dfxtp_1
XFILLER_10_197 VPWR VGND VPWR VGND sky130_ef_sc_hd__decap_12
XFILLER_137_895 VGND VGND VPWR VPWR sky130_fd_sc_hd__fill_1
X_10365_ clknet_leaf_147_clk _00495_ VGND VGND VPWR VPWR cpuregs\[25\]\[11\] sky130_fd_sc_hd__dfxtp_1
XFILLER_88_53 VPWR VGND VPWR VGND sky130_ef_sc_hd__decap_12
XFILLER_3_853 VPWR VGND VPWR VGND sky130_ef_sc_hd__decap_12
XFILLER_151_375 VGND VGND VPWR VPWR sky130_fd_sc_hd__fill_1
XFILLER_124_578 VGND VGND VPWR VPWR sky130_fd_sc_hd__decap_8
XFILLER_111_206 VPWR VGND VPWR VGND sky130_ef_sc_hd__decap_12
XFILLER_97_429 VGND VGND VPWR VPWR sky130_fd_sc_hd__decap_4
XFILLER_3_897 VPWR VGND VPWR VGND sky130_ef_sc_hd__decap_12
XFILLER_2_363 VGND VGND VPWR VPWR sky130_fd_sc_hd__fill_1
X_10296_ clknet_leaf_2_clk _00426_ VGND VGND VPWR VPWR cpuregs\[26\]\[6\] sky130_fd_sc_hd__dfxtp_1
XTAP_TAPCELL_ROW_148_2692 VGND VPWR sky130_fd_sc_hd__tapvpwrvgnd_1
XFILLER_120_773 VPWR VGND VPWR VGND sky130_ef_sc_hd__decap_12
XTAP_TAPCELL_ROW_53_1186 VGND VPWR sky130_fd_sc_hd__tapvpwrvgnd_1
XTAP_TAPCELL_ROW_53_1175 VGND VPWR sky130_fd_sc_hd__tapvpwrvgnd_1
XPHY_EDGE_ROW_47_Right_47 VGND VGND VPWR VPWR sky130_fd_sc_hd__decap_3
XFILLER_65_337 VGND VGND VPWR VPWR sky130_fd_sc_hd__decap_3
XFILLER_19_710 VGND VGND VPWR VPWR sky130_fd_sc_hd__fill_2
XFILLER_46_540 VGND VGND VPWR VPWR sky130_fd_sc_hd__fill_1
XFILLER_34_735 VGND VGND VPWR VPWR sky130_fd_sc_hd__fill_2
XTAP_TAPCELL_ROW_29_793 VGND VPWR sky130_fd_sc_hd__tapvpwrvgnd_1
XFILLER_33_223 VGND VGND VPWR VPWR sky130_fd_sc_hd__fill_1
X_05340_ reg_pc\[22\] decoded_imm\[22\] VGND VGND VPWR VPWR _01933_ sky130_fd_sc_hd__xnor2_1
XPHY_EDGE_ROW_56_Right_56 VGND VGND VPWR VPWR sky130_fd_sc_hd__decap_3
XFILLER_147_615 VGND VGND VPWR VPWR sky130_fd_sc_hd__fill_1
X_05271_ net8 _01665_ _01856_ VGND VGND VPWR VPWR _01870_ sky130_fd_sc_hd__a21o_1
XFILLER_143_810 VPWR VGND VPWR VGND sky130_ef_sc_hd__decap_12
Xpicorv32_301 VGND VGND VPWR VPWR picorv32_301/HI eoi[20] sky130_fd_sc_hd__conb_1
XFILLER_127_350 VGND VGND VPWR VPWR sky130_fd_sc_hd__decap_4
X_07010_ net188 _03422_ net237 VGND VGND VPWR VPWR _00094_ sky130_fd_sc_hd__mux2_1
Xpicorv32_345 VGND VGND VPWR VPWR picorv32_345/HI pcpi_insn[28] sky130_fd_sc_hd__conb_1
Xpicorv32_312 VGND VGND VPWR VPWR picorv32_312/HI eoi[31] sky130_fd_sc_hd__conb_1
XTAP_TAPCELL_ROW_73_1507 VGND VPWR sky130_fd_sc_hd__tapvpwrvgnd_1
Xpicorv32_323 VGND VGND VPWR VPWR picorv32_323/HI pcpi_insn[6] sky130_fd_sc_hd__conb_1
Xpicorv32_334 VGND VGND VPWR VPWR picorv32_334/HI pcpi_insn[17] sky130_fd_sc_hd__conb_1
XPHY_EDGE_ROW_47_Left_201 VGND VGND VPWR VPWR sky130_fd_sc_hd__decap_3
Xpicorv32_367 VGND VGND VPWR VPWR picorv32_367/HI trace_data[17] sky130_fd_sc_hd__conb_1
XFILLER_143_865 VPWR VGND VPWR VGND sky130_ef_sc_hd__decap_12
XFILLER_115_545 VPWR VGND VPWR VGND sky130_ef_sc_hd__decap_12
Xpicorv32_378 VGND VGND VPWR VPWR picorv32_378/HI trace_data[28] sky130_fd_sc_hd__conb_1
Xpicorv32_356 VGND VGND VPWR VPWR picorv32_356/HI trace_data[6] sky130_fd_sc_hd__conb_1
XFILLER_142_386 VGND VGND VPWR VPWR sky130_fd_sc_hd__decap_3
X_08961_ _01558_ _04636_ VGND VGND VPWR VPWR _04637_ sky130_fd_sc_hd__or2_1
XFILLER_102_206 VPWR VGND VPWR VGND sky130_ef_sc_hd__decap_12
XPHY_EDGE_ROW_65_Right_65 VGND VGND VPWR VPWR sky130_fd_sc_hd__decap_3
X_08892_ _04568_ _04570_ _04571_ _00010_ _01560_ VGND VGND VPWR VPWR _04572_ sky130_fd_sc_hd__a221o_1
XFILLER_124_29 VPWR VGND VPWR VGND sky130_ef_sc_hd__decap_12
XFILLER_102_239 VPWR VGND VPWR VGND sky130_ef_sc_hd__decap_12
X_07912_ _03740_ _03741_ reg_next_pc\[3\] _01624_ VGND VGND VPWR VPWR _00678_ sky130_fd_sc_hd__a2bb2o_1
X_07843_ _02622_ reg_next_pc\[10\] _02482_ VGND VGND VPWR VPWR _03697_ sky130_fd_sc_hd__mux2_4
XFILLER_57_816 VGND VGND VPWR VPWR sky130_fd_sc_hd__fill_1
XFILLER_110_283 VGND VGND VPWR VPWR sky130_fd_sc_hd__decap_4
XFILLER_83_101 VGND VGND VPWR VPWR sky130_fd_sc_hd__decap_8
XFILLER_83_156 VGND VGND VPWR VPWR sky130_fd_sc_hd__decap_6
X_07774_ count_instr\[45\] _03654_ _01549_ VGND VGND VPWR VPWR _03656_ sky130_fd_sc_hd__a21oi_1
XPHY_EDGE_ROW_56_Left_210 VGND VGND VPWR VPWR sky130_fd_sc_hd__decap_3
X_04986_ mem_do_prefetch _01613_ VGND VGND VPWR VPWR _01614_ sky130_fd_sc_hd__nand2_4
XFILLER_17_27 VPWR VGND VPWR VGND sky130_ef_sc_hd__decap_12
X_09513_ cpuregs\[31\]\[18\] _02657_ _04865_ VGND VGND VPWR VPWR _01176_ sky130_fd_sc_hd__mux2_1
XFILLER_83_167 VGND VGND VPWR VPWR sky130_fd_sc_hd__fill_1
X_06725_ cpuregs\[8\]\[15\] cpuregs\[9\]\[15\] cpuregs\[10\]\[15\] cpuregs\[11\]\[15\]
+ net263 net259 VGND VGND VPWR VPWR _03148_ sky130_fd_sc_hd__mux4_1
XTAP_TAPCELL_ROW_84_1669 VGND VPWR sky130_fd_sc_hd__tapvpwrvgnd_1
X_09444_ _02646_ cpuregs\[19\]\[15\] _04863_ VGND VGND VPWR VPWR _01077_ sky130_fd_sc_hd__mux2_1
X_06656_ net174 _03081_ net236 VGND VGND VPWR VPWR _00081_ sky130_fd_sc_hd__mux2_1
XFILLER_37_595 VGND VGND VPWR VPWR sky130_fd_sc_hd__decap_8
XPHY_EDGE_ROW_74_Right_74 VGND VGND VPWR VPWR sky130_fd_sc_hd__decap_3
X_05607_ net200 _01572_ _02189_ VGND VGND VPWR VPWR _02190_ sky130_fd_sc_hd__o21a_1
XFILLER_33_15 VPWR VGND VPWR VGND sky130_ef_sc_hd__decap_12
XFILLER_149_15 VPWR VGND VPWR VGND sky130_ef_sc_hd__decap_12
X_06587_ _02744_ _02931_ _03013_ _03014_ VGND VGND VPWR VPWR _03015_ sky130_fd_sc_hd__a31o_1
X_09375_ instr_jal decoded_imm_j\[8\] _04823_ mem_rdata_q\[28\] _04747_ VGND VGND
+ VPWR VPWR _04850_ sky130_fd_sc_hd__a221o_1
XFILLER_138_604 VGND VGND VPWR VPWR sky130_fd_sc_hd__fill_1
X_08326_ count_cycle\[24\] _04100_ net34 VGND VGND VPWR VPWR _04103_ sky130_fd_sc_hd__o21ai_1
X_05538_ net172 net204 VGND VGND VPWR VPWR _02121_ sky130_fd_sc_hd__and2_1
XFILLER_20_440 VGND VGND VPWR VPWR sky130_fd_sc_hd__decap_4
X_05469_ _02049_ _02051_ VGND VGND VPWR VPWR _02052_ sky130_fd_sc_hd__nor2_1
X_08257_ _03575_ _04057_ _04058_ VGND VGND VPWR VPWR _04059_ sky130_fd_sc_hd__a21o_1
XFILLER_137_169 VGND VGND VPWR VPWR sky130_fd_sc_hd__decap_8
X_07208_ cpuregs\[30\]\[26\] _02691_ _03556_ VGND VGND VPWR VPWR _00158_ sky130_fd_sc_hd__mux2_1
X_08188_ _03575_ _03994_ _03995_ VGND VGND VPWR VPWR _03996_ sky130_fd_sc_hd__a21oi_1
XFILLER_4_606 VGND VGND VPWR VPWR sky130_fd_sc_hd__fill_1
XFILLER_152_139 VGND VGND VPWR VPWR sky130_fd_sc_hd__fill_1
XFILLER_146_681 VGND VGND VPWR VPWR sky130_fd_sc_hd__decap_8
XFILLER_119_895 VGND VGND VPWR VPWR sky130_fd_sc_hd__fill_1
XFILLER_118_361 VGND VGND VPWR VPWR sky130_fd_sc_hd__decap_3
XTAP_TAPCELL_ROW_115_2179 VGND VPWR sky130_fd_sc_hd__tapvpwrvgnd_1
XTAP_TAPCELL_ROW_115_2168 VGND VPWR sky130_fd_sc_hd__tapvpwrvgnd_1
X_07139_ reg_pc\[30\] _02751_ _03546_ _02715_ VGND VGND VPWR VPWR _03547_ sky130_fd_sc_hd__a211o_1
XFILLER_3_105 VGND VGND VPWR VPWR sky130_fd_sc_hd__decap_6
XFILLER_106_545 VGND VGND VPWR VPWR sky130_fd_sc_hd__decap_6
XPHY_EDGE_ROW_83_Right_83 VGND VGND VPWR VPWR sky130_fd_sc_hd__decap_3
XFILLER_3_149 VPWR VGND VPWR VGND sky130_ef_sc_hd__decap_12
X_10150_ clknet_leaf_77_clk _00280_ VGND VGND VPWR VPWR cpuregs\[21\]\[20\] sky130_fd_sc_hd__dfxtp_1
XFILLER_106_578 VGND VGND VPWR VPWR sky130_fd_sc_hd__fill_1
XFILLER_121_559 VGND VGND VPWR VPWR sky130_fd_sc_hd__fill_1
X_10081_ clknet_leaf_25_clk _00211_ VGND VGND VPWR VPWR cpuregs\[2\]\[15\] sky130_fd_sc_hd__dfxtp_1
XTAP_TAPCELL_ROW_7_444 VGND VPWR sky130_fd_sc_hd__tapvpwrvgnd_1
XFILLER_102_773 VGND VGND VPWR VPWR sky130_fd_sc_hd__decap_8
XFILLER_0_867 VGND VGND VPWR VPWR sky130_fd_sc_hd__fill_1
XFILLER_75_635 VPWR VGND VPWR VGND sky130_ef_sc_hd__decap_12
XFILLER_47_337 VGND VGND VPWR VPWR sky130_fd_sc_hd__fill_1
XFILLER_47_359 VPWR VGND VPWR VGND sky130_ef_sc_hd__decap_12
XFILLER_90_638 VGND VGND VPWR VPWR sky130_fd_sc_hd__decap_6
X_10983_ clknet_leaf_21_clk _01045_ VGND VGND VPWR VPWR cpuregs\[18\]\[15\] sky130_fd_sc_hd__dfxtp_1
Xclkbuf_leaf_148_clk clknet_4_2_0_clk VGND VGND VPWR VPWR clknet_leaf_148_clk sky130_fd_sc_hd__clkbuf_8
XPHY_EDGE_ROW_92_Right_92 VGND VGND VPWR VPWR sky130_fd_sc_hd__decap_3
XFILLER_83_690 VGND VGND VPWR VPWR sky130_fd_sc_hd__fill_2
XFILLER_55_381 VGND VGND VPWR VPWR sky130_fd_sc_hd__decap_4
XFILLER_15_223 VGND VGND VPWR VPWR sky130_fd_sc_hd__fill_1
XFILLER_16_757 VGND VGND VPWR VPWR sky130_fd_sc_hd__decap_6
XTAP_TAPCELL_ROW_26_741 VGND VPWR sky130_fd_sc_hd__tapvpwrvgnd_1
XPHY_EDGE_ROW_133_Right_133 VGND VGND VPWR VPWR sky130_fd_sc_hd__decap_3
XFILLER_90_21 VGND VGND VPWR VPWR sky130_fd_sc_hd__decap_6
XFILLER_15_278 VGND VGND VPWR VPWR sky130_fd_sc_hd__fill_2
XFILLER_16_779 VPWR VGND VPWR VGND sky130_ef_sc_hd__decap_12
XTAP_TAPCELL_ROW_26_752 VGND VPWR sky130_fd_sc_hd__tapvpwrvgnd_1
XFILLER_43_587 VPWR VGND VPWR VGND sky130_ef_sc_hd__decap_12
XFILLER_90_43 VPWR VGND VPWR VGND sky130_ef_sc_hd__decap_12
XFILLER_15_289 VGND VGND VPWR VPWR sky130_fd_sc_hd__fill_1
XFILLER_90_76 VGND VGND VPWR VPWR sky130_fd_sc_hd__decap_8
XFILLER_128_136 VGND VGND VPWR VPWR sky130_fd_sc_hd__decap_4
XFILLER_116_309 VPWR VGND VPWR VGND sky130_ef_sc_hd__decap_12
XFILLER_143_106 VGND VGND VPWR VPWR sky130_fd_sc_hd__decap_6
XFILLER_125_832 VGND VGND VPWR VPWR sky130_fd_sc_hd__decap_8
XFILLER_99_41 VGND VGND VPWR VPWR sky130_fd_sc_hd__fill_1
X_11466_ clknet_leaf_125_clk _01510_ VGND VGND VPWR VPWR cpuregs\[10\]\[0\] sky130_fd_sc_hd__dfxtp_1
XFILLER_125_865 VPWR VGND VPWR VGND sky130_ef_sc_hd__decap_12
X_11397_ clknet_leaf_38_clk _01441_ VGND VGND VPWR VPWR cpuregs\[7\]\[27\] sky130_fd_sc_hd__dfxtp_1
X_10417_ clknet_leaf_17_clk _00547_ VGND VGND VPWR VPWR cpuregs\[20\]\[31\] sky130_fd_sc_hd__dfxtp_1
XTAP_TAPCELL_ROW_55_1215 VGND VPWR sky130_fd_sc_hd__tapvpwrvgnd_1
XTAP_TAPCELL_ROW_55_1204 VGND VPWR sky130_fd_sc_hd__tapvpwrvgnd_1
XFILLER_151_161 VGND VGND VPWR VPWR sky130_fd_sc_hd__decap_6
X_10348_ clknet_leaf_46_clk _00478_ VGND VGND VPWR VPWR cpuregs\[16\]\[26\] sky130_fd_sc_hd__dfxtp_1
XFILLER_140_813 VPWR VGND VPWR VGND sky130_ef_sc_hd__decap_12
XFILLER_97_204 VGND VGND VPWR VPWR sky130_fd_sc_hd__decap_8
X_10279_ clknet_leaf_80_clk _00409_ VGND VGND VPWR VPWR cpuregs\[15\]\[21\] sky130_fd_sc_hd__dfxtp_1
Xclone210 net599 net603 VGND VGND VPWR VPWR net596 sky130_fd_sc_hd__nand2_4
XFILLER_78_473 VGND VGND VPWR VPWR sky130_fd_sc_hd__decap_3
XFILLER_93_454 VGND VGND VPWR VPWR sky130_fd_sc_hd__decap_8
XFILLER_66_657 VPWR VGND VPWR VGND sky130_ef_sc_hd__decap_12
XFILLER_54_819 VGND VGND VPWR VPWR sky130_fd_sc_hd__fill_1
XFILLER_93_498 VGND VGND VPWR VPWR sky130_fd_sc_hd__decap_6
XFILLER_65_178 VGND VGND VPWR VPWR sky130_fd_sc_hd__decap_6
XFILLER_0_41 VPWR VGND VPWR VGND sky130_ef_sc_hd__decap_12
XFILLER_19_573 VGND VGND VPWR VPWR sky130_fd_sc_hd__decap_4
Xclkbuf_leaf_139_clk clknet_4_2_0_clk VGND VGND VPWR VPWR clknet_leaf_139_clk sky130_fd_sc_hd__clkbuf_8
XFILLER_0_85 VPWR VGND VPWR VGND sky130_ef_sc_hd__decap_12
X_06510_ cpuregs\[8\]\[7\] cpuregs\[9\]\[7\] cpuregs\[10\]\[7\] cpuregs\[11\]\[7\]
+ net264 net259 VGND VGND VPWR VPWR _02941_ sky130_fd_sc_hd__mux4_1
X_07490_ cpuregs\[26\]\[8\] _02616_ _03568_ VGND VGND VPWR VPWR _00428_ sky130_fd_sc_hd__mux2_1
XTAP_TAPCELL_ROW_66_1388 VGND VPWR sky130_fd_sc_hd__tapvpwrvgnd_1
X_06441_ _02872_ _02873_ VGND VGND VPWR VPWR _02874_ sky130_fd_sc_hd__nand2_1
XPHY_EDGE_ROW_100_Right_100 VGND VGND VPWR VPWR sky130_fd_sc_hd__decap_3
XFILLER_22_749 VGND VGND VPWR VPWR sky130_fd_sc_hd__decap_6
X_09160_ _04775_ _04776_ _04777_ VGND VGND VPWR VPWR _04778_ sky130_fd_sc_hd__or3_1
X_06372_ decoded_imm\[3\] net196 VGND VGND VPWR VPWR _02807_ sky130_fd_sc_hd__nor2_1
XFILLER_147_423 VGND VGND VPWR VPWR sky130_fd_sc_hd__decap_4
X_08111_ _01551_ _03922_ _03924_ _03575_ VGND VGND VPWR VPWR _03925_ sky130_fd_sc_hd__o211a_1
X_05323_ count_cycle\[20\] _01588_ VGND VGND VPWR VPWR _01918_ sky130_fd_sc_hd__or2_1
X_09091_ _01555_ decoder_pseudo_trigger VGND VGND VPWR VPWR _04746_ sky130_fd_sc_hd__nor2_8
X_05254_ _01851_ _01852_ _01853_ VGND VGND VPWR VPWR _01854_ sky130_fd_sc_hd__a21oi_1
X_08042_ _03859_ _03860_ VGND VGND VPWR VPWR _03861_ sky130_fd_sc_hd__or2_1
X_05185_ reg_pc\[10\] decoded_imm\[10\] VGND VGND VPWR VPWR _01790_ sky130_fd_sc_hd__xnor2_1
X_09993_ clknet_leaf_50_clk _00123_ VGND VGND VPWR VPWR cpuregs\[12\]\[23\] sky130_fd_sc_hd__dfxtp_1
XFILLER_115_353 VGND VGND VPWR VPWR sky130_fd_sc_hd__fill_2
XFILLER_89_727 VGND VGND VPWR VPWR sky130_fd_sc_hd__fill_1
X_08944_ _01558_ _04615_ _01560_ VGND VGND VPWR VPWR _04621_ sky130_fd_sc_hd__o21a_1
XFILLER_142_194 VGND VGND VPWR VPWR sky130_fd_sc_hd__fill_2
XFILLER_135_39 VPWR VGND VPWR VGND sky130_ef_sc_hd__decap_12
XFILLER_88_248 VGND VGND VPWR VPWR sky130_fd_sc_hd__decap_4
XFILLER_88_237 VGND VGND VPWR VPWR sky130_fd_sc_hd__fill_2
XTAP_TAPCELL_ROW_110_2098 VGND VPWR sky130_fd_sc_hd__tapvpwrvgnd_1
XTAP_TAPCELL_ROW_110_2087 VGND VPWR sky130_fd_sc_hd__tapvpwrvgnd_1
XTAP_TAPCELL_ROW_4_403 VGND VPWR sky130_fd_sc_hd__tapvpwrvgnd_1
X_08875_ net270 _04551_ _04550_ _01560_ VGND VGND VPWR VPWR _04556_ sky130_fd_sc_hd__o211a_1
XFILLER_97_793 VGND VGND VPWR VPWR sky130_fd_sc_hd__decap_6
XFILLER_84_421 VGND VGND VPWR VPWR sky130_fd_sc_hd__fill_2
XFILLER_28_15 VPWR VGND VPWR VGND sky130_ef_sc_hd__decap_12
XFILLER_29_326 VGND VGND VPWR VPWR sky130_fd_sc_hd__decap_8
XFILLER_29_337 VGND VGND VPWR VPWR sky130_fd_sc_hd__decap_3
XFILLER_151_27 VPWR VGND VPWR VGND sky130_ef_sc_hd__decap_12
XTAP_TAPCELL_ROW_86_1709 VGND VPWR sky130_fd_sc_hd__tapvpwrvgnd_1
XFILLER_57_679 VGND VGND VPWR VPWR sky130_fd_sc_hd__decap_6
X_07826_ _02589_ reg_next_pc\[2\] _02482_ VGND VGND VPWR VPWR _03688_ sky130_fd_sc_hd__mux2_2
XFILLER_72_638 VGND VGND VPWR VPWR sky130_fd_sc_hd__decap_6
X_04969_ _01590_ _01591_ _01592_ _01598_ VGND VGND VPWR VPWR _01599_ sky130_fd_sc_hd__or4_1
X_07757_ _03644_ _03645_ VGND VGND VPWR VPWR _00619_ sky130_fd_sc_hd__nor2_1
X_06708_ decoded_imm\[15\] net177 VGND VGND VPWR VPWR _03131_ sky130_fd_sc_hd__or2_1
X_07688_ net412 _03601_ VGND VGND VPWR VPWR _00594_ sky130_fd_sc_hd__nor2_1
X_06639_ net173 _02721_ _02985_ _01641_ VGND VGND VPWR VPWR _03065_ sky130_fd_sc_hd__o211a_1
X_09427_ _02712_ cpuregs\[18\]\[31\] _04862_ VGND VGND VPWR VPWR _01061_ sky130_fd_sc_hd__mux2_1
XTAP_TAPCELL_ROW_23_700 VGND VPWR sky130_fd_sc_hd__tapvpwrvgnd_1
X_09358_ instr_jal decoded_imm_j\[16\] _01589_ mem_rdata_q\[16\] VGND VGND VPWR VPWR
+ _04841_ sky130_fd_sc_hd__a22o_1
XTAP_TAPCELL_ROW_117_2208 VGND VPWR sky130_fd_sc_hd__tapvpwrvgnd_1
X_08309_ _04090_ _04091_ VGND VGND VPWR VPWR _00725_ sky130_fd_sc_hd__nor2_1
XFILLER_21_782 VGND VGND VPWR VPWR sky130_fd_sc_hd__fill_2
X_09289_ net145 net107 _04206_ VGND VGND VPWR VPWR _00975_ sky130_fd_sc_hd__mux2_1
X_11320_ clknet_leaf_24_clk _01367_ VGND VGND VPWR VPWR cpuregs\[5\]\[17\] sky130_fd_sc_hd__dfxtp_1
XTAP_TAPCELL_ROW_130_2408 VGND VPWR sky130_fd_sc_hd__tapvpwrvgnd_1
XFILLER_114_3 VGND VGND VPWR VPWR sky130_fd_sc_hd__decap_3
XFILLER_107_832 VGND VGND VPWR VPWR sky130_fd_sc_hd__fill_1
XFILLER_134_640 VGND VGND VPWR VPWR sky130_fd_sc_hd__decap_4
XTAP_TAPCELL_ROW_130_2419 VGND VPWR sky130_fd_sc_hd__tapvpwrvgnd_1
XFILLER_125_139 VPWR VGND VPWR VGND sky130_ef_sc_hd__decap_12
XFILLER_69_11 VPWR VGND VPWR VGND sky130_ef_sc_hd__decap_12
X_11251_ clknet_leaf_6_clk _01298_ VGND VGND VPWR VPWR cpuregs\[22\]\[12\] sky130_fd_sc_hd__dfxtp_1
XFILLER_122_813 VPWR VGND VPWR VGND sky130_ef_sc_hd__decap_12
XFILLER_4_469 VGND VGND VPWR VPWR sky130_fd_sc_hd__decap_6
X_11182_ clknet_leaf_143_clk _01229_ VGND VGND VPWR VPWR cpuregs\[29\]\[7\] sky130_fd_sc_hd__dfxtp_1
X_10202_ clknet_leaf_13_clk _00332_ VGND VGND VPWR VPWR cpuregs\[14\]\[8\] sky130_fd_sc_hd__dfxtp_1
X_10133_ clknet_leaf_124_clk _00263_ VGND VGND VPWR VPWR cpuregs\[21\]\[3\] sky130_fd_sc_hd__dfxtp_1
XFILLER_95_719 VGND VGND VPWR VPWR sky130_fd_sc_hd__decap_8
XFILLER_0_664 VGND VGND VPWR VPWR sky130_fd_sc_hd__decap_4
XFILLER_125_83 VGND VGND VPWR VPWR sky130_fd_sc_hd__fill_1
X_10064_ clknet_leaf_27_clk _00194_ VGND VGND VPWR VPWR cpuregs\[13\]\[30\] sky130_fd_sc_hd__dfxtp_1
XFILLER_87_281 VGND VGND VPWR VPWR sky130_fd_sc_hd__decap_4
XTAP_TAPCELL_ROW_50_1134 VGND VPWR sky130_fd_sc_hd__tapvpwrvgnd_1
XFILLER_48_613 VGND VGND VPWR VPWR sky130_fd_sc_hd__decap_6
XFILLER_0_697 VGND VGND VPWR VPWR sky130_fd_sc_hd__decap_3
XTAP_TAPCELL_ROW_145_2651 VGND VPWR sky130_fd_sc_hd__tapvpwrvgnd_1
XFILLER_91_903 VGND VGND VPWR VPWR sky130_fd_sc_hd__fill_1
XFILLER_85_87 VGND VGND VPWR VPWR sky130_fd_sc_hd__decap_8
XFILLER_141_93 VGND VGND VPWR VPWR sky130_fd_sc_hd__decap_8
XFILLER_16_565 VGND VGND VPWR VPWR sky130_fd_sc_hd__fill_2
XFILLER_31_502 VGND VGND VPWR VPWR sky130_fd_sc_hd__fill_2
X_10966_ clknet_leaf_128_clk _01028_ VGND VGND VPWR VPWR decoded_imm\[2\] sky130_fd_sc_hd__dfxtp_1
XFILLER_71_693 VGND VGND VPWR VPWR sky130_fd_sc_hd__decap_3
XTAP_TAPCELL_ROW_48_1096 VGND VPWR sky130_fd_sc_hd__tapvpwrvgnd_1
X_10897_ clknet_leaf_4_clk _00959_ VGND VGND VPWR VPWR net160 sky130_fd_sc_hd__dfxtp_1
XFILLER_148_209 VGND VGND VPWR VPWR sky130_fd_sc_hd__decap_8
XFILLER_70_192 VGND VGND VPWR VPWR sky130_fd_sc_hd__decap_4
XFILLER_129_445 VGND VGND VPWR VPWR sky130_fd_sc_hd__decap_3
XFILLER_11_281 VGND VGND VPWR VPWR sky130_fd_sc_hd__fill_2
XFILLER_12_793 VPWR VGND VPWR VGND sky130_ef_sc_hd__decap_12
XFILLER_8_797 VPWR VGND VPWR VGND sky130_ef_sc_hd__decap_12
XFILLER_7_263 VPWR VGND VPWR VGND sky130_ef_sc_hd__decap_12
X_11449_ clknet_leaf_20_clk _01493_ VGND VGND VPWR VPWR cpuregs\[0\]\[15\] sky130_fd_sc_hd__dfxtp_1
XFILLER_124_194 VGND VGND VPWR VPWR sky130_fd_sc_hd__fill_2
XFILLER_113_857 VGND VGND VPWR VPWR sky130_fd_sc_hd__decap_4
X_06990_ _01621_ _03402_ VGND VGND VPWR VPWR _03403_ sky130_fd_sc_hd__nor2_1
XFILLER_86_719 VGND VGND VPWR VPWR sky130_fd_sc_hd__fill_1
XFILLER_85_207 VGND VGND VPWR VPWR sky130_fd_sc_hd__fill_1
XFILLER_79_793 VGND VGND VPWR VPWR sky130_fd_sc_hd__fill_1
XFILLER_79_782 VGND VGND VPWR VPWR sky130_fd_sc_hd__fill_2
X_05941_ mem_wordsize\[1\] net126 net209 _01672_ VGND VGND VPWR VPWR net103 sky130_fd_sc_hd__a22o_1
XFILLER_66_421 VGND VGND VPWR VPWR sky130_fd_sc_hd__decap_8
X_05872_ _02052_ _02240_ _02429_ VGND VGND VPWR VPWR _02430_ sky130_fd_sc_hd__a21o_1
X_08660_ net234 _01585_ _04351_ _04352_ VGND VGND VPWR VPWR _00815_ sky130_fd_sc_hd__o22a_1
X_07611_ cpuregs\[20\]\[28\] _02699_ net245 VGND VGND VPWR VPWR _00544_ sky130_fd_sc_hd__mux2_1
XTAP_TAPCELL_ROW_68_1417 VGND VPWR sky130_fd_sc_hd__tapvpwrvgnd_1
XFILLER_26_307 VGND VGND VPWR VPWR sky130_fd_sc_hd__fill_1
XFILLER_35_841 VPWR VGND VPWR VGND sky130_ef_sc_hd__decap_12
X_08591_ cpuregs\[0\]\[6\] cpuregs\[1\]\[6\] cpuregs\[2\]\[6\] cpuregs\[3\]\[6\] net278
+ net273 VGND VGND VPWR VPWR _04287_ sky130_fd_sc_hd__mux4_1
X_07542_ _02691_ cpuregs\[16\]\[26\] _03570_ VGND VGND VPWR VPWR _00478_ sky130_fd_sc_hd__mux2_1
XFILLER_50_800 VPWR VGND VPWR VGND sky130_ef_sc_hd__decap_12
X_07473_ cpuregs\[15\]\[24\] _02683_ net246 VGND VGND VPWR VPWR _00412_ sky130_fd_sc_hd__mux2_1
XTAP_TAPCELL_ROW_81_1628 VGND VPWR sky130_fd_sc_hd__tapvpwrvgnd_1
XFILLER_22_524 VGND VGND VPWR VPWR sky130_fd_sc_hd__decap_3
X_09212_ mem_rdata_q\[30\] _01556_ _04751_ mem_rdata_q\[29\] mem_rdata_q\[31\] VGND
+ VGND VPWR VPWR _04796_ sky130_fd_sc_hd__a2111o_1
XFILLER_61_181 VPWR VGND VPWR VGND sky130_ef_sc_hd__decap_12
X_06424_ _00015_ _02853_ _02857_ _01581_ _02849_ VGND VGND VPWR VPWR _02858_ sky130_fd_sc_hd__o311a_1
X_09143_ net34 is_alu_reg_reg _04767_ _04769_ VGND VGND VPWR VPWR _04772_ sky130_fd_sc_hd__and4_2
XFILLER_10_719 VPWR VGND VPWR VGND sky130_ef_sc_hd__decap_12
X_06355_ _01580_ _02776_ _02780_ _02786_ _02790_ VGND VGND VPWR VPWR _02791_ sky130_fd_sc_hd__o32a_1
XFILLER_136_905 VGND VGND VPWR VPWR sky130_fd_sc_hd__decap_4
X_05306_ net11 _01665_ _01856_ VGND VGND VPWR VPWR _01902_ sky130_fd_sc_hd__a21o_1
X_09074_ mem_rdata_q\[1\] net12 _01609_ VGND VGND VPWR VPWR _01095_ sky130_fd_sc_hd__mux2_1
X_06286_ mem_do_rdata cpu_state\[6\] _01614_ _02713_ _02723_ VGND VGND VPWR VPWR _02724_
+ sky130_fd_sc_hd__a311oi_4
XFILLER_30_27 VGND VGND VPWR VPWR sky130_fd_sc_hd__fill_1
XFILLER_146_27 VGND VGND VPWR VPWR sky130_fd_sc_hd__fill_1
XTAP_TAPCELL_ROW_112_2127 VGND VPWR sky130_fd_sc_hd__tapvpwrvgnd_1
XTAP_TAPCELL_ROW_112_2116 VGND VPWR sky130_fd_sc_hd__tapvpwrvgnd_1
XTAP_TAPCELL_ROW_96_1871 VGND VPWR sky130_fd_sc_hd__tapvpwrvgnd_1
XTAP_TAPCELL_ROW_96_1860 VGND VPWR sky130_fd_sc_hd__tapvpwrvgnd_1
X_05237_ count_cycle\[13\] _01588_ net256 _01838_ VGND VGND VPWR VPWR _01839_ sky130_fd_sc_hd__o211a_1
X_08025_ _03819_ _03830_ VGND VGND VPWR VPWR _03845_ sky130_fd_sc_hd__and2_1
XFILLER_150_418 VGND VGND VPWR VPWR sky130_fd_sc_hd__fill_2
XFILLER_115_150 VGND VGND VPWR VPWR sky130_fd_sc_hd__fill_1
XFILLER_104_813 VGND VGND VPWR VPWR sky130_fd_sc_hd__fill_2
XFILLER_89_513 VGND VGND VPWR VPWR sky130_fd_sc_hd__decap_3
XFILLER_89_502 VGND VGND VPWR VPWR sky130_fd_sc_hd__fill_2
X_05168_ count_instr\[8\] instr_rdinstr count_cycle\[40\] instr_rdcycleh VGND VGND
+ VPWR VPWR _01775_ sky130_fd_sc_hd__a22o_1
XFILLER_1_417 VPWR VGND VPWR VGND sky130_ef_sc_hd__decap_12
XFILLER_131_621 VGND VGND VPWR VPWR sky130_fd_sc_hd__fill_1
XFILLER_104_846 VPWR VGND VPWR VGND sky130_ef_sc_hd__decap_12
XFILLER_130_153 VGND VGND VPWR VPWR sky130_fd_sc_hd__decap_6
X_05099_ count_instr\[35\] instr_rdinstrh instr_rdcycleh count_cycle\[35\] VGND VGND
+ VPWR VPWR _01711_ sky130_fd_sc_hd__a22o_1
X_09976_ clknet_leaf_1_clk _00106_ VGND VGND VPWR VPWR cpuregs\[12\]\[6\] sky130_fd_sc_hd__dfxtp_1
X_08927_ _04601_ _04603_ _04604_ net269 _00010_ VGND VGND VPWR VPWR _04605_ sky130_fd_sc_hd__a221o_1
X_08858_ _04538_ _04539_ _04266_ _04536_ VGND VGND VPWR VPWR _04540_ sky130_fd_sc_hd__o211a_1
XFILLER_130_197 VGND VGND VPWR VPWR sky130_fd_sc_hd__decap_6
XFILLER_69_281 VGND VGND VPWR VPWR sky130_fd_sc_hd__fill_1
XTAP_TAPCELL_ROW_127_2370 VGND VPWR sky130_fd_sc_hd__tapvpwrvgnd_1
X_07809_ _03674_ count_instr\[57\] count_instr\[58\] VGND VGND VPWR VPWR _03678_ sky130_fd_sc_hd__and3_1
XFILLER_84_251 VGND VGND VPWR VPWR sky130_fd_sc_hd__fill_1
XFILLER_55_35 VPWR VGND VPWR VGND sky130_ef_sc_hd__decap_12
XFILLER_45_627 VGND VGND VPWR VPWR sky130_fd_sc_hd__fill_2
X_08789_ decoded_imm\[16\] _01654_ _01586_ VGND VGND VPWR VPWR _04475_ sky130_fd_sc_hd__a21o_1
XFILLER_111_30 VGND VGND VPWR VPWR sky130_fd_sc_hd__decap_8
X_10820_ clknet_leaf_88_clk _00885_ VGND VGND VPWR VPWR instr_rdinstrh sky130_fd_sc_hd__dfxtp_4
XTAP_TAPCELL_ROW_140_2570 VGND VPWR sky130_fd_sc_hd__tapvpwrvgnd_1
XFILLER_13_513 VGND VGND VPWR VPWR sky130_fd_sc_hd__fill_1
X_10751_ clknet_leaf_134_clk alu_out\[4\] VGND VGND VPWR VPWR alu_out_q\[4\] sky130_fd_sc_hd__dfxtp_1
XFILLER_71_23 VPWR VGND VPWR VGND sky130_ef_sc_hd__decap_12
XFILLER_52_181 VGND VGND VPWR VPWR sky130_fd_sc_hd__fill_1
XFILLER_9_517 VGND VGND VPWR VPWR sky130_fd_sc_hd__decap_8
X_10682_ clknet_leaf_123_clk _00780_ VGND VGND VPWR VPWR net35 sky130_fd_sc_hd__dfxtp_1
XFILLER_13_579 VPWR VGND VPWR VGND sky130_ef_sc_hd__decap_12
XFILLER_139_754 VGND VGND VPWR VPWR sky130_fd_sc_hd__decap_8
XFILLER_138_253 VGND VGND VPWR VPWR sky130_fd_sc_hd__fill_2
XFILLER_126_437 VPWR VGND VPWR VGND sky130_ef_sc_hd__decap_12
XFILLER_4_233 VPWR VGND VPWR VGND sky130_ef_sc_hd__decap_12
X_11303_ clknet_leaf_124_clk _01350_ VGND VGND VPWR VPWR cpuregs\[5\]\[0\] sky130_fd_sc_hd__dfxtp_1
X_11234_ clknet_leaf_36_clk _01281_ VGND VGND VPWR VPWR cpuregs\[3\]\[27\] sky130_fd_sc_hd__dfxtp_1
X_11165_ clknet_leaf_46_clk _01212_ VGND VGND VPWR VPWR cpuregs\[23\]\[22\] sky130_fd_sc_hd__dfxtp_1
XFILLER_96_42 VGND VGND VPWR VPWR sky130_fd_sc_hd__fill_1
XFILLER_95_505 VPWR VGND VPWR VGND sky130_ef_sc_hd__decap_12
XFILLER_68_708 VGND VGND VPWR VPWR sky130_fd_sc_hd__decap_6
XFILLER_121_175 VPWR VGND VPWR VGND sky130_ef_sc_hd__decap_12
X_10116_ clknet_leaf_51_clk _00246_ VGND VGND VPWR VPWR cpuregs\[28\]\[18\] sky130_fd_sc_hd__dfxtp_1
X_11096_ clknet_leaf_42_clk _01153_ VGND VGND VPWR VPWR cpuregs\[24\]\[27\] sky130_fd_sc_hd__dfxtp_1
XFILLER_76_752 VGND VGND VPWR VPWR sky130_fd_sc_hd__decap_4
X_10047_ clknet_leaf_10_clk _00177_ VGND VGND VPWR VPWR cpuregs\[13\]\[13\] sky130_fd_sc_hd__dfxtp_1
XFILLER_48_421 VGND VGND VPWR VPWR sky130_fd_sc_hd__decap_4
XFILLER_17_841 VPWR VGND VPWR VGND sky130_ef_sc_hd__decap_12
XFILLER_91_777 VGND VGND VPWR VPWR sky130_fd_sc_hd__decap_6
XPHY_EDGE_ROW_11_Left_165 VGND VGND VPWR VPWR sky130_fd_sc_hd__decap_3
XFILLER_35_148 VGND VGND VPWR VPWR sky130_fd_sc_hd__fill_2
X_10949_ clknet_leaf_89_clk _01011_ VGND VGND VPWR VPWR decoded_imm\[19\] sky130_fd_sc_hd__dfxtp_2
XTAP_TAPCELL_ROW_63_1336 VGND VPWR sky130_fd_sc_hd__tapvpwrvgnd_1
Xclkbuf_leaf_70_clk clknet_4_13_0_clk VGND VGND VPWR VPWR clknet_leaf_70_clk sky130_fd_sc_hd__clkbuf_8
XTAP_TAPCELL_ROW_63_1347 VGND VPWR sky130_fd_sc_hd__tapvpwrvgnd_1
XFILLER_43_181 VGND VGND VPWR VPWR sky130_fd_sc_hd__fill_2
XTAP_TAPCELL_ROW_14_552 VGND VPWR sky130_fd_sc_hd__tapvpwrvgnd_1
XTAP_TAPCELL_ROW_14_563 VGND VPWR sky130_fd_sc_hd__tapvpwrvgnd_1
XFILLER_118_905 VGND VGND VPWR VPWR sky130_fd_sc_hd__decap_3
XFILLER_77_3 VGND VGND VPWR VPWR sky130_fd_sc_hd__decap_3
X_06140_ reg_out\[6\] alu_out_q\[6\] net589 VGND VGND VPWR VPWR _02604_ sky130_fd_sc_hd__mux2_2
XFILLER_144_245 VGND VGND VPWR VPWR sky130_fd_sc_hd__decap_6
XFILLER_144_223 VGND VGND VPWR VPWR sky130_fd_sc_hd__fill_1
X_06071_ cpuregs\[12\]\[3\] cpuregs\[13\]\[3\] cpuregs\[14\]\[3\] cpuregs\[15\]\[3\]
+ net278 net273 VGND VGND VPWR VPWR _02543_ sky130_fd_sc_hd__mux4_1
XFILLER_145_779 VGND VGND VPWR VPWR sky130_fd_sc_hd__decap_4
X_05022_ _01547_ net405 VGND VGND VPWR VPWR _01645_ sky130_fd_sc_hd__nor2_8
XPHY_EDGE_ROW_20_Left_174 VGND VGND VPWR VPWR sky130_fd_sc_hd__decap_3
XFILLER_153_790 VGND VGND VPWR VPWR sky130_fd_sc_hd__decap_4
XFILLER_116_19 VGND VGND VPWR VPWR sky130_fd_sc_hd__decap_8
XFILLER_112_131 VGND VGND VPWR VPWR sky130_fd_sc_hd__decap_8
XFILLER_59_708 VPWR VGND VPWR VGND sky130_ef_sc_hd__decap_12
X_09830_ _02598_ cpuregs\[10\]\[4\] _04876_ VGND VGND VPWR VPWR _01514_ sky130_fd_sc_hd__mux2_1
XFILLER_140_495 VGND VGND VPWR VPWR sky130_fd_sc_hd__decap_4
X_06973_ cpuregs\[12\]\[24\] cpuregs\[13\]\[24\] cpuregs\[14\]\[24\] cpuregs\[15\]\[24\]
+ net267 net261 VGND VGND VPWR VPWR _03387_ sky130_fd_sc_hd__mux4_1
XFILLER_112_153 VPWR VGND VPWR VGND sky130_ef_sc_hd__decap_12
XTAP_TAPCELL_ROW_91_1790 VGND VPWR sky130_fd_sc_hd__tapvpwrvgnd_1
XFILLER_86_516 VGND VGND VPWR VPWR sky130_fd_sc_hd__fill_2
XFILLER_58_218 VGND VGND VPWR VPWR sky130_fd_sc_hd__fill_1
X_09761_ _02588_ cpuregs\[7\]\[1\] _04874_ VGND VGND VPWR VPWR _01415_ sky130_fd_sc_hd__mux2_1
XFILLER_112_197 VPWR VGND VPWR VGND sky130_ef_sc_hd__decap_12
X_08712_ _04399_ _04401_ _04266_ _04398_ VGND VGND VPWR VPWR _04402_ sky130_fd_sc_hd__o211a_1
X_05924_ net608 _01553_ _01665_ _01668_ VGND VGND VPWR VPWR net132 sky130_fd_sc_hd__a211o_1
XFILLER_132_29 VPWR VGND VPWR VGND sky130_ef_sc_hd__decap_12
Xrebuffer12 net397 VGND VGND VPWR VPWR net398 sky130_fd_sc_hd__dlymetal6s2s_1
X_09692_ cpuregs\[4\]\[31\] _02712_ net238 VGND VGND VPWR VPWR _01349_ sky130_fd_sc_hd__mux2_1
XFILLER_39_476 VGND VGND VPWR VPWR sky130_fd_sc_hd__fill_2
X_05855_ _02413_ VGND VGND VPWR VPWR _02414_ sky130_fd_sc_hd__inv_2
XFILLER_82_744 VPWR VGND VPWR VGND sky130_ef_sc_hd__decap_12
Xrebuffer23 _04078_ VGND VGND VPWR VPWR net409 sky130_fd_sc_hd__dlygate4sd1_1
Xrebuffer45 net432 VGND VGND VPWR VPWR net431 sky130_fd_sc_hd__dlygate4sd1_1
Xrebuffer34 net421 VGND VGND VPWR VPWR net420 sky130_fd_sc_hd__dlygate4sd1_1
XFILLER_26_104 VGND VGND VPWR VPWR sky130_fd_sc_hd__fill_1
X_08643_ cpuregs\[16\]\[9\] cpuregs\[17\]\[9\] cpuregs\[18\]\[9\] cpuregs\[19\]\[9\]
+ net278 net273 VGND VGND VPWR VPWR _04336_ sky130_fd_sc_hd__mux4_1
X_05786_ _02111_ _02238_ _02240_ _02113_ _02352_ VGND VGND VPWR VPWR _02353_ sky130_fd_sc_hd__a221o_1
Xrebuffer56 _03590_ VGND VGND VPWR VPWR net442 sky130_fd_sc_hd__dlymetal6s2s_1
X_08574_ cpuregs\[0\]\[5\] cpuregs\[1\]\[5\] cpuregs\[2\]\[5\] cpuregs\[3\]\[5\] net279
+ _00008_ VGND VGND VPWR VPWR _04271_ sky130_fd_sc_hd__mux4_1
XFILLER_25_27 VPWR VGND VPWR VGND sky130_ef_sc_hd__decap_12
XFILLER_35_660 VPWR VGND VPWR VGND sky130_ef_sc_hd__decap_12
Xrebuffer67 count_cycle\[0\] VGND VGND VPWR VPWR net453 sky130_fd_sc_hd__dlygate4sd1_1
XFILLER_23_833 VGND VGND VPWR VPWR sky130_fd_sc_hd__decap_6
X_07525_ _02621_ cpuregs\[16\]\[9\] _03570_ VGND VGND VPWR VPWR _00461_ sky130_fd_sc_hd__mux2_1
XFILLER_35_682 VGND VGND VPWR VPWR sky130_fd_sc_hd__decap_4
XFILLER_34_192 VGND VGND VPWR VPWR sky130_fd_sc_hd__decap_4
X_07456_ cpuregs\[15\]\[7\] _02612_ net246 VGND VGND VPWR VPWR _00395_ sky130_fd_sc_hd__mux2_1
XFILLER_22_365 VGND VGND VPWR VPWR sky130_fd_sc_hd__decap_8
XFILLER_23_877 VPWR VGND VPWR VGND sky130_ef_sc_hd__decap_12
XTAP_TAPCELL_ROW_33_861 VGND VPWR sky130_fd_sc_hd__tapvpwrvgnd_1
XTAP_TAPCELL_ROW_98_1900 VGND VPWR sky130_fd_sc_hd__tapvpwrvgnd_1
X_07387_ cpuregs\[14\]\[5\] _02603_ net247 VGND VGND VPWR VPWR _00329_ sky130_fd_sc_hd__mux2_1
X_06407_ _01579_ _02838_ _02840_ VGND VGND VPWR VPWR _02841_ sky130_fd_sc_hd__a21o_1
X_09126_ instr_sh _04747_ _04753_ is_sb_sh_sw VGND VGND VPWR VPWR _00860_ sky130_fd_sc_hd__a22o_1
X_06338_ cpuregs\[28\]\[2\] cpuregs\[29\]\[2\] net268 VGND VGND VPWR VPWR _02774_
+ sky130_fd_sc_hd__mux2_1
XFILLER_135_223 VGND VGND VPWR VPWR sky130_fd_sc_hd__fill_1
X_06269_ _02583_ _02705_ _02708_ VGND VGND VPWR VPWR _02709_ sky130_fd_sc_hd__a21o_4
Xrebuffer179 net566 VGND VGND VPWR VPWR net565 sky130_fd_sc_hd__clkbuf_2
X_09057_ _01560_ _04727_ _01559_ VGND VGND VPWR VPWR _04728_ sky130_fd_sc_hd__a21o_1
XFILLER_135_278 VGND VGND VPWR VPWR sky130_fd_sc_hd__fill_2
X_08008_ _03828_ _03829_ net34 VGND VGND VPWR VPWR _00686_ sky130_fd_sc_hd__o21a_1
Xmax_cap280 _00007_ VGND VGND VPWR VPWR net280 sky130_fd_sc_hd__buf_12
XFILLER_89_332 VGND VGND VPWR VPWR sky130_fd_sc_hd__decap_4
XFILLER_2_737 VPWR VGND VPWR VGND sky130_ef_sc_hd__decap_12
XFILLER_1_225 VPWR VGND VPWR VGND sky130_ef_sc_hd__decap_12
XFILLER_89_343 VGND VGND VPWR VPWR sky130_fd_sc_hd__fill_1
XFILLER_77_505 VPWR VGND VPWR VGND sky130_ef_sc_hd__decap_12
XFILLER_131_484 VGND VGND VPWR VPWR sky130_fd_sc_hd__decap_4
XFILLER_106_41 VPWR VGND VPWR VGND sky130_ef_sc_hd__decap_12
X_09959_ clknet_leaf_92_clk _00089_ VGND VGND VPWR VPWR net183 sky130_fd_sc_hd__dfxtp_4
XFILLER_49_229 VGND VGND VPWR VPWR sky130_fd_sc_hd__fill_1
XTAP_TAPCELL_ROW_142_2610 VGND VPWR sky130_fd_sc_hd__tapvpwrvgnd_1
XTAP_TAPCELL_ROW_125_2329 VGND VPWR sky130_fd_sc_hd__tapvpwrvgnd_1
XFILLER_58_774 VGND VGND VPWR VPWR sky130_fd_sc_hd__fill_2
XFILLER_85_582 VGND VGND VPWR VPWR sky130_fd_sc_hd__decap_8
XFILLER_17_137 VPWR VGND VPWR VGND sky130_ef_sc_hd__decap_12
XFILLER_45_424 VGND VGND VPWR VPWR sky130_fd_sc_hd__decap_8
XFILLER_122_73 VGND VGND VPWR VPWR sky130_fd_sc_hd__decap_4
X_10803_ clknet_leaf_99_clk _00868_ VGND VGND VPWR VPWR instr_slli sky130_fd_sc_hd__dfxtp_1
Xclkbuf_leaf_52_clk clknet_4_7_0_clk VGND VGND VPWR VPWR clknet_leaf_52_clk sky130_fd_sc_hd__clkbuf_8
XFILLER_13_310 VGND VGND VPWR VPWR sky130_fd_sc_hd__decap_4
XTAP_TAPCELL_ROW_45_1044 VGND VPWR sky130_fd_sc_hd__tapvpwrvgnd_1
XTAP_TAPCELL_ROW_45_1055 VGND VPWR sky130_fd_sc_hd__tapvpwrvgnd_1
X_10734_ clknet_leaf_50_clk _00831_ VGND VGND VPWR VPWR net220 sky130_fd_sc_hd__dfxtp_4
XFILLER_9_325 VGND VGND VPWR VPWR sky130_fd_sc_hd__decap_8
XFILLER_15_93 VGND VGND VPWR VPWR sky130_fd_sc_hd__decap_6
XFILLER_41_685 VGND VGND VPWR VPWR sky130_fd_sc_hd__decap_3
X_10665_ clknet_leaf_63_clk _04893_ VGND VGND VPWR VPWR reg_out\[23\] sky130_fd_sc_hd__dfxtp_1
XTAP_TAPCELL_ROW_11_511 VGND VPWR sky130_fd_sc_hd__tapvpwrvgnd_1
XTAP_TAPCELL_ROW_11_500 VGND VPWR sky130_fd_sc_hd__tapvpwrvgnd_1
XFILLER_139_573 VGND VGND VPWR VPWR sky130_fd_sc_hd__decap_4
XTAP_TAPCELL_ROW_153_2783 VGND VPWR sky130_fd_sc_hd__tapvpwrvgnd_1
XTAP_TAPCELL_ROW_153_2772 VGND VPWR sky130_fd_sc_hd__tapvpwrvgnd_1
XFILLER_127_746 VGND VGND VPWR VPWR sky130_fd_sc_hd__fill_1
X_10596_ clknet_leaf_89_clk _00726_ VGND VGND VPWR VPWR count_cycle\[19\] sky130_fd_sc_hd__dfxtp_1
XTAP_TAPCELL_ROW_153_2794 VGND VPWR sky130_fd_sc_hd__tapvpwrvgnd_1
XFILLER_5_553 VGND VGND VPWR VPWR sky130_fd_sc_hd__decap_6
XFILLER_31_92 VPWR VGND VPWR VGND sky130_ef_sc_hd__decap_12
XFILLER_147_81 VPWR VGND VPWR VGND sky130_ef_sc_hd__decap_12
XFILLER_142_749 VGND VGND VPWR VPWR sky130_fd_sc_hd__decap_6
XFILLER_49_7 VPWR VGND VPWR VGND sky130_ef_sc_hd__decap_12
Xoutput70 net70 VGND VGND VPWR VPWR mem_la_addr[14] sky130_fd_sc_hd__buf_2
X_11217_ clknet_leaf_3_clk _01264_ VGND VGND VPWR VPWR cpuregs\[3\]\[10\] sky130_fd_sc_hd__dfxtp_1
Xoutput81 net81 VGND VGND VPWR VPWR mem_la_addr[25] sky130_fd_sc_hd__buf_2
XFILLER_150_793 VPWR VGND VPWR VGND sky130_ef_sc_hd__decap_12
X_11148_ clknet_leaf_142_clk _01195_ VGND VGND VPWR VPWR cpuregs\[23\]\[5\] sky130_fd_sc_hd__dfxtp_1
Xoutput92 net92 VGND VGND VPWR VPWR mem_la_addr[6] sky130_fd_sc_hd__buf_2
XFILLER_96_858 VGND VGND VPWR VPWR sky130_fd_sc_hd__fill_1
XFILLER_95_335 VGND VGND VPWR VPWR sky130_fd_sc_hd__fill_1
X_11079_ clknet_leaf_14_clk _01136_ VGND VGND VPWR VPWR cpuregs\[24\]\[10\] sky130_fd_sc_hd__dfxtp_1
XFILLER_49_785 VGND VGND VPWR VPWR sky130_fd_sc_hd__decap_4
XFILLER_49_763 VGND VGND VPWR VPWR sky130_fd_sc_hd__fill_2
XFILLER_63_221 VGND VGND VPWR VPWR sky130_fd_sc_hd__decap_3
X_05640_ _02098_ _02215_ _02222_ VGND VGND VPWR VPWR _02223_ sky130_fd_sc_hd__o21a_1
XFILLER_64_766 VGND VGND VPWR VPWR sky130_fd_sc_hd__fill_2
XTAP_TAPCELL_ROW_19_633 VGND VPWR sky130_fd_sc_hd__tapvpwrvgnd_1
X_05571_ net174 net206 VGND VGND VPWR VPWR _02154_ sky130_fd_sc_hd__and2_1
XFILLER_51_405 VGND VGND VPWR VPWR sky130_fd_sc_hd__fill_1
XFILLER_23_129 VGND VGND VPWR VPWR sky130_fd_sc_hd__fill_2
Xclkbuf_leaf_43_clk clknet_4_7_0_clk VGND VGND VPWR VPWR clknet_leaf_43_clk sky130_fd_sc_hd__clkbuf_8
X_07310_ cpuregs\[28\]\[28\] _02699_ net249 VGND VGND VPWR VPWR _00256_ sky130_fd_sc_hd__mux2_1
XFILLER_51_449 VGND VGND VPWR VPWR sky130_fd_sc_hd__decap_6
XFILLER_149_337 VPWR VGND VPWR VGND sky130_ef_sc_hd__decap_12
X_08290_ count_cycle\[12\] _04077_ net34 VGND VGND VPWR VPWR _04079_ sky130_fd_sc_hd__o21ai_1
XFILLER_20_825 VPWR VGND VPWR VGND sky130_ef_sc_hd__decap_12
XFILLER_31_151 VPWR VGND VPWR VGND sky130_ef_sc_hd__decap_12
XFILLER_32_685 VGND VGND VPWR VPWR sky130_fd_sc_hd__fill_1
X_07241_ cpuregs\[13\]\[25\] _02688_ net251 VGND VGND VPWR VPWR _00189_ sky130_fd_sc_hd__mux2_1
X_07172_ cpuregs\[12\]\[26\] _02691_ net253 VGND VGND VPWR VPWR _00126_ sky130_fd_sc_hd__mux2_1
XFILLER_20_869 VPWR VGND VPWR VGND sky130_ef_sc_hd__decap_12
XFILLER_145_521 VPWR VGND VPWR VGND sky130_ef_sc_hd__decap_12
XFILLER_118_757 VGND VGND VPWR VPWR sky130_fd_sc_hd__decap_4
XFILLER_117_234 VGND VGND VPWR VPWR sky130_fd_sc_hd__decap_6
X_06123_ _02590_ cpuregs\[11\]\[2\] _02582_ VGND VGND VPWR VPWR _00039_ sky130_fd_sc_hd__mux2_1
XTAP_TAPCELL_ROW_76_1549 VGND VPWR sky130_fd_sc_hd__tapvpwrvgnd_1
XFILLER_105_429 VGND VGND VPWR VPWR sky130_fd_sc_hd__decap_6
X_06054_ decoded_imm_j\[3\] decoded_imm_j\[2\] decoded_imm_j\[1\] _02525_ VGND VGND
+ VPWR VPWR _02527_ sky130_fd_sc_hd__or4_1
X_05005_ instr_lbu instr_lb _01630_ VGND VGND VPWR VPWR _01632_ sky130_fd_sc_hd__o21a_1
X_09813_ _02665_ cpuregs\[8\]\[20\] _04875_ VGND VGND VPWR VPWR _01466_ sky130_fd_sc_hd__mux2_1
XFILLER_87_814 VGND VGND VPWR VPWR sky130_fd_sc_hd__fill_2
XFILLER_143_39 VPWR VGND VPWR VGND sky130_ef_sc_hd__decap_12
XFILLER_100_112 VPWR VGND VPWR VGND sky130_ef_sc_hd__decap_12
X_06956_ _03319_ _03346_ _03347_ VGND VGND VPWR VPWR _03370_ sky130_fd_sc_hd__o21ba_1
X_09744_ _02654_ cpuregs\[6\]\[17\] _04873_ VGND VGND VPWR VPWR _01399_ sky130_fd_sc_hd__mux2_1
XTAP_TAPCELL_ROW_107_2048 VGND VPWR sky130_fd_sc_hd__tapvpwrvgnd_1
XTAP_TAPCELL_ROW_107_2037 VGND VPWR sky130_fd_sc_hd__tapvpwrvgnd_1
X_06887_ net179 _02721_ _02744_ _03303_ VGND VGND VPWR VPWR _03304_ sky130_fd_sc_hd__o211a_1
X_05907_ _02075_ _02453_ _02225_ VGND VGND VPWR VPWR _02460_ sky130_fd_sc_hd__a21oi_1
XFILLER_100_189 VGND VGND VPWR VPWR sky130_fd_sc_hd__decap_6
X_09675_ cpuregs\[4\]\[14\] _02641_ net238 VGND VGND VPWR VPWR _01332_ sky130_fd_sc_hd__mux2_1
XFILLER_36_15 VPWR VGND VPWR VGND sky130_ef_sc_hd__decap_12
X_05838_ _02380_ _02397_ _02398_ VGND VGND VPWR VPWR _02399_ sky130_fd_sc_hd__o21a_1
XTAP_TAPCELL_ROW_38_942 VGND VPWR sky130_fd_sc_hd__tapvpwrvgnd_1
X_08626_ cpuregs\[28\]\[8\] cpuregs\[29\]\[8\] cpuregs\[30\]\[8\] cpuregs\[31\]\[8\]
+ net277 net272 VGND VGND VPWR VPWR _04320_ sky130_fd_sc_hd__mux4_1
XFILLER_54_265 VPWR VGND VPWR VGND sky130_ef_sc_hd__decap_12
XTAP_TAPCELL_ROW_120_2259 VGND VPWR sky130_fd_sc_hd__tapvpwrvgnd_1
XTAP_TAPCELL_ROW_120_2248 VGND VPWR sky130_fd_sc_hd__tapvpwrvgnd_1
Xclkbuf_leaf_34_clk clknet_4_5_0_clk VGND VGND VPWR VPWR clknet_leaf_34_clk sky130_fd_sc_hd__clkbuf_8
X_05769_ _02146_ _02337_ VGND VGND VPWR VPWR _02338_ sky130_fd_sc_hd__or2_1
X_08557_ decoded_imm\[2\] _02536_ _01653_ VGND VGND VPWR VPWR _04257_ sky130_fd_sc_hd__mux2_1
X_07508_ cpuregs\[26\]\[26\] _02691_ _03568_ VGND VGND VPWR VPWR _00446_ sky130_fd_sc_hd__mux2_1
X_08488_ net72 net41 _04208_ VGND VGND VPWR VPWR _00786_ sky130_fd_sc_hd__mux2_1
XFILLER_23_685 VGND VGND VPWR VPWR sky130_fd_sc_hd__decap_6
X_07439_ cpuregs\[27\]\[23\] _02678_ _03566_ VGND VGND VPWR VPWR _00379_ sky130_fd_sc_hd__mux2_1
XTAP_TAPCELL_ROW_102_1970 VGND VPWR sky130_fd_sc_hd__tapvpwrvgnd_1
XFILLER_109_724 VGND VGND VPWR VPWR sky130_fd_sc_hd__decap_4
X_10450_ clknet_leaf_111_clk _00580_ VGND VGND VPWR VPWR net235 sky130_fd_sc_hd__dfxtp_4
XFILLER_148_381 VGND VGND VPWR VPWR sky130_fd_sc_hd__decap_4
XFILLER_108_234 VGND VGND VPWR VPWR sky130_fd_sc_hd__fill_2
X_09109_ mem_rdata_q\[12\] net4 _01609_ VGND VGND VPWR VPWR _01106_ sky130_fd_sc_hd__mux2_1
XTAP_TAPCELL_ROW_135_2491 VGND VPWR sky130_fd_sc_hd__tapvpwrvgnd_1
X_10381_ clknet_leaf_34_clk _00511_ VGND VGND VPWR VPWR cpuregs\[25\]\[27\] sky130_fd_sc_hd__dfxtp_1
XFILLER_136_587 VGND VGND VPWR VPWR sky130_fd_sc_hd__fill_1
XFILLER_123_237 VPWR VGND VPWR VGND sky130_ef_sc_hd__decap_12
XFILLER_7_3 VPWR VGND VPWR VGND sky130_ef_sc_hd__decap_12
XFILLER_2_545 VPWR VGND VPWR VGND sky130_ef_sc_hd__decap_12
XFILLER_89_151 VGND VGND VPWR VPWR sky130_fd_sc_hd__fill_1
XFILLER_77_22 VPWR VGND VPWR VGND sky130_ef_sc_hd__decap_12
XFILLER_2_589 VPWR VGND VPWR VGND sky130_ef_sc_hd__decap_12
X_11002_ clknet_leaf_125_clk _01064_ VGND VGND VPWR VPWR cpuregs\[19\]\[2\] sky130_fd_sc_hd__dfxtp_1
XFILLER_131_281 VPWR VGND VPWR VGND sky130_ef_sc_hd__decap_12
XFILLER_78_869 VGND VGND VPWR VPWR sky130_fd_sc_hd__decap_3
XFILLER_93_839 VGND VGND VPWR VPWR sky130_fd_sc_hd__fill_1
XFILLER_93_817 VGND VGND VPWR VPWR sky130_fd_sc_hd__fill_1
XFILLER_65_519 VGND VGND VPWR VPWR sky130_fd_sc_hd__fill_2
XFILLER_19_903 VGND VGND VPWR VPWR sky130_fd_sc_hd__fill_1
XFILLER_92_349 VGND VGND VPWR VPWR sky130_fd_sc_hd__fill_1
XFILLER_58_593 VGND VGND VPWR VPWR sky130_fd_sc_hd__fill_1
XFILLER_46_733 VGND VGND VPWR VPWR sky130_fd_sc_hd__decap_3
XFILLER_93_87 VGND VGND VPWR VPWR sky130_fd_sc_hd__fill_2
Xclkbuf_leaf_25_clk clknet_4_4_0_clk VGND VGND VPWR VPWR clknet_leaf_25_clk sky130_fd_sc_hd__clkbuf_8
XFILLER_33_449 VGND VGND VPWR VPWR sky130_fd_sc_hd__decap_8
X_10717_ clknet_leaf_133_clk _00814_ VGND VGND VPWR VPWR net233 sky130_fd_sc_hd__dfxtp_2
XFILLER_9_111 VGND VGND VPWR VPWR sky130_fd_sc_hd__fill_1
XFILLER_146_318 VGND VGND VPWR VPWR sky130_fd_sc_hd__decap_6
Xrebuffer3 _03595_ VGND VGND VPWR VPWR net389 sky130_fd_sc_hd__dlygate4sd1_1
X_10648_ clknet_leaf_129_clk _04906_ VGND VGND VPWR VPWR reg_out\[6\] sky130_fd_sc_hd__dfxtp_1
XFILLER_9_177 VGND VGND VPWR VPWR sky130_fd_sc_hd__fill_1
XFILLER_42_91 VGND VGND VPWR VPWR sky130_fd_sc_hd__fill_1
XFILLER_142_502 VGND VGND VPWR VPWR sky130_fd_sc_hd__fill_1
X_10579_ clknet_leaf_110_clk _00709_ VGND VGND VPWR VPWR count_cycle\[2\] sky130_fd_sc_hd__dfxtp_2
XFILLER_142_524 VGND VGND VPWR VPWR sky130_fd_sc_hd__decap_8
XFILLER_115_727 VGND VGND VPWR VPWR sky130_fd_sc_hd__fill_1
XFILLER_114_226 VGND VGND VPWR VPWR sky130_fd_sc_hd__decap_4
XTAP_TAPCELL_ROW_58_1257 VGND VPWR sky130_fd_sc_hd__tapvpwrvgnd_1
XFILLER_5_361 VPWR VGND VPWR VGND sky130_ef_sc_hd__decap_12
XFILLER_123_782 VGND VGND VPWR VPWR sky130_fd_sc_hd__fill_2
XFILLER_69_814 VGND VGND VPWR VPWR sky130_fd_sc_hd__decap_4
XFILLER_68_313 VGND VGND VPWR VPWR sky130_fd_sc_hd__fill_1
XFILLER_110_421 VGND VGND VPWR VPWR sky130_fd_sc_hd__fill_2
XTAP_TAPCELL_ROW_71_1468 VGND VPWR sky130_fd_sc_hd__tapvpwrvgnd_1
X_06810_ _03221_ _03222_ _03226_ _03227_ _01579_ _01581_ VGND VGND VPWR VPWR _03230_
+ sky130_fd_sc_hd__mux4_1
XFILLER_96_699 VGND VGND VPWR VPWR sky130_fd_sc_hd__fill_1
X_07790_ _03664_ count_instr\[51\] _01549_ VGND VGND VPWR VPWR _03666_ sky130_fd_sc_hd__a21oi_1
XPHY_EDGE_ROW_147_Right_147 VGND VGND VPWR VPWR sky130_fd_sc_hd__decap_3
X_06741_ _03058_ _03084_ _03161_ VGND VGND VPWR VPWR _03163_ sky130_fd_sc_hd__nor3_1
XFILLER_49_582 VGND VGND VPWR VPWR sky130_fd_sc_hd__decap_8
XFILLER_92_850 VGND VGND VPWR VPWR sky130_fd_sc_hd__fill_2
X_09460_ _02712_ cpuregs\[19\]\[31\] _04863_ VGND VGND VPWR VPWR _01093_ sky130_fd_sc_hd__mux2_1
X_08411_ _04154_ count_cycle\[56\] _01549_ VGND VGND VPWR VPWR _04156_ sky130_fd_sc_hd__a21oi_1
X_06672_ cpuregs\[4\]\[13\] cpuregs\[5\]\[13\] cpuregs\[6\]\[13\] cpuregs\[7\]\[13\]
+ net263 net260 VGND VGND VPWR VPWR _03097_ sky130_fd_sc_hd__mux4_1
X_05623_ _02049_ _02051_ _02205_ VGND VGND VPWR VPWR _02206_ sky130_fd_sc_hd__o21ai_1
XFILLER_91_393 VPWR VGND VPWR VGND sky130_ef_sc_hd__decap_12
XFILLER_91_382 VGND VGND VPWR VPWR sky130_fd_sc_hd__decap_8
Xclkbuf_leaf_16_clk clknet_4_3_0_clk VGND VGND VPWR VPWR clknet_leaf_16_clk sky130_fd_sc_hd__clkbuf_8
XFILLER_51_246 VGND VGND VPWR VPWR sky130_fd_sc_hd__decap_6
X_09391_ decoded_imm\[2\] _04746_ _04858_ _04859_ VGND VGND VPWR VPWR _01028_ sky130_fd_sc_hd__o22a_1
X_08342_ count_cycle\[29\] count_cycle\[30\] _04109_ VGND VGND VPWR VPWR _04113_ sky130_fd_sc_hd__and3_1
X_05554_ _02134_ _02136_ VGND VGND VPWR VPWR _02137_ sky130_fd_sc_hd__nor2_1
XFILLER_51_268 VPWR VGND VPWR VGND sky130_ef_sc_hd__decap_12
X_05485_ net194 net226 VGND VGND VPWR VPWR _02068_ sky130_fd_sc_hd__and2_1
X_08273_ count_cycle\[4\] count_cycle\[5\] _04063_ count_cycle\[6\] VGND VGND VPWR
+ VPWR _04068_ sky130_fd_sc_hd__and4_1
XFILLER_149_167 VGND VGND VPWR VPWR sky130_fd_sc_hd__fill_1
X_07224_ cpuregs\[13\]\[8\] _02616_ net251 VGND VGND VPWR VPWR _00172_ sky130_fd_sc_hd__mux2_1
X_07155_ cpuregs\[12\]\[9\] _02621_ net253 VGND VGND VPWR VPWR _00109_ sky130_fd_sc_hd__mux2_1
X_07086_ _00014_ _03490_ _00016_ VGND VGND VPWR VPWR _03496_ sky130_fd_sc_hd__o21a_1
XFILLER_105_215 VGND VGND VPWR VPWR sky130_fd_sc_hd__decap_8
X_06106_ is_slli_srli_srai _02576_ VGND VGND VPWR VPWR _02577_ sky130_fd_sc_hd__or2_1
X_06037_ mem_rdata_q\[18\] net10 _01609_ VGND VGND VPWR VPWR _01112_ sky130_fd_sc_hd__mux2_1
XFILLER_113_281 VGND VGND VPWR VPWR sky130_fd_sc_hd__decap_6
XFILLER_101_421 VGND VGND VPWR VPWR sky130_fd_sc_hd__fill_1
XFILLER_86_121 VGND VGND VPWR VPWR sky130_fd_sc_hd__decap_4
XFILLER_59_324 VPWR VGND VPWR VGND sky130_ef_sc_hd__decap_12
X_07988_ _03808_ _03809_ VGND VGND VPWR VPWR _03811_ sky130_fd_sc_hd__or2_1
X_06939_ cpuregs\[20\]\[23\] cpuregs\[21\]\[23\] cpuregs\[22\]\[23\] cpuregs\[23\]\[23\]
+ net267 net260 VGND VGND VPWR VPWR _03354_ sky130_fd_sc_hd__mux4_1
XPHY_EDGE_ROW_114_Right_114 VGND VGND VPWR VPWR sky130_fd_sc_hd__decap_3
XFILLER_101_487 VGND VGND VPWR VPWR sky130_fd_sc_hd__fill_2
XFILLER_86_187 VGND VGND VPWR VPWR sky130_fd_sc_hd__decap_8
X_09727_ _02586_ cpuregs\[6\]\[0\] _04873_ VGND VGND VPWR VPWR _01382_ sky130_fd_sc_hd__mux2_1
XFILLER_103_31 VPWR VGND VPWR VGND sky130_ef_sc_hd__decap_12
XTAP_TAPCELL_ROW_2_364 VGND VPWR sky130_fd_sc_hd__tapvpwrvgnd_1
XFILLER_82_360 VGND VGND VPWR VPWR sky130_fd_sc_hd__decap_4
X_09658_ _02712_ cpuregs\[22\]\[31\] _04869_ VGND VGND VPWR VPWR _01317_ sky130_fd_sc_hd__mux2_1
X_09589_ cpuregs\[29\]\[28\] _02699_ _04867_ VGND VGND VPWR VPWR _01250_ sky130_fd_sc_hd__mux2_1
XFILLER_70_544 VGND VGND VPWR VPWR sky130_fd_sc_hd__decap_4
XFILLER_70_533 VGND VGND VPWR VPWR sky130_fd_sc_hd__decap_6
XFILLER_63_57 VGND VGND VPWR VPWR sky130_fd_sc_hd__decap_4
XFILLER_55_596 VGND VGND VPWR VPWR sky130_fd_sc_hd__decap_4
X_08609_ cpuregs\[4\]\[7\] cpuregs\[5\]\[7\] cpuregs\[6\]\[7\] cpuregs\[7\]\[7\] net279
+ _00008_ VGND VGND VPWR VPWR _04304_ sky130_fd_sc_hd__mux4_1
XFILLER_15_449 VGND VGND VPWR VPWR sky130_fd_sc_hd__decap_6
XFILLER_70_566 VPWR VGND VPWR VGND sky130_ef_sc_hd__decap_12
XFILLER_144_3 VPWR VGND VPWR VGND sky130_ef_sc_hd__decap_12
XTAP_TAPCELL_ROW_137_2520 VGND VPWR sky130_fd_sc_hd__tapvpwrvgnd_1
XTAP_TAPCELL_ROW_100_1929 VGND VPWR sky130_fd_sc_hd__tapvpwrvgnd_1
XFILLER_11_611 VGND VGND VPWR VPWR sky130_fd_sc_hd__decap_4
XTAP_TAPCELL_ROW_42_1003 VGND VPWR sky130_fd_sc_hd__tapvpwrvgnd_1
XTAP_TAPCELL_ROW_137_2531 VGND VPWR sky130_fd_sc_hd__tapvpwrvgnd_1
X_10502_ clknet_leaf_87_clk _00632_ VGND VGND VPWR VPWR count_instr\[51\] sky130_fd_sc_hd__dfxtp_1
XFILLER_10_121 VGND VGND VPWR VPWR sky130_fd_sc_hd__decap_3
XFILLER_137_841 VPWR VGND VPWR VGND sky130_ef_sc_hd__decap_12
X_11482_ clknet_leaf_21_clk _01526_ VGND VGND VPWR VPWR cpuregs\[10\]\[16\] sky130_fd_sc_hd__dfxtp_1
XFILLER_11_699 VGND VGND VPWR VPWR sky130_fd_sc_hd__decap_8
XTAP_TAPCELL_ROW_21_661 VGND VPWR sky130_fd_sc_hd__tapvpwrvgnd_1
XTAP_TAPCELL_ROW_21_672 VGND VPWR sky130_fd_sc_hd__tapvpwrvgnd_1
XTAP_TAPCELL_ROW_150_2731 VGND VPWR sky130_fd_sc_hd__tapvpwrvgnd_1
X_10433_ clknet_leaf_20_clk _00563_ VGND VGND VPWR VPWR cpuregs\[17\]\[15\] sky130_fd_sc_hd__dfxtp_1
XFILLER_152_811 VGND VGND VPWR VPWR sky130_fd_sc_hd__fill_1
X_10364_ clknet_leaf_15_clk _00494_ VGND VGND VPWR VPWR cpuregs\[25\]\[10\] sky130_fd_sc_hd__dfxtp_1
XFILLER_3_821 VPWR VGND VPWR VGND sky130_ef_sc_hd__decap_12
XFILLER_12_83 VGND VGND VPWR VPWR sky130_fd_sc_hd__fill_1
XFILLER_128_83 VGND VGND VPWR VPWR sky130_fd_sc_hd__fill_1
XFILLER_3_865 VPWR VGND VPWR VGND sky130_ef_sc_hd__decap_12
XFILLER_152_899 VGND VGND VPWR VPWR sky130_fd_sc_hd__fill_1
XFILLER_111_218 VGND VGND VPWR VPWR sky130_fd_sc_hd__decap_6
XFILLER_88_65 VPWR VGND VPWR VGND sky130_ef_sc_hd__decap_12
X_10295_ clknet_leaf_140_clk _00425_ VGND VGND VPWR VPWR cpuregs\[26\]\[5\] sky130_fd_sc_hd__dfxtp_1
XFILLER_105_793 VGND VGND VPWR VPWR sky130_fd_sc_hd__fill_1
XFILLER_78_622 VGND VGND VPWR VPWR sky130_fd_sc_hd__decap_4
XFILLER_93_614 VGND VGND VPWR VPWR sky130_fd_sc_hd__fill_2
XTAP_TAPCELL_ROW_53_1187 VGND VPWR sky130_fd_sc_hd__tapvpwrvgnd_1
XTAP_TAPCELL_ROW_53_1176 VGND VPWR sky130_fd_sc_hd__tapvpwrvgnd_1
XTAP_TAPCELL_ROW_148_2693 VGND VPWR sky130_fd_sc_hd__tapvpwrvgnd_1
XFILLER_120_785 VPWR VGND VPWR VGND sky130_ef_sc_hd__decap_12
XTAP_TAPCELL_ROW_29_794 VGND VPWR sky130_fd_sc_hd__tapvpwrvgnd_1
XFILLER_14_471 VGND VGND VPWR VPWR sky130_fd_sc_hd__decap_4
X_05270_ _01866_ _01867_ VGND VGND VPWR VPWR _01869_ sky130_fd_sc_hd__nor2_2
XTAP_TAPCELL_ROW_40_970 VGND VPWR sky130_fd_sc_hd__tapvpwrvgnd_1
Xpicorv32_302 VGND VGND VPWR VPWR picorv32_302/HI eoi[21] sky130_fd_sc_hd__conb_1
Xpicorv32_313 VGND VGND VPWR VPWR picorv32_313/HI mem_addr[0] sky130_fd_sc_hd__conb_1
XFILLER_143_822 VPWR VGND VPWR VGND sky130_ef_sc_hd__decap_12
Xpicorv32_324 VGND VGND VPWR VPWR picorv32_324/HI pcpi_insn[7] sky130_fd_sc_hd__conb_1
Xpicorv32_335 VGND VGND VPWR VPWR picorv32_335/HI pcpi_insn[18] sky130_fd_sc_hd__conb_1
Xpicorv32_346 VGND VGND VPWR VPWR picorv32_346/HI pcpi_insn[29] sky130_fd_sc_hd__conb_1
Xpicorv32_357 VGND VGND VPWR VPWR picorv32_357/HI trace_data[7] sky130_fd_sc_hd__conb_1
XFILLER_143_877 VPWR VGND VPWR VGND sky130_ef_sc_hd__decap_12
XFILLER_115_568 VPWR VGND VPWR VGND sky130_ef_sc_hd__decap_12
XFILLER_115_557 VGND VGND VPWR VPWR sky130_fd_sc_hd__decap_3
XFILLER_115_535 VGND VGND VPWR VPWR sky130_fd_sc_hd__fill_1
XFILLER_103_708 VPWR VGND VPWR VGND sky130_ef_sc_hd__decap_12
XFILLER_89_909 VGND VGND VPWR VPWR sky130_fd_sc_hd__decap_3
Xpicorv32_368 VGND VGND VPWR VPWR picorv32_368/HI trace_data[18] sky130_fd_sc_hd__conb_1
Xpicorv32_379 VGND VGND VPWR VPWR picorv32_379/HI trace_data[29] sky130_fd_sc_hd__conb_1
XFILLER_142_365 VGND VGND VPWR VPWR sky130_fd_sc_hd__decap_4
X_08960_ cpuregs\[12\]\[26\] cpuregs\[13\]\[26\] cpuregs\[14\]\[26\] cpuregs\[15\]\[26\]
+ net277 net272 VGND VGND VPWR VPWR _04636_ sky130_fd_sc_hd__mux4_1
XFILLER_102_218 VPWR VGND VPWR VGND sky130_ef_sc_hd__decap_12
Xclkbuf_leaf_5_clk clknet_4_1_0_clk VGND VGND VPWR VPWR clknet_leaf_5_clk sky130_fd_sc_hd__clkbuf_8
X_08891_ _04562_ _04563_ _01558_ VGND VGND VPWR VPWR _04571_ sky130_fd_sc_hd__mux2_1
XFILLER_111_741 VPWR VGND VPWR VGND sky130_ef_sc_hd__decap_12
XFILLER_96_430 VGND VGND VPWR VPWR sky130_fd_sc_hd__fill_2
X_07911_ _01629_ _03724_ _03690_ VGND VGND VPWR VPWR _03741_ sky130_fd_sc_hd__o21a_1
XFILLER_110_251 VGND VGND VPWR VPWR sky130_fd_sc_hd__fill_1
X_07842_ reg_pc\[9\] _01624_ _01628_ _03696_ VGND VGND VPWR VPWR _00653_ sky130_fd_sc_hd__a22o_1
XFILLER_111_785 VGND VGND VPWR VPWR sky130_fd_sc_hd__fill_1
XFILLER_68_176 VPWR VGND VPWR VGND sky130_ef_sc_hd__decap_12
X_09512_ cpuregs\[31\]\[17\] _02654_ net240 VGND VGND VPWR VPWR _01175_ sky130_fd_sc_hd__mux2_1
XTAP_TAPCELL_ROW_88_1740 VGND VPWR sky130_fd_sc_hd__tapvpwrvgnd_1
X_07773_ _03654_ _03655_ VGND VGND VPWR VPWR _00625_ sky130_fd_sc_hd__nor2_1
X_04985_ _01549_ _01612_ VGND VGND VPWR VPWR _01613_ sky130_fd_sc_hd__or2_4
XPHY_EDGE_ROW_3_Left_157 VGND VGND VPWR VPWR sky130_fd_sc_hd__decap_3
XFILLER_37_552 VGND VGND VPWR VPWR sky130_fd_sc_hd__decap_8
XFILLER_140_29 VPWR VGND VPWR VGND sky130_ef_sc_hd__decap_12
X_06724_ cpuregs\[12\]\[15\] cpuregs\[13\]\[15\] cpuregs\[14\]\[15\] cpuregs\[15\]\[15\]
+ net263 net259 VGND VGND VPWR VPWR _03147_ sky130_fd_sc_hd__mux4_1
XFILLER_17_39 VPWR VGND VPWR VGND sky130_ef_sc_hd__decap_12
XFILLER_25_725 VGND VGND VPWR VPWR sky130_fd_sc_hd__decap_3
XFILLER_37_574 VGND VGND VPWR VPWR sky130_fd_sc_hd__decap_4
X_09443_ _02641_ cpuregs\[19\]\[14\] _04863_ VGND VGND VPWR VPWR _01076_ sky130_fd_sc_hd__mux2_1
X_06655_ _02714_ _03062_ _03064_ _03065_ _03080_ VGND VGND VPWR VPWR _03081_ sky130_fd_sc_hd__o41a_1
XFILLER_52_533 VGND VGND VPWR VPWR sky130_fd_sc_hd__decap_6
XFILLER_13_909 VGND VGND VPWR VPWR sky130_fd_sc_hd__decap_3
X_09374_ decoded_imm\[9\] _04746_ _04849_ VGND VGND VPWR VPWR _01021_ sky130_fd_sc_hd__o21a_1
X_05606_ _02164_ _02188_ _02177_ VGND VGND VPWR VPWR _02189_ sky130_fd_sc_hd__a21o_1
XFILLER_40_706 VGND VGND VPWR VPWR sky130_fd_sc_hd__decap_8
X_08325_ count_cycle\[23\] count_cycle\[24\] _04098_ VGND VGND VPWR VPWR _04102_ sky130_fd_sc_hd__and3_1
X_06586_ _01641_ _03012_ _02714_ VGND VGND VPWR VPWR _03014_ sky130_fd_sc_hd__a21o_1
XFILLER_33_27 VPWR VGND VPWR VGND sky130_ef_sc_hd__decap_12
XFILLER_40_739 VPWR VGND VPWR VGND sky130_ef_sc_hd__decap_12
XFILLER_149_27 VPWR VGND VPWR VGND sky130_ef_sc_hd__decap_12
X_05537_ _02116_ _02118_ VGND VGND VPWR VPWR _02120_ sky130_fd_sc_hd__nand2_1
XFILLER_119_841 VPWR VGND VPWR VGND sky130_ef_sc_hd__decap_12
X_05468_ net188 net220 VGND VGND VPWR VPWR _02051_ sky130_fd_sc_hd__and2_1
X_08256_ reg_next_pc\[31\] _01547_ _01645_ _03720_ VGND VGND VPWR VPWR _04058_ sky130_fd_sc_hd__a22o_1
XFILLER_20_474 VGND VGND VPWR VPWR sky130_fd_sc_hd__fill_2
X_07207_ cpuregs\[30\]\[25\] _02688_ _03556_ VGND VGND VPWR VPWR _00157_ sky130_fd_sc_hd__mux2_1
X_08187_ _01547_ reg_next_pc\[25\] _01645_ _03712_ VGND VGND VPWR VPWR _03995_ sky130_fd_sc_hd__a22o_1
XFILLER_134_811 VGND VGND VPWR VPWR sky130_fd_sc_hd__fill_1
XTAP_TAPCELL_ROW_132_2450 VGND VPWR sky130_fd_sc_hd__tapvpwrvgnd_1
XTAP_TAPCELL_ROW_115_2169 VGND VPWR sky130_fd_sc_hd__tapvpwrvgnd_1
X_05399_ count_cycle\[26\] _01588_ VGND VGND VPWR VPWR _01988_ sky130_fd_sc_hd__or2_1
X_07138_ _00015_ _03542_ _03545_ _02735_ VGND VGND VPWR VPWR _03546_ sky130_fd_sc_hd__o211a_1
XFILLER_145_181 VPWR VGND VPWR VGND sky130_ef_sc_hd__decap_12
XFILLER_121_505 VGND VGND VPWR VPWR sky130_fd_sc_hd__decap_6
X_07069_ _03477_ _03478_ VGND VGND VPWR VPWR _03479_ sky130_fd_sc_hd__nand2_1
XFILLER_0_813 VGND VGND VPWR VPWR sky130_fd_sc_hd__fill_2
X_10080_ clknet_leaf_27_clk _00210_ VGND VGND VPWR VPWR cpuregs\[2\]\[14\] sky130_fd_sc_hd__dfxtp_1
XTAP_TAPCELL_ROW_7_445 VGND VPWR sky130_fd_sc_hd__tapvpwrvgnd_1
XFILLER_0_846 VGND VGND VPWR VPWR sky130_fd_sc_hd__decap_4
XFILLER_114_41 VGND VGND VPWR VPWR sky130_fd_sc_hd__decap_6
XFILLER_87_485 VGND VGND VPWR VPWR sky130_fd_sc_hd__decap_4
XFILLER_75_647 VGND VGND VPWR VPWR sky130_fd_sc_hd__decap_3
XFILLER_75_614 VGND VGND VPWR VPWR sky130_fd_sc_hd__fill_2
XFILLER_114_85 VGND VGND VPWR VPWR sky130_fd_sc_hd__decap_8
X_10982_ clknet_leaf_28_clk _01044_ VGND VGND VPWR VPWR cpuregs\[18\]\[14\] sky130_fd_sc_hd__dfxtp_1
XFILLER_74_179 VPWR VGND VPWR VGND sky130_ef_sc_hd__decap_12
XFILLER_90_11 VGND VGND VPWR VPWR sky130_fd_sc_hd__fill_1
XTAP_TAPCELL_ROW_26_742 VGND VPWR sky130_fd_sc_hd__tapvpwrvgnd_1
XTAP_TAPCELL_ROW_26_753 VGND VPWR sky130_fd_sc_hd__tapvpwrvgnd_1
XFILLER_130_73 VGND VGND VPWR VPWR sky130_fd_sc_hd__fill_2
XFILLER_90_55 VGND VGND VPWR VPWR sky130_fd_sc_hd__decap_4
XFILLER_71_897 VGND VGND VPWR VPWR sky130_fd_sc_hd__fill_1
XFILLER_43_599 VPWR VGND VPWR VGND sky130_ef_sc_hd__decap_12
XFILLER_129_638 VGND VGND VPWR VPWR sky130_fd_sc_hd__decap_6
X_11465_ clknet_leaf_135_clk _01509_ VGND VGND VPWR VPWR cpuregs\[0\]\[31\] sky130_fd_sc_hd__dfxtp_1
XFILLER_137_682 VPWR VGND VPWR VGND sky130_ef_sc_hd__decap_12
X_10416_ clknet_leaf_33_clk _00546_ VGND VGND VPWR VPWR cpuregs\[20\]\[30\] sky130_fd_sc_hd__dfxtp_1
XFILLER_99_53 VGND VGND VPWR VPWR sky130_fd_sc_hd__decap_3
X_11396_ clknet_leaf_40_clk _01440_ VGND VGND VPWR VPWR cpuregs\[7\]\[26\] sky130_fd_sc_hd__dfxtp_1
XTAP_TAPCELL_ROW_55_1216 VGND VPWR sky130_fd_sc_hd__tapvpwrvgnd_1
XTAP_TAPCELL_ROW_55_1205 VGND VPWR sky130_fd_sc_hd__tapvpwrvgnd_1
X_10347_ clknet_leaf_68_clk _00477_ VGND VGND VPWR VPWR cpuregs\[16\]\[25\] sky130_fd_sc_hd__dfxtp_1
XFILLER_140_825 VPWR VGND VPWR VGND sky130_ef_sc_hd__decap_12
XFILLER_140_803 VGND VGND VPWR VPWR sky130_fd_sc_hd__decap_8
XFILLER_125_877 VPWR VGND VPWR VGND sky130_ef_sc_hd__decap_12
XFILLER_98_728 VGND VGND VPWR VPWR sky130_fd_sc_hd__fill_2
XFILLER_3_673 VPWR VGND VPWR VGND sky130_ef_sc_hd__decap_12
XFILLER_140_869 VPWR VGND VPWR VGND sky130_ef_sc_hd__decap_12
X_10278_ clknet_leaf_72_clk _00408_ VGND VGND VPWR VPWR cpuregs\[15\]\[20\] sky130_fd_sc_hd__dfxtp_1
Xclone211 net598 net602 VGND VGND VPWR VPWR net597 sky130_fd_sc_hd__nand2_4
XFILLER_65_113 VGND VGND VPWR VPWR sky130_fd_sc_hd__decap_4
XFILLER_39_839 VGND VGND VPWR VPWR sky130_fd_sc_hd__fill_1
XFILLER_66_669 VPWR VGND VPWR VGND sky130_ef_sc_hd__decap_12
XFILLER_0_53 VGND VGND VPWR VPWR sky130_fd_sc_hd__decap_3
XFILLER_34_533 VGND VGND VPWR VPWR sky130_fd_sc_hd__decap_6
XFILLER_46_371 VPWR VGND VPWR VGND sky130_ef_sc_hd__decap_12
XFILLER_0_97 VPWR VGND VPWR VGND sky130_ef_sc_hd__decap_12
X_06440_ decoded_imm\[5\] net198 VGND VGND VPWR VPWR _02873_ sky130_fd_sc_hd__or2_1
XTAP_TAPCELL_ROW_66_1389 VGND VPWR sky130_fd_sc_hd__tapvpwrvgnd_1
XFILLER_15_780 VGND VGND VPWR VPWR sky130_fd_sc_hd__decap_4
XFILLER_147_402 VGND VGND VPWR VPWR sky130_fd_sc_hd__decap_4
XFILLER_9_51 VGND VGND VPWR VPWR sky130_fd_sc_hd__decap_4
X_06371_ decoded_imm\[3\] net196 VGND VGND VPWR VPWR _02806_ sky130_fd_sc_hd__and2_2
X_08110_ _01551_ _03923_ VGND VGND VPWR VPWR _03924_ sky130_fd_sc_hd__nand2_1
X_05322_ instr_rdcycleh count_cycle\[52\] _01587_ _01916_ VGND VGND VPWR VPWR _01917_
+ sky130_fd_sc_hd__a211o_1
X_09090_ instr_jal _02514_ _04744_ _04745_ VGND VGND VPWR VPWR _00846_ sky130_fd_sc_hd__a22o_1
XFILLER_119_19 VPWR VGND VPWR VGND sky130_ef_sc_hd__decap_12
X_08041_ _03843_ _03850_ _03858_ _01551_ VGND VGND VPWR VPWR _03860_ sky130_fd_sc_hd__a31o_1
X_05253_ _01840_ _01842_ _01841_ VGND VGND VPWR VPWR _01853_ sky130_fd_sc_hd__a21bo_1
X_05184_ cpu_state\[3\] _01782_ _01783_ _01789_ VGND VGND VPWR VPWR _04909_ sky130_fd_sc_hd__a31o_1
X_09992_ clknet_leaf_48_clk _00122_ VGND VGND VPWR VPWR cpuregs\[12\]\[22\] sky130_fd_sc_hd__dfxtp_1
XFILLER_0_109 VGND VGND VPWR VPWR sky130_fd_sc_hd__decap_3
X_08943_ cpuregs\[8\]\[25\] cpuregs\[9\]\[25\] cpuregs\[10\]\[25\] cpuregs\[11\]\[25\]
+ net280 net274 VGND VGND VPWR VPWR _04620_ sky130_fd_sc_hd__mux4_1
XFILLER_115_398 VGND VGND VPWR VPWR sky130_fd_sc_hd__decap_3
Xclkbuf_4_15_0_clk clknet_0_clk VGND VGND VPWR VPWR clknet_4_15_0_clk sky130_fd_sc_hd__clkbuf_8
XTAP_TAPCELL_ROW_110_2099 VGND VPWR sky130_fd_sc_hd__tapvpwrvgnd_1
XTAP_TAPCELL_ROW_110_2088 VGND VPWR sky130_fd_sc_hd__tapvpwrvgnd_1
XFILLER_97_761 VGND VGND VPWR VPWR sky130_fd_sc_hd__fill_1
X_08874_ _04545_ _04546_ _01558_ VGND VGND VPWR VPWR _04555_ sky130_fd_sc_hd__mux2_1
XFILLER_28_27 VGND VGND VPWR VPWR sky130_fd_sc_hd__fill_1
XFILLER_151_39 VPWR VGND VPWR VGND sky130_ef_sc_hd__decap_12
XFILLER_57_658 VPWR VGND VPWR VGND sky130_ef_sc_hd__decap_12
XFILLER_29_349 VGND VGND VPWR VPWR sky130_fd_sc_hd__decap_3
X_07825_ reg_pc\[1\] _01624_ _01628_ _03687_ VGND VGND VPWR VPWR _00645_ sky130_fd_sc_hd__a22o_1
XFILLER_84_477 VGND VGND VPWR VPWR sky130_fd_sc_hd__decap_4
XFILLER_71_105 VGND VGND VPWR VPWR sky130_fd_sc_hd__decap_6
X_04968_ instr_beq instr_rdcycle instr_srai instr_slli VGND VGND VPWR VPWR _01598_
+ sky130_fd_sc_hd__or4_1
X_07756_ count_instr\[38\] _03643_ net34 VGND VGND VPWR VPWR _03645_ sky130_fd_sc_hd__o21ai_1
X_06707_ _03114_ _03130_ net176 _02725_ VGND VGND VPWR VPWR _00083_ sky130_fd_sc_hd__a2bb2o_1
XFILLER_25_533 VGND VGND VPWR VPWR sky130_fd_sc_hd__fill_2
X_09426_ _02709_ cpuregs\[18\]\[30\] _04862_ VGND VGND VPWR VPWR _01060_ sky130_fd_sc_hd__mux2_1
X_07687_ count_instr\[13\] _03599_ net34 VGND VGND VPWR VPWR _03601_ sky130_fd_sc_hd__o21ai_1
XFILLER_25_577 VPWR VGND VPWR VGND sky130_ef_sc_hd__decap_12
X_06638_ _02744_ _02983_ _03063_ VGND VGND VPWR VPWR _03064_ sky130_fd_sc_hd__and3_1
XTAP_TAPCELL_ROW_23_701 VGND VPWR sky130_fd_sc_hd__tapvpwrvgnd_1
X_09357_ decoded_imm\[17\] _04746_ _04824_ _04840_ VGND VGND VPWR VPWR _01013_ sky130_fd_sc_hd__o22a_1
XFILLER_21_750 VGND VGND VPWR VPWR sky130_fd_sc_hd__decap_8
X_06569_ net258 _02988_ _00016_ VGND VGND VPWR VPWR _02998_ sky130_fd_sc_hd__o21a_1
XTAP_TAPCELL_ROW_117_2209 VGND VPWR sky130_fd_sc_hd__tapvpwrvgnd_1
X_09288_ net144 net106 _04206_ VGND VGND VPWR VPWR _00974_ sky130_fd_sc_hd__mux2_1
X_08308_ count_cycle\[18\] _04088_ net34 VGND VGND VPWR VPWR _04091_ sky130_fd_sc_hd__o21ai_1
X_08239_ _03719_ _04029_ instr_jal VGND VGND VPWR VPWR _04042_ sky130_fd_sc_hd__a21o_1
XFILLER_153_427 VGND VGND VPWR VPWR sky130_fd_sc_hd__decap_3
XTAP_TAPCELL_ROW_130_2409 VGND VPWR sky130_fd_sc_hd__tapvpwrvgnd_1
XFILLER_119_682 VGND VGND VPWR VPWR sky130_fd_sc_hd__decap_3
XFILLER_153_449 VGND VGND VPWR VPWR sky130_fd_sc_hd__fill_2
XFILLER_146_490 VPWR VGND VPWR VGND sky130_ef_sc_hd__decap_12
XFILLER_107_3 VGND VGND VPWR VPWR sky130_fd_sc_hd__decap_3
XFILLER_69_23 VPWR VGND VPWR VGND sky130_ef_sc_hd__decap_12
X_11250_ clknet_leaf_149_clk _01297_ VGND VGND VPWR VPWR cpuregs\[22\]\[11\] sky130_fd_sc_hd__dfxtp_1
XFILLER_122_825 VPWR VGND VPWR VGND sky130_ef_sc_hd__decap_12
X_10201_ clknet_leaf_146_clk _00331_ VGND VGND VPWR VPWR cpuregs\[14\]\[7\] sky130_fd_sc_hd__dfxtp_1
X_11181_ clknet_leaf_1_clk _01228_ VGND VGND VPWR VPWR cpuregs\[29\]\[6\] sky130_fd_sc_hd__dfxtp_1
XFILLER_134_696 VGND VGND VPWR VPWR sky130_fd_sc_hd__decap_4
X_10132_ clknet_leaf_122_clk _00262_ VGND VGND VPWR VPWR cpuregs\[21\]\[2\] sky130_fd_sc_hd__dfxtp_1
XFILLER_125_51 VGND VGND VPWR VPWR sky130_fd_sc_hd__decap_4
XFILLER_122_869 VPWR VGND VPWR VGND sky130_ef_sc_hd__decap_12
XFILLER_0_643 VGND VGND VPWR VPWR sky130_fd_sc_hd__fill_1
X_10063_ clknet_leaf_34_clk _00193_ VGND VGND VPWR VPWR cpuregs\[13\]\[29\] sky130_fd_sc_hd__dfxtp_1
XFILLER_102_571 VGND VGND VPWR VPWR sky130_fd_sc_hd__fill_1
XTAP_TAPCELL_ROW_50_1135 VGND VPWR sky130_fd_sc_hd__tapvpwrvgnd_1
XTAP_TAPCELL_ROW_50_1124 VGND VPWR sky130_fd_sc_hd__tapvpwrvgnd_1
XFILLER_48_636 VGND VGND VPWR VPWR sky130_fd_sc_hd__decap_8
XTAP_TAPCELL_ROW_145_2652 VGND VPWR sky130_fd_sc_hd__tapvpwrvgnd_1
XFILLER_85_55 VGND VGND VPWR VPWR sky130_fd_sc_hd__fill_1
XFILLER_48_669 VGND VGND VPWR VPWR sky130_fd_sc_hd__decap_3
XFILLER_35_308 VGND VGND VPWR VPWR sky130_fd_sc_hd__fill_2
XFILLER_35_319 VPWR VGND VPWR VGND sky130_ef_sc_hd__decap_12
XFILLER_16_533 VGND VGND VPWR VPWR sky130_fd_sc_hd__decap_4
X_10965_ clknet_leaf_111_clk _01027_ VGND VGND VPWR VPWR decoded_imm\[3\] sky130_fd_sc_hd__dfxtp_1
XFILLER_44_853 VPWR VGND VPWR VGND sky130_ef_sc_hd__decap_12
XTAP_TAPCELL_ROW_48_1097 VGND VPWR sky130_fd_sc_hd__tapvpwrvgnd_1
X_10896_ clknet_leaf_5_clk _00958_ VGND VGND VPWR VPWR net157 sky130_fd_sc_hd__dfxtp_1
XFILLER_43_363 VGND VGND VPWR VPWR sky130_fd_sc_hd__decap_4
XPHY_EDGE_ROW_75_Left_229 VGND VGND VPWR VPWR sky130_fd_sc_hd__decap_3
XFILLER_70_182 VGND VGND VPWR VPWR sky130_fd_sc_hd__fill_1
XFILLER_31_569 VGND VGND VPWR VPWR sky130_fd_sc_hd__decap_4
XFILLER_34_81 VGND VGND VPWR VPWR sky130_fd_sc_hd__decap_3
XFILLER_7_275 VGND VGND VPWR VPWR sky130_fd_sc_hd__decap_4
X_11448_ clknet_leaf_27_clk _01492_ VGND VGND VPWR VPWR cpuregs\[0\]\[14\] sky130_fd_sc_hd__dfxtp_1
XFILLER_7_297 VGND VGND VPWR VPWR sky130_fd_sc_hd__decap_3
X_11379_ clknet_leaf_150_clk _01423_ VGND VGND VPWR VPWR cpuregs\[7\]\[9\] sky130_fd_sc_hd__dfxtp_1
XPHY_EDGE_ROW_84_Left_238 VGND VGND VPWR VPWR sky130_fd_sc_hd__decap_3
XFILLER_86_709 VGND VGND VPWR VPWR sky130_fd_sc_hd__decap_4
X_05940_ mem_wordsize\[1\] net126 net209 mem_wordsize\[2\] VGND VGND VPWR VPWR _02481_
+ sky130_fd_sc_hd__a22o_1
XFILLER_22_3 VPWR VGND VPWR VGND sky130_ef_sc_hd__decap_12
X_05871_ _02050_ _02237_ _02238_ _02051_ VGND VGND VPWR VPWR _02429_ sky130_fd_sc_hd__a22o_1
XFILLER_66_455 VGND VGND VPWR VPWR sky130_fd_sc_hd__fill_2
XFILLER_27_809 VPWR VGND VPWR VGND sky130_ef_sc_hd__decap_12
X_07610_ cpuregs\[20\]\[27\] _02696_ net245 VGND VGND VPWR VPWR _00543_ sky130_fd_sc_hd__mux2_1
XFILLER_93_263 VPWR VGND VPWR VGND sky130_ef_sc_hd__decap_12
XTAP_TAPCELL_ROW_68_1418 VGND VPWR sky130_fd_sc_hd__tapvpwrvgnd_1
XFILLER_66_477 VGND VGND VPWR VPWR sky130_fd_sc_hd__fill_2
XFILLER_54_606 VGND VGND VPWR VPWR sky130_fd_sc_hd__fill_1
X_08590_ cpuregs\[4\]\[6\] cpuregs\[5\]\[6\] cpuregs\[6\]\[6\] cpuregs\[7\]\[6\] net278
+ net273 VGND VGND VPWR VPWR _04286_ sky130_fd_sc_hd__mux4_1
X_07541_ _02688_ cpuregs\[16\]\[25\] _03570_ VGND VGND VPWR VPWR _00477_ sky130_fd_sc_hd__mux2_1
XFILLER_81_447 VGND VGND VPWR VPWR sky130_fd_sc_hd__fill_1
XFILLER_19_393 VPWR VGND VPWR VGND sky130_ef_sc_hd__decap_12
XFILLER_47_680 VGND VGND VPWR VPWR sky130_fd_sc_hd__fill_1
XPHY_EDGE_ROW_93_Left_247 VGND VGND VPWR VPWR sky130_fd_sc_hd__decap_3
XFILLER_34_341 VGND VGND VPWR VPWR sky130_fd_sc_hd__decap_3
XFILLER_35_853 VGND VGND VPWR VPWR sky130_fd_sc_hd__decap_8
X_07472_ cpuregs\[15\]\[23\] _02678_ net246 VGND VGND VPWR VPWR _00411_ sky130_fd_sc_hd__mux2_1
XTAP_TAPCELL_ROW_81_1629 VGND VPWR sky130_fd_sc_hd__tapvpwrvgnd_1
XFILLER_34_363 VGND VGND VPWR VPWR sky130_fd_sc_hd__fill_1
XFILLER_61_193 VGND VGND VPWR VPWR sky130_fd_sc_hd__fill_2
X_09211_ is_lb_lh_lw_lbu_lhu _02514_ _04793_ _04795_ VGND VGND VPWR VPWR _00912_ sky130_fd_sc_hd__a22o_1
XFILLER_14_29 VPWR VGND VPWR VGND sky130_ef_sc_hd__decap_12
X_06423_ net259 _02856_ _02855_ net258 VGND VGND VPWR VPWR _02857_ sky130_fd_sc_hd__o211a_1
XFILLER_148_733 VGND VGND VPWR VPWR sky130_fd_sc_hd__decap_3
X_09142_ instr_srli _04747_ _04771_ VGND VGND VPWR VPWR _00869_ sky130_fd_sc_hd__a21o_1
X_06354_ _00016_ _02789_ _01580_ VGND VGND VPWR VPWR _02790_ sky130_fd_sc_hd__o21ai_1
X_05305_ _01899_ _01900_ VGND VGND VPWR VPWR _01901_ sky130_fd_sc_hd__xnor2_1
X_09073_ mem_rdata_q\[0\] net1 _01609_ VGND VGND VPWR VPWR _01094_ sky130_fd_sc_hd__mux2_1
X_06285_ _01643_ _02717_ _02722_ VGND VGND VPWR VPWR _02723_ sky130_fd_sc_hd__or3b_2
XFILLER_135_449 VGND VGND VPWR VPWR sky130_fd_sc_hd__decap_3
XTAP_TAPCELL_ROW_112_2117 VGND VPWR sky130_fd_sc_hd__tapvpwrvgnd_1
XTAP_TAPCELL_ROW_96_1872 VGND VPWR sky130_fd_sc_hd__tapvpwrvgnd_1
XTAP_TAPCELL_ROW_96_1861 VGND VPWR sky130_fd_sc_hd__tapvpwrvgnd_1
X_08024_ _03842_ _03843_ VGND VGND VPWR VPWR _03844_ sky130_fd_sc_hd__nand2_1
X_05236_ count_instr\[45\] instr_rdinstrh net257 _01837_ VGND VGND VPWR VPWR _01838_
+ sky130_fd_sc_hd__a211o_1
XFILLER_116_674 VPWR VGND VPWR VGND sky130_ef_sc_hd__decap_12
XFILLER_116_652 VPWR VGND VPWR VGND sky130_ef_sc_hd__decap_12
XTAP_TAPCELL_ROW_112_2128 VGND VPWR sky130_fd_sc_hd__tapvpwrvgnd_1
X_05167_ _01771_ _01773_ VGND VGND VPWR VPWR _01774_ sky130_fd_sc_hd__or2_1
XFILLER_104_858 VGND VGND VPWR VPWR sky130_fd_sc_hd__decap_8
XFILLER_1_429 VGND VGND VPWR VPWR sky130_fd_sc_hd__decap_8
XFILLER_39_15 VPWR VGND VPWR VGND sky130_ef_sc_hd__decap_12
XFILLER_104_869 VGND VGND VPWR VPWR sky130_fd_sc_hd__decap_3
X_05098_ net11 _01669_ net130 net26 _01709_ VGND VGND VPWR VPWR _01710_ sky130_fd_sc_hd__a221o_1
X_09975_ clknet_leaf_139_clk _00105_ VGND VGND VPWR VPWR cpuregs\[12\]\[5\] sky130_fd_sc_hd__dfxtp_1
X_08926_ _04593_ _04594_ _01558_ VGND VGND VPWR VPWR _04604_ sky130_fd_sc_hd__mux2_1
X_08857_ net269 _04537_ _01559_ VGND VGND VPWR VPWR _04539_ sky130_fd_sc_hd__a21o_1
XFILLER_29_113 VGND VGND VPWR VPWR sky130_fd_sc_hd__decap_3
XTAP_TAPCELL_ROW_127_2371 VGND VPWR sky130_fd_sc_hd__tapvpwrvgnd_1
XTAP_TAPCELL_ROW_127_2360 VGND VPWR sky130_fd_sc_hd__tapvpwrvgnd_1
X_07808_ count_instr\[57\] _03674_ count_instr\[58\] VGND VGND VPWR VPWR _03677_ sky130_fd_sc_hd__a21o_1
XFILLER_84_263 VPWR VGND VPWR VGND sky130_ef_sc_hd__decap_12
XFILLER_57_477 VPWR VGND VPWR VGND sky130_ef_sc_hd__decap_12
X_08788_ _04472_ _04473_ _04266_ _04470_ VGND VGND VPWR VPWR _04474_ sky130_fd_sc_hd__o211a_1
XFILLER_55_47 VGND VGND VPWR VPWR sky130_fd_sc_hd__decap_8
XFILLER_44_138 VGND VGND VPWR VPWR sky130_fd_sc_hd__fill_2
X_07739_ count_instr\[32\] _03629_ count_instr\[30\] count_instr\[31\] VGND VGND VPWR
+ VPWR _03634_ sky130_fd_sc_hd__and4_4
XTAP_TAPCELL_ROW_140_2571 VGND VPWR sky130_fd_sc_hd__tapvpwrvgnd_1
X_10750_ clknet_leaf_134_clk alu_out\[3\] VGND VGND VPWR VPWR alu_out_q\[3\] sky130_fd_sc_hd__dfxtp_1
X_09409_ _02638_ cpuregs\[18\]\[13\] _04862_ VGND VGND VPWR VPWR _01043_ sky130_fd_sc_hd__mux2_1
XFILLER_71_35 VPWR VGND VPWR VGND sky130_ef_sc_hd__decap_12
X_10681_ clknet_leaf_141_clk _00779_ VGND VGND VPWR VPWR net64 sky130_fd_sc_hd__dfxtp_1
XFILLER_13_558 VGND VGND VPWR VPWR sky130_fd_sc_hd__fill_2
XFILLER_40_399 VPWR VGND VPWR VGND sky130_ef_sc_hd__decap_12
XFILLER_126_449 VGND VGND VPWR VPWR sky130_fd_sc_hd__decap_8
X_11302_ clknet_leaf_135_clk _01349_ VGND VGND VPWR VPWR cpuregs\[4\]\[31\] sky130_fd_sc_hd__dfxtp_1
X_11233_ clknet_leaf_40_clk _01280_ VGND VGND VPWR VPWR cpuregs\[3\]\[26\] sky130_fd_sc_hd__dfxtp_1
XFILLER_134_460 VPWR VGND VPWR VGND sky130_ef_sc_hd__decap_12
XFILLER_4_245 VGND VGND VPWR VPWR sky130_fd_sc_hd__decap_6
XFILLER_20_83 VGND VGND VPWR VPWR sky130_fd_sc_hd__fill_1
XFILLER_136_83 VGND VGND VPWR VPWR sky130_fd_sc_hd__fill_1
X_11164_ clknet_leaf_75_clk _01211_ VGND VGND VPWR VPWR cpuregs\[23\]\[21\] sky130_fd_sc_hd__dfxtp_1
XFILLER_110_806 VGND VGND VPWR VPWR sky130_fd_sc_hd__decap_6
XFILLER_49_901 VGND VGND VPWR VPWR sky130_fd_sc_hd__fill_1
X_11095_ clknet_leaf_43_clk _01152_ VGND VGND VPWR VPWR cpuregs\[24\]\[26\] sky130_fd_sc_hd__dfxtp_1
XFILLER_95_517 VGND VGND VPWR VPWR sky130_fd_sc_hd__decap_4
X_10115_ clknet_leaf_22_clk _00245_ VGND VGND VPWR VPWR cpuregs\[28\]\[17\] sky130_fd_sc_hd__dfxtp_1
XFILLER_48_400 VGND VGND VPWR VPWR sky130_fd_sc_hd__fill_1
XFILLER_121_187 VGND VGND VPWR VPWR sky130_fd_sc_hd__decap_6
XFILLER_76_742 VGND VGND VPWR VPWR sky130_fd_sc_hd__fill_1
X_10046_ clknet_leaf_10_clk _00176_ VGND VGND VPWR VPWR cpuregs\[13\]\[12\] sky130_fd_sc_hd__dfxtp_1
XFILLER_75_263 VGND VGND VPWR VPWR sky130_fd_sc_hd__fill_1
XFILLER_91_767 VGND VGND VPWR VPWR sky130_fd_sc_hd__decap_3
XFILLER_17_853 VPWR VGND VPWR VGND sky130_ef_sc_hd__decap_12
X_10948_ clknet_leaf_93_clk _01010_ VGND VGND VPWR VPWR decoded_imm\[20\] sky130_fd_sc_hd__dfxtp_1
XFILLER_16_363 VGND VGND VPWR VPWR sky130_fd_sc_hd__fill_1
XFILLER_17_897 VPWR VGND VPWR VGND sky130_ef_sc_hd__decap_12
XFILLER_45_91 VGND VGND VPWR VPWR sky130_fd_sc_hd__decap_3
XTAP_TAPCELL_ROW_63_1337 VGND VPWR sky130_fd_sc_hd__tapvpwrvgnd_1
XFILLER_32_867 VGND VGND VPWR VPWR sky130_fd_sc_hd__fill_1
X_10879_ clknet_leaf_43_clk _00941_ VGND VGND VPWR VPWR cpuregs\[1\]\[23\] sky130_fd_sc_hd__dfxtp_1
XTAP_TAPCELL_ROW_14_553 VGND VPWR sky130_fd_sc_hd__tapvpwrvgnd_1
XFILLER_129_243 VPWR VGND VPWR VGND sky130_ef_sc_hd__decap_12
XFILLER_145_725 VGND VGND VPWR VPWR sky130_fd_sc_hd__decap_3
XFILLER_117_405 VGND VGND VPWR VPWR sky130_fd_sc_hd__decap_4
XFILLER_133_909 VGND VGND VPWR VPWR sky130_fd_sc_hd__decap_3
XFILLER_117_449 VPWR VGND VPWR VGND sky130_ef_sc_hd__decap_12
XANTENNA_1 _01553_ VGND VGND VPWR VPWR sky130_fd_sc_hd__diode_2
XFILLER_6_41 VPWR VGND VPWR VGND sky130_ef_sc_hd__decap_12
X_06070_ _02540_ _02541_ _01558_ VGND VGND VPWR VPWR _02542_ sky130_fd_sc_hd__mux2_1
XFILLER_99_812 VPWR VGND VPWR VGND sky130_ef_sc_hd__decap_12
XTAP_TAPCELL_ROW_78_1580 VGND VPWR sky130_fd_sc_hd__tapvpwrvgnd_1
X_05021_ _01543_ is_beq_bne_blt_bge_bltu_bgeu VGND VGND VPWR VPWR _01644_ sky130_fd_sc_hd__nor2_1
XFILLER_6_85 VPWR VGND VPWR VGND sky130_ef_sc_hd__decap_12
XFILLER_113_600 VPWR VGND VPWR VGND sky130_ef_sc_hd__decap_12
XFILLER_140_474 VGND VGND VPWR VPWR sky130_fd_sc_hd__fill_2
X_06972_ cpuregs\[8\]\[24\] cpuregs\[9\]\[24\] cpuregs\[10\]\[24\] cpuregs\[11\]\[24\]
+ net267 net261 VGND VGND VPWR VPWR _03386_ sky130_fd_sc_hd__mux4_1
XFILLER_101_817 VGND VGND VPWR VPWR sky130_fd_sc_hd__fill_1
XTAP_TAPCELL_ROW_91_1791 VGND VPWR sky130_fd_sc_hd__tapvpwrvgnd_1
XTAP_TAPCELL_ROW_91_1780 VGND VPWR sky130_fd_sc_hd__tapvpwrvgnd_1
X_09760_ _02586_ cpuregs\[7\]\[0\] _04874_ VGND VGND VPWR VPWR _01414_ sky130_fd_sc_hd__mux2_1
X_09691_ cpuregs\[4\]\[30\] _02709_ net238 VGND VGND VPWR VPWR _01348_ sky130_fd_sc_hd__mux2_1
XFILLER_79_580 VGND VGND VPWR VPWR sky130_fd_sc_hd__decap_6
X_05923_ net608 _01553_ _01667_ _01672_ VGND VGND VPWR VPWR net131 sky130_fd_sc_hd__a2bb2o_1
X_08711_ net269 _04400_ _01559_ VGND VGND VPWR VPWR _04401_ sky130_fd_sc_hd__a21o_1
XFILLER_82_701 VGND VGND VPWR VPWR sky130_fd_sc_hd__decap_8
X_08642_ cpuregs\[20\]\[9\] cpuregs\[21\]\[9\] cpuregs\[22\]\[9\] cpuregs\[23\]\[9\]
+ net278 net273 VGND VGND VPWR VPWR _04335_ sky130_fd_sc_hd__mux4_1
XFILLER_39_466 VGND VGND VPWR VPWR sky130_fd_sc_hd__fill_2
X_05854_ _02098_ _02382_ _02222_ VGND VGND VPWR VPWR _02413_ sky130_fd_sc_hd__o21ai_2
XFILLER_94_594 VGND VGND VPWR VPWR sky130_fd_sc_hd__fill_1
Xrebuffer46 net433 VGND VGND VPWR VPWR net432 sky130_fd_sc_hd__dlygate4sd1_1
Xrebuffer24 _03590_ VGND VGND VPWR VPWR net410 sky130_fd_sc_hd__dlygate4sd1_1
Xrebuffer35 net422 VGND VGND VPWR VPWR net421 sky130_fd_sc_hd__dlygate4sd1_1
Xrebuffer13 _03585_ VGND VGND VPWR VPWR net399 sky130_fd_sc_hd__dlygate4sd1_1
X_05785_ _02112_ _02237_ VGND VGND VPWR VPWR _02352_ sky130_fd_sc_hd__and2b_1
Xrebuffer57 _03595_ VGND VGND VPWR VPWR net443 sky130_fd_sc_hd__dlygate4sd1_1
X_08573_ cpuregs\[4\]\[5\] cpuregs\[5\]\[5\] cpuregs\[6\]\[5\] cpuregs\[7\]\[5\] net279
+ _00008_ VGND VGND VPWR VPWR _04270_ sky130_fd_sc_hd__mux4_1
Xrebuffer68 net453 VGND VGND VPWR VPWR net454 sky130_fd_sc_hd__buf_2
XFILLER_81_288 VGND VGND VPWR VPWR sky130_fd_sc_hd__decap_3
XFILLER_25_39 VPWR VGND VPWR VGND sky130_ef_sc_hd__decap_12
X_07524_ _02616_ cpuregs\[16\]\[8\] _03570_ VGND VGND VPWR VPWR _00460_ sky130_fd_sc_hd__mux2_1
XTAP_TAPCELL_ROW_122_2290 VGND VPWR sky130_fd_sc_hd__tapvpwrvgnd_1
X_07455_ cpuregs\[15\]\[6\] _02607_ net246 VGND VGND VPWR VPWR _00394_ sky130_fd_sc_hd__mux2_1
XFILLER_23_889 VGND VGND VPWR VPWR sky130_fd_sc_hd__decap_6
X_06406_ net258 _02839_ _00015_ VGND VGND VPWR VPWR _02840_ sky130_fd_sc_hd__a21o_1
XTAP_TAPCELL_ROW_33_862 VGND VPWR sky130_fd_sc_hd__tapvpwrvgnd_1
XTAP_TAPCELL_ROW_98_1901 VGND VPWR sky130_fd_sc_hd__tapvpwrvgnd_1
X_07386_ cpuregs\[14\]\[4\] _02598_ net247 VGND VGND VPWR VPWR _00328_ sky130_fd_sc_hd__mux2_1
X_09125_ instr_sb _04747_ _04760_ is_sb_sh_sw VGND VGND VPWR VPWR _00859_ sky130_fd_sc_hd__a22o_1
X_06337_ _01578_ _02772_ VGND VGND VPWR VPWR _02773_ sky130_fd_sc_hd__or2_1
XFILLER_135_235 VGND VGND VPWR VPWR sky130_fd_sc_hd__decap_4
X_06268_ _02584_ _02706_ _02707_ VGND VGND VPWR VPWR _02708_ sky130_fd_sc_hd__and3_1
X_09056_ _04721_ _04722_ _01558_ VGND VGND VPWR VPWR _04727_ sky130_fd_sc_hd__mux2_1
X_05219_ _01821_ cpu_state\[3\] _01820_ VGND VGND VPWR VPWR _01822_ sky130_fd_sc_hd__and3b_1
X_08007_ _01547_ reg_next_pc\[11\] _01645_ _03698_ VGND VGND VPWR VPWR _03829_ sky130_fd_sc_hd__a22o_1
X_06199_ reg_pc\[17\] reg_pc\[16\] _02644_ VGND VGND VPWR VPWR _02652_ sky130_fd_sc_hd__and3_1
XFILLER_2_749 VGND VGND VPWR VPWR sky130_fd_sc_hd__decap_6
Xmax_cap270 _00009_ VGND VGND VPWR VPWR net270 sky130_fd_sc_hd__buf_12
XTAP_TAPCELL_ROW_129_2400 VGND VPWR sky130_fd_sc_hd__tapvpwrvgnd_1
XFILLER_104_666 VGND VGND VPWR VPWR sky130_fd_sc_hd__decap_8
XFILLER_1_237 VPWR VGND VPWR VGND sky130_ef_sc_hd__decap_12
XFILLER_131_474 VGND VGND VPWR VPWR sky130_fd_sc_hd__fill_1
X_09958_ clknet_leaf_62_clk _00088_ VGND VGND VPWR VPWR net181 sky130_fd_sc_hd__dfxtp_4
XFILLER_106_53 VPWR VGND VPWR VGND sky130_ef_sc_hd__decap_12
XFILLER_104_699 VGND VGND VPWR VPWR sky130_fd_sc_hd__fill_1
XFILLER_77_517 VGND VGND VPWR VPWR sky130_fd_sc_hd__decap_8
X_08909_ net270 _04584_ _04583_ _01560_ VGND VGND VPWR VPWR _04588_ sky130_fd_sc_hd__o211a_1
X_09889_ cpuregs\[0\]\[19\] VGND VGND VPWR VPWR _01497_ sky130_fd_sc_hd__clkbuf_1
XTAP_TAPCELL_ROW_142_2611 VGND VPWR sky130_fd_sc_hd__tapvpwrvgnd_1
XTAP_TAPCELL_ROW_142_2600 VGND VPWR sky130_fd_sc_hd__tapvpwrvgnd_1
XFILLER_92_509 VGND VGND VPWR VPWR sky130_fd_sc_hd__fill_1
XFILLER_17_149 VGND VGND VPWR VPWR sky130_fd_sc_hd__decap_3
XFILLER_45_447 VGND VGND VPWR VPWR sky130_fd_sc_hd__fill_1
XFILLER_122_85 VPWR VGND VPWR VGND sky130_ef_sc_hd__decap_12
XFILLER_72_266 VPWR VGND VPWR VGND sky130_ef_sc_hd__decap_12
X_10802_ clknet_leaf_103_clk _00867_ VGND VGND VPWR VPWR instr_sw sky130_fd_sc_hd__dfxtp_1
XFILLER_60_406 VGND VGND VPWR VPWR sky130_fd_sc_hd__fill_1
XFILLER_32_119 VGND VGND VPWR VPWR sky130_fd_sc_hd__decap_3
X_10733_ clknet_leaf_65_clk _00830_ VGND VGND VPWR VPWR net219 sky130_fd_sc_hd__dfxtp_2
XFILLER_14_867 VGND VGND VPWR VPWR sky130_fd_sc_hd__fill_1
XTAP_TAPCELL_ROW_45_1045 VGND VPWR sky130_fd_sc_hd__tapvpwrvgnd_1
XFILLER_40_141 VPWR VGND VPWR VGND sky130_ef_sc_hd__decap_12
XTAP_TAPCELL_ROW_45_1056 VGND VPWR sky130_fd_sc_hd__tapvpwrvgnd_1
XPHY_EDGE_ROW_149_Left_303 VGND VGND VPWR VPWR sky130_fd_sc_hd__decap_3
X_10664_ clknet_leaf_92_clk _04892_ VGND VGND VPWR VPWR reg_out\[22\] sky130_fd_sc_hd__dfxtp_1
XTAP_TAPCELL_ROW_11_512 VGND VPWR sky130_fd_sc_hd__tapvpwrvgnd_1
XTAP_TAPCELL_ROW_11_501 VGND VPWR sky130_fd_sc_hd__tapvpwrvgnd_1
XFILLER_9_337 VGND VGND VPWR VPWR sky130_fd_sc_hd__fill_1
X_10595_ clknet_leaf_87_clk _00725_ VGND VGND VPWR VPWR count_cycle\[18\] sky130_fd_sc_hd__dfxtp_1
XTAP_TAPCELL_ROW_153_2773 VGND VPWR sky130_fd_sc_hd__tapvpwrvgnd_1
XTAP_TAPCELL_ROW_153_2795 VGND VPWR sky130_fd_sc_hd__tapvpwrvgnd_1
XTAP_TAPCELL_ROW_153_2784 VGND VPWR sky130_fd_sc_hd__tapvpwrvgnd_1
XFILLER_114_408 VPWR VGND VPWR VGND sky130_ef_sc_hd__decap_12
XFILLER_147_93 VPWR VGND VPWR VGND sky130_ef_sc_hd__decap_12
XFILLER_142_739 VGND VGND VPWR VPWR sky130_fd_sc_hd__fill_1
XPHY_EDGE_ROW_128_Right_128 VGND VGND VPWR VPWR sky130_fd_sc_hd__decap_3
Xoutput60 net60 VGND VGND VPWR VPWR mem_addr[5] sky130_fd_sc_hd__buf_2
X_11216_ clknet_leaf_151_clk _01263_ VGND VGND VPWR VPWR cpuregs\[3\]\[9\] sky130_fd_sc_hd__dfxtp_1
Xoutput82 net82 VGND VGND VPWR VPWR mem_la_addr[26] sky130_fd_sc_hd__buf_2
XFILLER_110_603 VGND VGND VPWR VPWR sky130_fd_sc_hd__decap_6
Xoutput71 net71 VGND VGND VPWR VPWR mem_la_addr[15] sky130_fd_sc_hd__buf_2
Xoutput93 net93 VGND VGND VPWR VPWR mem_la_addr[7] sky130_fd_sc_hd__buf_2
X_11147_ clknet_leaf_137_clk _01194_ VGND VGND VPWR VPWR cpuregs\[23\]\[4\] sky130_fd_sc_hd__dfxtp_1
XFILLER_0_281 VPWR VGND VPWR VGND sky130_ef_sc_hd__decap_12
XFILLER_95_358 VGND VGND VPWR VPWR sky130_fd_sc_hd__decap_8
X_11078_ clknet_leaf_146_clk _01135_ VGND VGND VPWR VPWR cpuregs\[24\]\[9\] sky130_fd_sc_hd__dfxtp_1
X_10029_ clknet_leaf_34_clk _00159_ VGND VGND VPWR VPWR cpuregs\[30\]\[27\] sky130_fd_sc_hd__dfxtp_1
XFILLER_36_414 VGND VGND VPWR VPWR sky130_fd_sc_hd__decap_6
XFILLER_17_650 VPWR VGND VPWR VGND sky130_ef_sc_hd__decap_12
XTAP_TAPCELL_ROW_19_634 VGND VPWR sky130_fd_sc_hd__tapvpwrvgnd_1
X_05570_ _02152_ VGND VGND VPWR VPWR _02153_ sky130_fd_sc_hd__inv_2
XFILLER_44_491 VGND VGND VPWR VPWR sky130_fd_sc_hd__fill_1
XFILLER_32_664 VGND VGND VPWR VPWR sky130_fd_sc_hd__fill_2
XFILLER_149_349 VGND VGND VPWR VPWR sky130_fd_sc_hd__decap_3
X_07240_ cpuregs\[13\]\[24\] _02683_ net251 VGND VGND VPWR VPWR _00188_ sky130_fd_sc_hd__mux2_1
XFILLER_20_837 VPWR VGND VPWR VGND sky130_ef_sc_hd__decap_12
XTAP_TAPCELL_ROW_30_810 VGND VPWR sky130_fd_sc_hd__tapvpwrvgnd_1
XFILLER_31_163 VGND VGND VPWR VPWR sky130_fd_sc_hd__decap_4
X_07171_ cpuregs\[12\]\[25\] _02688_ net253 VGND VGND VPWR VPWR _00125_ sky130_fd_sc_hd__mux2_1
XFILLER_145_533 VGND VGND VPWR VPWR sky130_fd_sc_hd__decap_6
XFILLER_117_202 VGND VGND VPWR VPWR sky130_fd_sc_hd__decap_6
X_06122_ _01548_ _02589_ _02583_ VGND VGND VPWR VPWR _02590_ sky130_fd_sc_hd__mux2_8
XTAP_TAPCELL_ROW_93_1820 VGND VPWR sky130_fd_sc_hd__tapvpwrvgnd_1
X_06053_ decoded_imm_j\[3\] decoded_imm_j\[2\] decoded_imm_j\[1\] _02525_ VGND VGND
+ VPWR VPWR _02526_ sky130_fd_sc_hd__nor4_4
X_05004_ mem_wordsize\[0\] _01627_ _01631_ VGND VGND VPWR VPWR _00024_ sky130_fd_sc_hd__a21o_1
XFILLER_141_783 VGND VGND VPWR VPWR sky130_fd_sc_hd__fill_1
X_09812_ _02662_ cpuregs\[8\]\[19\] _04875_ VGND VGND VPWR VPWR _01465_ sky130_fd_sc_hd__mux2_1
XFILLER_101_614 VGND VGND VPWR VPWR sky130_fd_sc_hd__fill_2
XFILLER_98_141 VGND VGND VPWR VPWR sky130_fd_sc_hd__decap_3
XFILLER_101_658 VGND VGND VPWR VPWR sky130_fd_sc_hd__decap_3
XFILLER_100_124 VGND VGND VPWR VPWR sky130_fd_sc_hd__decap_6
X_06955_ _03346_ _03347_ _03321_ VGND VGND VPWR VPWR _03369_ sky130_fd_sc_hd__or3b_1
X_09743_ _02649_ cpuregs\[6\]\[16\] _04873_ VGND VGND VPWR VPWR _01398_ sky130_fd_sc_hd__mux2_1
XFILLER_67_561 VGND VGND VPWR VPWR sky130_fd_sc_hd__fill_2
XTAP_TAPCELL_ROW_107_2049 VGND VPWR sky130_fd_sc_hd__tapvpwrvgnd_1
XTAP_TAPCELL_ROW_107_2038 VGND VPWR sky130_fd_sc_hd__tapvpwrvgnd_1
X_06886_ _01566_ _02721_ VGND VGND VPWR VPWR _03303_ sky130_fd_sc_hd__nand2_1
X_05906_ _02073_ _02452_ _02074_ VGND VGND VPWR VPWR _02459_ sky130_fd_sc_hd__a21oi_1
XFILLER_67_594 VGND VGND VPWR VPWR sky130_fd_sc_hd__decap_6
XFILLER_67_572 VGND VGND VPWR VPWR sky130_fd_sc_hd__decap_6
X_09674_ cpuregs\[4\]\[13\] _02638_ net238 VGND VGND VPWR VPWR _01331_ sky130_fd_sc_hd__mux2_1
XFILLER_27_414 VPWR VGND VPWR VGND sky130_ef_sc_hd__decap_12
XFILLER_36_27 VGND VGND VPWR VPWR sky130_fd_sc_hd__fill_1
XTAP_TAPCELL_ROW_38_932 VGND VPWR sky130_fd_sc_hd__tapvpwrvgnd_1
XFILLER_39_285 VGND VGND VPWR VPWR sky130_fd_sc_hd__fill_1
X_05837_ _02090_ _02095_ _02094_ VGND VGND VPWR VPWR _02398_ sky130_fd_sc_hd__o21ai_1
XFILLER_82_542 VGND VGND VPWR VPWR sky130_fd_sc_hd__fill_1
XFILLER_82_531 VGND VGND VPWR VPWR sky130_fd_sc_hd__fill_1
XFILLER_27_447 VGND VGND VPWR VPWR sky130_fd_sc_hd__fill_1
X_08625_ net270 _04318_ VGND VGND VPWR VPWR _04319_ sky130_fd_sc_hd__or2_1
XTAP_TAPCELL_ROW_38_943 VGND VPWR sky130_fd_sc_hd__tapvpwrvgnd_1
XFILLER_54_277 VGND VGND VPWR VPWR sky130_fd_sc_hd__fill_1
XFILLER_14_108 VGND VGND VPWR VPWR sky130_fd_sc_hd__decap_6
X_08556_ _01570_ _01585_ _04256_ VGND VGND VPWR VPWR _00807_ sky130_fd_sc_hd__o21ai_1
X_07507_ cpuregs\[26\]\[25\] _02688_ _03568_ VGND VGND VPWR VPWR _00445_ sky130_fd_sc_hd__mux2_1
XTAP_TAPCELL_ROW_120_2249 VGND VPWR sky130_fd_sc_hd__tapvpwrvgnd_1
X_05768_ _02335_ _02336_ instr_sub VGND VGND VPWR VPWR _02337_ sky130_fd_sc_hd__mux2_1
X_08487_ net71 net40 _04208_ VGND VGND VPWR VPWR _00785_ sky130_fd_sc_hd__mux2_1
XFILLER_50_461 VPWR VGND VPWR VGND sky130_ef_sc_hd__decap_12
X_05699_ _02275_ _02188_ instr_sub VGND VGND VPWR VPWR _02276_ sky130_fd_sc_hd__mux2_1
XFILLER_22_141 VPWR VGND VPWR VGND sky130_ef_sc_hd__decap_12
X_07438_ cpuregs\[27\]\[22\] _02675_ _03566_ VGND VGND VPWR VPWR _00378_ sky130_fd_sc_hd__mux2_1
XTAP_TAPCELL_ROW_102_1971 VGND VPWR sky130_fd_sc_hd__tapvpwrvgnd_1
XTAP_TAPCELL_ROW_102_1960 VGND VPWR sky130_fd_sc_hd__tapvpwrvgnd_1
XFILLER_10_303 VGND VGND VPWR VPWR sky130_fd_sc_hd__decap_4
XFILLER_22_174 VGND VGND VPWR VPWR sky130_fd_sc_hd__decap_8
X_07369_ _02665_ cpuregs\[9\]\[20\] _03563_ VGND VGND VPWR VPWR _00312_ sky130_fd_sc_hd__mux2_1
XFILLER_6_307 VGND VGND VPWR VPWR sky130_fd_sc_hd__fill_1
XFILLER_136_533 VGND VGND VPWR VPWR sky130_fd_sc_hd__fill_2
XFILLER_109_736 VGND VGND VPWR VPWR sky130_fd_sc_hd__decap_8
XFILLER_108_224 VGND VGND VPWR VPWR sky130_fd_sc_hd__fill_1
X_09108_ instr_bgeu _04748_ _04750_ _04757_ VGND VGND VPWR VPWR _00852_ sky130_fd_sc_hd__a22o_1
XFILLER_136_566 VPWR VGND VPWR VGND sky130_ef_sc_hd__decap_12
XTAP_TAPCELL_ROW_135_2492 VGND VPWR sky130_fd_sc_hd__tapvpwrvgnd_1
X_10380_ clknet_leaf_43_clk _00510_ VGND VGND VPWR VPWR cpuregs\[25\]\[26\] sky130_fd_sc_hd__dfxtp_1
XFILLER_117_780 VGND VGND VPWR VPWR sky130_fd_sc_hd__decap_4
X_09039_ net269 _04707_ _04710_ _04266_ VGND VGND VPWR VPWR _04711_ sky130_fd_sc_hd__o211a_1
XFILLER_151_558 VGND VGND VPWR VPWR sky130_fd_sc_hd__fill_2
XFILLER_123_249 VPWR VGND VPWR VGND sky130_ef_sc_hd__decap_12
XFILLER_2_557 VPWR VGND VPWR VGND sky130_ef_sc_hd__decap_12
XFILLER_78_837 VPWR VGND VPWR VGND sky130_ef_sc_hd__decap_12
XFILLER_78_826 VGND VGND VPWR VPWR sky130_fd_sc_hd__fill_1
XFILLER_77_34 VGND VGND VPWR VPWR sky130_fd_sc_hd__decap_6
X_11001_ clknet_leaf_116_clk _01063_ VGND VGND VPWR VPWR cpuregs\[19\]\[1\] sky130_fd_sc_hd__dfxtp_1
XFILLER_132_794 VPWR VGND VPWR VGND sky130_ef_sc_hd__decap_12
XFILLER_131_293 VGND VGND VPWR VPWR sky130_fd_sc_hd__decap_3
XFILLER_78_859 VGND VGND VPWR VPWR sky130_fd_sc_hd__decap_8
XFILLER_77_369 VPWR VGND VPWR VGND sky130_ef_sc_hd__decap_12
XFILLER_58_550 VGND VGND VPWR VPWR sky130_fd_sc_hd__fill_1
XFILLER_133_51 VGND VGND VPWR VPWR sky130_fd_sc_hd__decap_4
XFILLER_61_726 VGND VGND VPWR VPWR sky130_fd_sc_hd__fill_2
XFILLER_61_715 VGND VGND VPWR VPWR sky130_fd_sc_hd__fill_2
XFILLER_147_809 VPWR VGND VPWR VGND sky130_ef_sc_hd__decap_12
XFILLER_14_686 VPWR VGND VPWR VGND sky130_ef_sc_hd__decap_12
X_10716_ clknet_leaf_134_clk _00813_ VGND VGND VPWR VPWR net126 sky130_fd_sc_hd__dfxtp_4
X_10647_ clknet_leaf_110_clk _04905_ VGND VGND VPWR VPWR reg_out\[5\] sky130_fd_sc_hd__dfxtp_1
XFILLER_139_393 VGND VGND VPWR VPWR sky130_fd_sc_hd__fill_2
XFILLER_127_533 VPWR VGND VPWR VGND sky130_ef_sc_hd__decap_12
Xrebuffer4 _03595_ VGND VGND VPWR VPWR net390 sky130_fd_sc_hd__dlygate4sd1_1
XFILLER_10_881 VPWR VGND VPWR VGND sky130_ef_sc_hd__decap_12
XFILLER_61_7 VPWR VGND VPWR VGND sky130_ef_sc_hd__decap_12
X_10578_ clknet_leaf_110_clk _00708_ VGND VGND VPWR VPWR count_cycle\[1\] sky130_fd_sc_hd__dfxtp_2
XTAP_TAPCELL_ROW_58_1258 VGND VPWR sky130_fd_sc_hd__tapvpwrvgnd_1
XFILLER_5_373 VPWR VGND VPWR VGND sky130_ef_sc_hd__decap_12
XFILLER_110_400 VGND VGND VPWR VPWR sky130_fd_sc_hd__decap_4
XFILLER_122_282 VGND VGND VPWR VPWR sky130_fd_sc_hd__decap_4
XFILLER_96_645 VGND VGND VPWR VPWR sky130_fd_sc_hd__decap_8
XFILLER_96_623 VGND VGND VPWR VPWR sky130_fd_sc_hd__fill_1
XTAP_TAPCELL_ROW_71_1469 VGND VPWR sky130_fd_sc_hd__tapvpwrvgnd_1
XFILLER_69_848 VGND VGND VPWR VPWR sky130_fd_sc_hd__decap_6
XFILLER_77_870 VGND VGND VPWR VPWR sky130_fd_sc_hd__decap_8
X_06740_ _03160_ _03161_ VGND VGND VPWR VPWR _03162_ sky130_fd_sc_hd__or2_1
XFILLER_64_520 VGND VGND VPWR VPWR sky130_fd_sc_hd__decap_8
XFILLER_49_572 VGND VGND VPWR VPWR sky130_fd_sc_hd__decap_4
X_06671_ cpuregs\[16\]\[13\] cpuregs\[17\]\[13\] cpuregs\[18\]\[13\] cpuregs\[19\]\[13\]
+ net263 net260 VGND VGND VPWR VPWR _03096_ sky130_fd_sc_hd__mux4_1
X_05622_ net219 net187 VGND VGND VPWR VPWR _02205_ sky130_fd_sc_hd__and2b_1
X_08410_ _04155_ _04154_ VGND VGND VPWR VPWR _00762_ sky130_fd_sc_hd__nor2_1
XFILLER_52_726 VGND VGND VPWR VPWR sky130_fd_sc_hd__fill_2
XFILLER_24_439 VPWR VGND VPWR VGND sky130_ef_sc_hd__decap_12
X_09390_ instr_jal decoded_imm_j\[2\] _04791_ mem_rdata_q\[22\] _04747_ VGND VGND
+ VPWR VPWR _04859_ sky130_fd_sc_hd__a221o_1
X_08341_ count_cycle\[29\] _04109_ count_cycle\[30\] VGND VGND VPWR VPWR _04112_ sky130_fd_sc_hd__a21o_1
X_05553_ net202 net234 VGND VGND VPWR VPWR _02136_ sky130_fd_sc_hd__and2_1
XFILLER_32_450 VGND VGND VPWR VPWR sky130_fd_sc_hd__decap_3
XFILLER_149_113 VPWR VGND VPWR VGND sky130_ef_sc_hd__decap_12
X_05484_ net195 net227 VGND VGND VPWR VPWR _02067_ sky130_fd_sc_hd__xor2_4
XFILLER_60_792 VGND VGND VPWR VPWR sky130_fd_sc_hd__fill_1
X_08272_ _04067_ net34 _04066_ VGND VGND VPWR VPWR _00712_ sky130_fd_sc_hd__and3b_1
XFILLER_32_472 VGND VGND VPWR VPWR sky130_fd_sc_hd__decap_4
XFILLER_20_645 VGND VGND VPWR VPWR sky130_fd_sc_hd__decap_6
XFILLER_22_29 VPWR VGND VPWR VGND sky130_ef_sc_hd__decap_12
X_07223_ cpuregs\[13\]\[7\] _02612_ net251 VGND VGND VPWR VPWR _00171_ sky130_fd_sc_hd__mux2_1
XFILLER_138_29 VPWR VGND VPWR VGND sky130_ef_sc_hd__decap_12
XFILLER_118_533 VPWR VGND VPWR VGND sky130_ef_sc_hd__decap_12
X_07154_ cpuregs\[12\]\[8\] _02616_ net253 VGND VGND VPWR VPWR _00108_ sky130_fd_sc_hd__mux2_1
X_07085_ _03486_ _03487_ _03491_ _03492_ _01579_ _01581_ VGND VGND VPWR VPWR _03495_
+ sky130_fd_sc_hd__mux4_1
XFILLER_133_503 VGND VGND VPWR VPWR sky130_fd_sc_hd__fill_1
X_06105_ _02571_ _02575_ _02526_ _02567_ VGND VGND VPWR VPWR _02576_ sky130_fd_sc_hd__a211o_1
X_06036_ decoded_imm_j\[17\] _01111_ _02513_ VGND VGND VPWR VPWR _00034_ sky130_fd_sc_hd__mux2_1
XFILLER_99_472 VPWR VGND VPWR VGND sky130_ef_sc_hd__decap_12
XFILLER_101_411 VGND VGND VPWR VPWR sky130_fd_sc_hd__fill_1
XFILLER_99_494 VGND VGND VPWR VPWR sky130_fd_sc_hd__decap_8
X_07987_ _03808_ _03809_ VGND VGND VPWR VPWR _03810_ sky130_fd_sc_hd__nand2_1
X_06938_ _01622_ _03348_ _03349_ _03352_ _02714_ VGND VGND VPWR VPWR _03353_ sky130_fd_sc_hd__a311o_1
X_09726_ _03554_ _04870_ VGND VGND VPWR VPWR _04873_ sky130_fd_sc_hd__or2_4
XFILLER_67_391 VGND VGND VPWR VPWR sky130_fd_sc_hd__fill_1
XTAP_TAPCELL_ROW_2_365 VGND VPWR sky130_fd_sc_hd__tapvpwrvgnd_1
X_06869_ cpuregs\[12\]\[20\] cpuregs\[13\]\[20\] cpuregs\[14\]\[20\] cpuregs\[15\]\[20\]
+ net267 _00013_ VGND VGND VPWR VPWR _03287_ sky130_fd_sc_hd__mux4_1
XFILLER_103_43 VPWR VGND VPWR VGND sky130_ef_sc_hd__decap_12
X_09657_ _02709_ cpuregs\[22\]\[30\] _04869_ VGND VGND VPWR VPWR _01316_ sky130_fd_sc_hd__mux2_1
XFILLER_83_895 VGND VGND VPWR VPWR sky130_fd_sc_hd__fill_1
XFILLER_83_884 VGND VGND VPWR VPWR sky130_fd_sc_hd__fill_1
XFILLER_43_704 VGND VGND VPWR VPWR sky130_fd_sc_hd__fill_2
X_09588_ cpuregs\[29\]\[27\] _02696_ _04867_ VGND VGND VPWR VPWR _01249_ sky130_fd_sc_hd__mux2_1
X_08608_ cpuregs\[24\]\[7\] cpuregs\[25\]\[7\] cpuregs\[26\]\[7\] cpuregs\[27\]\[7\]
+ net279 _00008_ VGND VGND VPWR VPWR _04303_ sky130_fd_sc_hd__mux4_1
XFILLER_70_578 VGND VGND VPWR VPWR sky130_fd_sc_hd__fill_2
X_08539_ _04238_ _04239_ _00009_ VGND VGND VPWR VPWR _04240_ sky130_fd_sc_hd__mux2_1
XFILLER_129_809 VPWR VGND VPWR VGND sky130_ef_sc_hd__decap_12
XTAP_TAPCELL_ROW_42_1004 VGND VPWR sky130_fd_sc_hd__tapvpwrvgnd_1
XTAP_TAPCELL_ROW_137_2521 VGND VPWR sky130_fd_sc_hd__tapvpwrvgnd_1
XFILLER_137_3 VPWR VGND VPWR VGND sky130_ef_sc_hd__decap_12
X_10501_ clknet_leaf_86_clk _00631_ VGND VGND VPWR VPWR count_instr\[50\] sky130_fd_sc_hd__dfxtp_1
XFILLER_10_133 VGND VGND VPWR VPWR sky130_fd_sc_hd__decap_6
XFILLER_109_511 VGND VGND VPWR VPWR sky130_fd_sc_hd__decap_3
X_11481_ clknet_leaf_15_clk _01525_ VGND VGND VPWR VPWR cpuregs\[10\]\[15\] sky130_fd_sc_hd__dfxtp_1
XTAP_TAPCELL_ROW_21_662 VGND VPWR sky130_fd_sc_hd__tapvpwrvgnd_1
XTAP_TAPCELL_ROW_21_673 VGND VPWR sky130_fd_sc_hd__tapvpwrvgnd_1
XFILLER_137_853 VPWR VGND VPWR VGND sky130_ef_sc_hd__decap_12
X_10432_ clknet_leaf_28_clk _00562_ VGND VGND VPWR VPWR cpuregs\[17\]\[14\] sky130_fd_sc_hd__dfxtp_1
XTAP_TAPCELL_ROW_150_2732 VGND VPWR sky130_fd_sc_hd__tapvpwrvgnd_1
XFILLER_137_897 VPWR VGND VPWR VGND sky130_ef_sc_hd__decap_12
X_10363_ clknet_leaf_1_clk _00493_ VGND VGND VPWR VPWR cpuregs\[25\]\[9\] sky130_fd_sc_hd__dfxtp_1
XFILLER_152_867 VGND VGND VPWR VPWR sky130_fd_sc_hd__fill_1
XFILLER_136_396 VPWR VGND VPWR VGND sky130_ef_sc_hd__decap_12
XFILLER_3_833 VGND VGND VPWR VPWR sky130_fd_sc_hd__decap_6
XFILLER_151_355 VPWR VGND VPWR VGND sky130_ef_sc_hd__decap_12
XFILLER_88_77 VGND VGND VPWR VPWR sky130_fd_sc_hd__decap_6
XFILLER_78_601 VGND VGND VPWR VPWR sky130_fd_sc_hd__decap_6
XFILLER_3_877 VPWR VGND VPWR VGND sky130_ef_sc_hd__decap_12
XFILLER_2_365 VPWR VGND VPWR VGND sky130_ef_sc_hd__decap_12
X_10294_ clknet_leaf_137_clk _00424_ VGND VGND VPWR VPWR cpuregs\[26\]\[4\] sky130_fd_sc_hd__dfxtp_1
XFILLER_105_783 VGND VGND VPWR VPWR sky130_fd_sc_hd__fill_1
XFILLER_144_83 VGND VGND VPWR VPWR sky130_fd_sc_hd__fill_1
XTAP_TAPCELL_ROW_53_1177 VGND VPWR sky130_fd_sc_hd__tapvpwrvgnd_1
XTAP_TAPCELL_ROW_148_2694 VGND VPWR sky130_fd_sc_hd__tapvpwrvgnd_1
XFILLER_120_797 VPWR VGND VPWR VGND sky130_ef_sc_hd__decap_12
XFILLER_80_309 VGND VGND VPWR VPWR sky130_fd_sc_hd__decap_8
XFILLER_18_266 VGND VGND VPWR VPWR sky130_fd_sc_hd__fill_1
XFILLER_61_523 VPWR VGND VPWR VGND sky130_ef_sc_hd__decap_12
XFILLER_18_288 VGND VGND VPWR VPWR sky130_fd_sc_hd__decap_4
XTAP_TAPCELL_ROW_29_795 VGND VPWR sky130_fd_sc_hd__tapvpwrvgnd_1
XFILLER_61_578 VGND VGND VPWR VPWR sky130_fd_sc_hd__decap_4
XFILLER_21_409 VPWR VGND VPWR VGND sky130_ef_sc_hd__decap_12
XFILLER_14_461 VGND VGND VPWR VPWR sky130_fd_sc_hd__fill_1
XFILLER_147_617 VPWR VGND VPWR VGND sky130_ef_sc_hd__decap_12
XFILLER_53_91 VGND VGND VPWR VPWR sky130_fd_sc_hd__decap_3
XTAP_TAPCELL_ROW_40_971 VGND VPWR sky130_fd_sc_hd__tapvpwrvgnd_1
XFILLER_143_834 VGND VGND VPWR VPWR sky130_fd_sc_hd__decap_6
Xpicorv32_303 VGND VGND VPWR VPWR picorv32_303/HI eoi[22] sky130_fd_sc_hd__conb_1
Xpicorv32_336 VGND VGND VPWR VPWR picorv32_336/HI pcpi_insn[19] sky130_fd_sc_hd__conb_1
XFILLER_115_503 VGND VGND VPWR VPWR sky130_fd_sc_hd__fill_1
Xpicorv32_325 VGND VGND VPWR VPWR picorv32_325/HI pcpi_insn[8] sky130_fd_sc_hd__conb_1
XFILLER_6_671 VGND VGND VPWR VPWR sky130_fd_sc_hd__decap_6
Xpicorv32_314 VGND VGND VPWR VPWR picorv32_314/HI mem_addr[1] sky130_fd_sc_hd__conb_1
XFILLER_6_693 VGND VGND VPWR VPWR sky130_fd_sc_hd__decap_6
XFILLER_5_181 VPWR VGND VPWR VGND sky130_ef_sc_hd__decap_12
Xpicorv32_358 VGND VGND VPWR VPWR picorv32_358/HI trace_data[8] sky130_fd_sc_hd__conb_1
Xpicorv32_369 VGND VGND VPWR VPWR picorv32_369/HI trace_data[19] sky130_fd_sc_hd__conb_1
Xpicorv32_347 VGND VGND VPWR VPWR picorv32_347/HI pcpi_insn[30] sky130_fd_sc_hd__conb_1
XFILLER_143_889 VGND VGND VPWR VPWR sky130_fd_sc_hd__decap_6
XFILLER_69_612 VGND VGND VPWR VPWR sky130_fd_sc_hd__decap_4
X_08890_ _01558_ _04566_ _01559_ VGND VGND VPWR VPWR _04570_ sky130_fd_sc_hd__o21a_1
XFILLER_69_634 VPWR VGND VPWR VGND sky130_ef_sc_hd__decap_12
XFILLER_69_623 VGND VGND VPWR VPWR sky130_fd_sc_hd__fill_2
X_07910_ instr_jal _03738_ _03739_ _03737_ net406 VGND VGND VPWR VPWR _03740_ sky130_fd_sc_hd__o221a_1
XFILLER_111_753 VGND VGND VPWR VPWR sky130_fd_sc_hd__decap_6
X_07841_ _02617_ reg_next_pc\[9\] _02482_ VGND VGND VPWR VPWR _03696_ sky130_fd_sc_hd__mux2_2
XFILLER_29_509 VGND VGND VPWR VPWR sky130_fd_sc_hd__fill_1
XFILLER_84_615 VGND VGND VPWR VPWR sky130_fd_sc_hd__fill_1
X_07772_ count_instr\[44\] _03653_ net34 VGND VGND VPWR VPWR _03655_ sky130_fd_sc_hd__o21ai_1
XFILLER_68_188 VGND VGND VPWR VPWR sky130_fd_sc_hd__decap_8
XTAP_TAPCELL_ROW_88_1741 VGND VPWR sky130_fd_sc_hd__tapvpwrvgnd_1
X_09511_ cpuregs\[31\]\[16\] _02649_ net240 VGND VGND VPWR VPWR _01174_ sky130_fd_sc_hd__mux2_1
X_06723_ cpuregs\[0\]\[15\] cpuregs\[1\]\[15\] cpuregs\[2\]\[15\] cpuregs\[3\]\[15\]
+ net265 net260 VGND VGND VPWR VPWR _03146_ sky130_fd_sc_hd__mux4_1
XFILLER_49_391 VGND VGND VPWR VPWR sky130_fd_sc_hd__fill_1
X_04984_ mem_do_rinst _01608_ _01611_ VGND VGND VPWR VPWR _01612_ sky130_fd_sc_hd__a21oi_4
XFILLER_83_169 VGND VGND VPWR VPWR sky130_fd_sc_hd__decap_3
XFILLER_80_810 VGND VGND VPWR VPWR sky130_fd_sc_hd__fill_2
XFILLER_92_692 VGND VGND VPWR VPWR sky130_fd_sc_hd__decap_8
X_09442_ _02638_ cpuregs\[19\]\[13\] _04863_ VGND VGND VPWR VPWR _01075_ sky130_fd_sc_hd__mux2_1
X_06654_ reg_pc\[12\] _02751_ _03079_ _02715_ VGND VGND VPWR VPWR _03080_ sky130_fd_sc_hd__a211o_1
XFILLER_65_895 VGND VGND VPWR VPWR sky130_fd_sc_hd__fill_1
XFILLER_91_191 VPWR VGND VPWR VGND sky130_ef_sc_hd__decap_12
X_06585_ net176 net254 VGND VGND VPWR VPWR _03013_ sky130_fd_sc_hd__or2_1
X_09373_ instr_jal decoded_imm_j\[9\] _04823_ mem_rdata_q\[29\] _04747_ VGND VGND
+ VPWR VPWR _04849_ sky130_fd_sc_hd__a221o_1
X_05605_ net198 _01573_ _02187_ VGND VGND VPWR VPWR _02188_ sky130_fd_sc_hd__o21a_1
X_08324_ _04100_ _04101_ VGND VGND VPWR VPWR _00730_ sky130_fd_sc_hd__nor2_1
XFILLER_80_898 VGND VGND VPWR VPWR sky130_fd_sc_hd__decap_4
X_05536_ _02116_ _02118_ VGND VGND VPWR VPWR _02119_ sky130_fd_sc_hd__and2_1
XFILLER_52_589 VGND VGND VPWR VPWR sky130_fd_sc_hd__decap_6
XFILLER_33_39 VPWR VGND VPWR VGND sky130_ef_sc_hd__decap_12
XFILLER_149_39 VPWR VGND VPWR VGND sky130_ef_sc_hd__decap_12
XTAP_TAPCELL_ROW_119_2240 VGND VPWR sky130_fd_sc_hd__tapvpwrvgnd_1
X_05467_ net188 net220 VGND VGND VPWR VPWR _02050_ sky130_fd_sc_hd__or2_1
X_08255_ _04052_ _04053_ _04056_ instr_jal VGND VGND VPWR VPWR _04057_ sky130_fd_sc_hd__a22o_1
X_07206_ cpuregs\[30\]\[24\] _02683_ _03556_ VGND VGND VPWR VPWR _00156_ sky130_fd_sc_hd__mux2_1
X_08186_ _03989_ _03990_ _03993_ VGND VGND VPWR VPWR _03994_ sky130_fd_sc_hd__o21ai_1
XFILLER_119_853 VPWR VGND VPWR VGND sky130_ef_sc_hd__decap_12
X_05398_ count_instr\[58\] instr_rdinstrh _01587_ _01986_ VGND VGND VPWR VPWR _01987_
+ sky130_fd_sc_hd__a211o_1
XPHY_EDGE_ROW_104_Left_258 VGND VGND VPWR VPWR sky130_fd_sc_hd__decap_3
XTAP_TAPCELL_ROW_132_2440 VGND VPWR sky130_fd_sc_hd__tapvpwrvgnd_1
XFILLER_119_897 VGND VGND VPWR VPWR sky130_fd_sc_hd__decap_8
X_07137_ _03536_ _03543_ _03544_ _01581_ _01580_ VGND VGND VPWR VPWR _03545_ sky130_fd_sc_hd__a221o_1
XFILLER_145_193 VPWR VGND VPWR VGND sky130_ef_sc_hd__decap_12
XFILLER_134_867 VGND VGND VPWR VPWR sky130_fd_sc_hd__fill_1
XTAP_TAPCELL_ROW_132_2451 VGND VPWR sky130_fd_sc_hd__tapvpwrvgnd_1
X_07068_ _03449_ _03451_ _03448_ VGND VGND VPWR VPWR _03478_ sky130_fd_sc_hd__o21a_1
X_06019_ _01546_ _01613_ VGND VGND VPWR VPWR _02513_ sky130_fd_sc_hd__nor2_8
XTAP_TAPCELL_ROW_7_446 VGND VPWR sky130_fd_sc_hd__tapvpwrvgnd_1
XFILLER_0_825 VGND VGND VPWR VPWR sky130_fd_sc_hd__decap_4
XFILLER_101_241 VGND VGND VPWR VPWR sky130_fd_sc_hd__decap_6
XFILLER_0_869 VGND VGND VPWR VPWR sky130_fd_sc_hd__decap_6
XFILLER_87_475 VGND VGND VPWR VPWR sky130_fd_sc_hd__fill_1
XFILLER_59_166 VGND VGND VPWR VPWR sky130_fd_sc_hd__fill_2
XFILLER_114_64 VPWR VGND VPWR VGND sky130_ef_sc_hd__decap_12
XPHY_EDGE_ROW_113_Left_267 VGND VGND VPWR VPWR sky130_fd_sc_hd__decap_3
XFILLER_74_136 VGND VGND VPWR VPWR sky130_fd_sc_hd__decap_4
XFILLER_28_531 VGND VGND VPWR VPWR sky130_fd_sc_hd__fill_1
XFILLER_90_607 VPWR VGND VPWR VGND sky130_ef_sc_hd__decap_12
XFILLER_83_670 VGND VGND VPWR VPWR sky130_fd_sc_hd__fill_2
X_09709_ _02646_ cpuregs\[5\]\[15\] _04872_ VGND VGND VPWR VPWR _01365_ sky130_fd_sc_hd__mux2_1
X_10981_ clknet_leaf_8_clk _01043_ VGND VGND VPWR VPWR cpuregs\[18\]\[13\] sky130_fd_sc_hd__dfxtp_1
XFILLER_56_895 VGND VGND VPWR VPWR sky130_fd_sc_hd__fill_1
XFILLER_15_225 VGND VGND VPWR VPWR sky130_fd_sc_hd__decap_4
XFILLER_28_586 VGND VGND VPWR VPWR sky130_fd_sc_hd__fill_2
XFILLER_130_41 VPWR VGND VPWR VGND sky130_ef_sc_hd__decap_12
XFILLER_70_331 VGND VGND VPWR VPWR sky130_fd_sc_hd__fill_2
XTAP_TAPCELL_ROW_26_743 VGND VPWR sky130_fd_sc_hd__tapvpwrvgnd_1
XTAP_TAPCELL_ROW_26_754 VGND VPWR sky130_fd_sc_hd__tapvpwrvgnd_1
XFILLER_30_206 VGND VGND VPWR VPWR sky130_fd_sc_hd__decap_8
XPHY_EDGE_ROW_122_Left_276 VGND VGND VPWR VPWR sky130_fd_sc_hd__decap_3
XFILLER_137_650 VGND VGND VPWR VPWR sky130_fd_sc_hd__decap_6
XFILLER_109_341 VGND VGND VPWR VPWR sky130_fd_sc_hd__fill_1
XFILLER_99_21 VPWR VGND VPWR VGND sky130_ef_sc_hd__decap_12
X_11464_ clknet_leaf_30_clk _01508_ VGND VGND VPWR VPWR cpuregs\[0\]\[30\] sky130_fd_sc_hd__dfxtp_1
X_10415_ clknet_leaf_33_clk _00545_ VGND VGND VPWR VPWR cpuregs\[20\]\[29\] sky130_fd_sc_hd__dfxtp_1
XFILLER_7_479 VGND VGND VPWR VPWR sky130_fd_sc_hd__decap_6
X_11395_ clknet_leaf_47_clk _01439_ VGND VGND VPWR VPWR cpuregs\[7\]\[25\] sky130_fd_sc_hd__dfxtp_1
XFILLER_137_694 VGND VGND VPWR VPWR sky130_fd_sc_hd__decap_3
XFILLER_136_171 VPWR VGND VPWR VGND sky130_ef_sc_hd__decap_12
XTAP_TAPCELL_ROW_55_1206 VGND VPWR sky130_fd_sc_hd__tapvpwrvgnd_1
X_10346_ clknet_leaf_70_clk _00476_ VGND VGND VPWR VPWR cpuregs\[16\]\[24\] sky130_fd_sc_hd__dfxtp_1
XFILLER_125_889 VGND VGND VPWR VPWR sky130_fd_sc_hd__decap_6
XTAP_TAPCELL_ROW_55_1217 VGND VPWR sky130_fd_sc_hd__tapvpwrvgnd_1
XFILLER_3_641 VPWR VGND VPWR VGND sky130_ef_sc_hd__decap_12
XFILLER_140_837 VPWR VGND VPWR VGND sky130_ef_sc_hd__decap_12
X_10277_ clknet_leaf_70_clk _00407_ VGND VGND VPWR VPWR cpuregs\[15\]\[19\] sky130_fd_sc_hd__dfxtp_1
XFILLER_124_399 VGND VGND VPWR VPWR sky130_fd_sc_hd__decap_3
XFILLER_3_685 VPWR VGND VPWR VGND sky130_ef_sc_hd__decap_12
XFILLER_2_195 VGND VGND VPWR VPWR sky130_fd_sc_hd__fill_1
XPHY_EDGE_ROW_131_Left_285 VGND VGND VPWR VPWR sky130_fd_sc_hd__decap_3
XFILLER_65_158 VGND VGND VPWR VPWR sky130_fd_sc_hd__decap_8
XFILLER_47_895 VGND VGND VPWR VPWR sky130_fd_sc_hd__fill_1
XFILLER_34_523 VGND VGND VPWR VPWR sky130_fd_sc_hd__decap_8
XFILLER_46_383 VGND VGND VPWR VPWR sky130_fd_sc_hd__fill_1
XFILLER_61_353 VPWR VGND VPWR VGND sky130_ef_sc_hd__decap_12
XFILLER_34_545 VPWR VGND VPWR VGND sky130_ef_sc_hd__decap_12
XTAP_TAPCELL_ROW_83_1660 VGND VPWR sky130_fd_sc_hd__tapvpwrvgnd_1
XFILLER_34_589 VGND VGND VPWR VPWR sky130_fd_sc_hd__decap_6
XPHY_EDGE_ROW_140_Left_294 VGND VGND VPWR VPWR sky130_fd_sc_hd__decap_3
X_06370_ _01640_ _02803_ _02804_ VGND VGND VPWR VPWR _02805_ sky130_fd_sc_hd__o21ai_1
X_05321_ count_instr\[52\] instr_rdinstrh instr_rdinstr count_instr\[20\] VGND VGND
+ VPWR VPWR _01916_ sky130_fd_sc_hd__a22o_1
X_05252_ reg_pc\[15\] decoded_imm\[15\] VGND VGND VPWR VPWR _01852_ sky130_fd_sc_hd__nand2_1
X_08040_ _03843_ _03850_ _03858_ VGND VGND VPWR VPWR _03859_ sky130_fd_sc_hd__a21oi_1
XFILLER_128_683 VPWR VGND VPWR VGND sky130_ef_sc_hd__decap_12
XFILLER_128_661 VGND VGND VPWR VPWR sky130_fd_sc_hd__fill_1
X_05183_ cpu_state\[4\] net202 _01785_ _01788_ VGND VGND VPWR VPWR _01789_ sky130_fd_sc_hd__a211o_1
XFILLER_6_490 VGND VGND VPWR VPWR sky130_fd_sc_hd__fill_1
X_09991_ clknet_leaf_80_clk _00121_ VGND VGND VPWR VPWR cpuregs\[12\]\[21\] sky130_fd_sc_hd__dfxtp_1
XFILLER_89_729 VGND VGND VPWR VPWR sky130_fd_sc_hd__decap_3
XFILLER_88_206 VGND VGND VPWR VPWR sky130_fd_sc_hd__decap_6
X_08942_ _01558_ _04618_ VGND VGND VPWR VPWR _04619_ sky130_fd_sc_hd__or2_1
XFILLER_103_528 VGND VGND VPWR VPWR sky130_fd_sc_hd__decap_8
XTAP_TAPCELL_ROW_110_2089 VGND VPWR sky130_fd_sc_hd__tapvpwrvgnd_1
X_08873_ _04544_ _04552_ _04553_ _01560_ _00010_ VGND VGND VPWR VPWR _04554_ sky130_fd_sc_hd__a221o_1
XFILLER_111_561 VGND VGND VPWR VPWR sky130_fd_sc_hd__fill_1
XFILLER_57_615 VGND VGND VPWR VPWR sky130_fd_sc_hd__fill_1
X_07824_ _02587_ reg_next_pc\[1\] _02482_ VGND VGND VPWR VPWR _03687_ sky130_fd_sc_hd__mux2_1
X_04967_ instr_sll instr_sub instr_add instr_andi VGND VGND VPWR VPWR _01597_ sky130_fd_sc_hd__or4_1
X_07755_ _03639_ count_instr\[37\] count_instr\[36\] count_instr\[38\] VGND VGND VPWR
+ VPWR _03644_ sky130_fd_sc_hd__and4_1
X_06706_ net236 _03129_ VGND VGND VPWR VPWR _03130_ sky130_fd_sc_hd__nand2_1
X_07686_ _03595_ count_instr\[12\] count_instr\[11\] count_instr\[13\] VGND VGND VPWR
+ VPWR _03600_ sky130_fd_sc_hd__and4_1
XFILLER_71_128 VGND VGND VPWR VPWR sky130_fd_sc_hd__decap_6
XFILLER_37_361 VGND VGND VPWR VPWR sky130_fd_sc_hd__decap_4
X_09425_ _02704_ cpuregs\[18\]\[29\] _04862_ VGND VGND VPWR VPWR _01059_ sky130_fd_sc_hd__mux2_1
X_06637_ net178 net254 VGND VGND VPWR VPWR _03063_ sky130_fd_sc_hd__or2_1
XFILLER_52_342 VGND VGND VPWR VPWR sky130_fd_sc_hd__decap_3
XFILLER_13_707 VGND VGND VPWR VPWR sky130_fd_sc_hd__fill_1
XFILLER_44_27 VGND VGND VPWR VPWR sky130_fd_sc_hd__fill_1
XFILLER_13_729 VGND VGND VPWR VPWR sky130_fd_sc_hd__fill_2
XTAP_TAPCELL_ROW_23_702 VGND VPWR sky130_fd_sc_hd__tapvpwrvgnd_1
XFILLER_25_589 VPWR VGND VPWR VGND sky130_ef_sc_hd__decap_12
X_09356_ instr_jal decoded_imm_j\[17\] _01589_ mem_rdata_q\[17\] VGND VGND VPWR VPWR
+ _04840_ sky130_fd_sc_hd__a22o_1
XFILLER_12_228 VGND VGND VPWR VPWR sky130_fd_sc_hd__fill_1
X_06568_ _02991_ _02992_ _02995_ _02996_ _01579_ _01581_ VGND VGND VPWR VPWR _02997_
+ sky130_fd_sc_hd__mux4_1
X_05519_ _02100_ _02101_ VGND VGND VPWR VPWR _02102_ sky130_fd_sc_hd__nor2_1
X_09287_ net143 net105 _04206_ VGND VGND VPWR VPWR _00973_ sky130_fd_sc_hd__mux2_1
X_08307_ count_cycle\[18\] _04083_ _04087_ VGND VGND VPWR VPWR _04090_ sky130_fd_sc_hd__and3_1
X_06499_ net173 _02720_ _02744_ _02869_ VGND VGND VPWR VPWR _02930_ sky130_fd_sc_hd__o211a_1
X_08238_ _03719_ _04029_ VGND VGND VPWR VPWR _04041_ sky130_fd_sc_hd__nor2_1
XFILLER_153_406 VGND VGND VPWR VPWR sky130_fd_sc_hd__decap_3
X_08169_ _03710_ _03711_ _03959_ VGND VGND VPWR VPWR _03978_ sky130_fd_sc_hd__and3_1
XFILLER_107_845 VGND VGND VPWR VPWR sky130_fd_sc_hd__decap_8
X_10200_ clknet_leaf_0_clk _00330_ VGND VGND VPWR VPWR cpuregs\[14\]\[6\] sky130_fd_sc_hd__dfxtp_1
XFILLER_133_141 VGND VGND VPWR VPWR sky130_fd_sc_hd__decap_8
XFILLER_109_86 VGND VGND VPWR VPWR sky130_fd_sc_hd__decap_4
XFILLER_107_878 VPWR VGND VPWR VGND sky130_ef_sc_hd__decap_12
XFILLER_69_57 VGND VGND VPWR VPWR sky130_fd_sc_hd__decap_6
XFILLER_69_35 VGND VGND VPWR VPWR sky130_fd_sc_hd__decap_4
X_11180_ clknet_leaf_141_clk _01227_ VGND VGND VPWR VPWR cpuregs\[29\]\[5\] sky130_fd_sc_hd__dfxtp_1
XFILLER_122_837 VPWR VGND VPWR VGND sky130_ef_sc_hd__decap_12
XFILLER_121_325 VGND VGND VPWR VPWR sky130_fd_sc_hd__decap_8
X_10131_ clknet_leaf_116_clk _00261_ VGND VGND VPWR VPWR cpuregs\[21\]\[1\] sky130_fd_sc_hd__dfxtp_1
X_10062_ clknet_leaf_41_clk _00192_ VGND VGND VPWR VPWR cpuregs\[13\]\[28\] sky130_fd_sc_hd__dfxtp_1
XFILLER_130_881 VPWR VGND VPWR VGND sky130_ef_sc_hd__decap_12
XFILLER_102_561 VGND VGND VPWR VPWR sky130_fd_sc_hd__fill_2
XFILLER_85_23 VPWR VGND VPWR VGND sky130_ef_sc_hd__decap_12
XFILLER_75_401 VPWR VGND VPWR VGND sky130_ef_sc_hd__decap_12
XTAP_TAPCELL_ROW_50_1136 VGND VPWR sky130_fd_sc_hd__tapvpwrvgnd_1
XTAP_TAPCELL_ROW_50_1125 VGND VPWR sky130_fd_sc_hd__tapvpwrvgnd_1
XTAP_TAPCELL_ROW_145_2653 VGND VPWR sky130_fd_sc_hd__tapvpwrvgnd_1
XFILLER_47_169 VPWR VGND VPWR VGND sky130_ef_sc_hd__decap_12
XFILLER_141_51 VGND VGND VPWR VPWR sky130_fd_sc_hd__decap_4
XFILLER_90_448 VGND VGND VPWR VPWR sky130_fd_sc_hd__decap_8
XFILLER_62_139 VGND VGND VPWR VPWR sky130_fd_sc_hd__fill_1
XFILLER_62_106 VGND VGND VPWR VPWR sky130_fd_sc_hd__decap_4
XFILLER_18_83 VGND VGND VPWR VPWR sky130_fd_sc_hd__fill_1
XFILLER_29_895 VGND VGND VPWR VPWR sky130_fd_sc_hd__fill_1
XFILLER_44_843 VGND VGND VPWR VPWR sky130_fd_sc_hd__decap_6
X_10964_ clknet_leaf_128_clk _01026_ VGND VGND VPWR VPWR decoded_imm\[4\] sky130_fd_sc_hd__dfxtp_1
XFILLER_44_865 VGND VGND VPWR VPWR sky130_fd_sc_hd__decap_3
XFILLER_71_673 VPWR VGND VPWR VGND sky130_ef_sc_hd__decap_12
X_10895_ clknet_leaf_5_clk _00957_ VGND VGND VPWR VPWR net146 sky130_fd_sc_hd__dfxtp_1
XTAP_TAPCELL_ROW_48_1098 VGND VPWR sky130_fd_sc_hd__tapvpwrvgnd_1
XFILLER_16_589 VGND VGND VPWR VPWR sky130_fd_sc_hd__decap_8
XFILLER_31_515 VGND VGND VPWR VPWR sky130_fd_sc_hd__fill_2
XFILLER_31_526 VGND VGND VPWR VPWR sky130_fd_sc_hd__decap_8
XFILLER_43_386 VGND VGND VPWR VPWR sky130_fd_sc_hd__decap_6
XFILLER_31_559 VGND VGND VPWR VPWR sky130_fd_sc_hd__fill_1
XFILLER_8_722 VGND VGND VPWR VPWR sky130_fd_sc_hd__decap_6
XFILLER_8_744 VGND VGND VPWR VPWR sky130_fd_sc_hd__decap_3
X_11447_ clknet_leaf_28_clk _01491_ VGND VGND VPWR VPWR cpuregs\[0\]\[13\] sky130_fd_sc_hd__dfxtp_1
XFILLER_152_450 VGND VGND VPWR VPWR sky130_fd_sc_hd__decap_6
XFILLER_140_601 VGND VGND VPWR VPWR sky130_fd_sc_hd__decap_8
XFILLER_124_141 VGND VGND VPWR VPWR sky130_fd_sc_hd__decap_8
X_11378_ clknet_leaf_146_clk _01422_ VGND VGND VPWR VPWR cpuregs\[7\]\[8\] sky130_fd_sc_hd__dfxtp_1
X_10329_ clknet_leaf_145_clk _00459_ VGND VGND VPWR VPWR cpuregs\[16\]\[7\] sky130_fd_sc_hd__dfxtp_1
XFILLER_140_645 VGND VGND VPWR VPWR sky130_fd_sc_hd__fill_2
XFILLER_79_762 VPWR VGND VPWR VGND sky130_ef_sc_hd__decap_12
XFILLER_66_401 VGND VGND VPWR VPWR sky130_fd_sc_hd__fill_2
X_05870_ _02052_ _02427_ VGND VGND VPWR VPWR _02428_ sky130_fd_sc_hd__xnor2_1
XFILLER_15_3 VPWR VGND VPWR VGND sky130_ef_sc_hd__decap_12
XFILLER_93_242 VGND VGND VPWR VPWR sky130_fd_sc_hd__decap_6
XTAP_TAPCELL_ROW_68_1419 VGND VPWR sky130_fd_sc_hd__tapvpwrvgnd_1
X_07540_ _02683_ cpuregs\[16\]\[24\] _03570_ VGND VGND VPWR VPWR _00476_ sky130_fd_sc_hd__mux2_1
XFILLER_93_275 VGND VGND VPWR VPWR sky130_fd_sc_hd__decap_4
XFILLER_35_821 VPWR VGND VPWR VGND sky130_ef_sc_hd__decap_12
XFILLER_46_191 VGND VGND VPWR VPWR sky130_fd_sc_hd__decap_4
X_07471_ cpuregs\[15\]\[22\] _02675_ net246 VGND VGND VPWR VPWR _00410_ sky130_fd_sc_hd__mux2_1
XFILLER_50_813 VGND VGND VPWR VPWR sky130_fd_sc_hd__decap_4
XFILLER_148_701 VGND VGND VPWR VPWR sky130_fd_sc_hd__decap_3
X_09210_ _01100_ _04794_ _02513_ VGND VGND VPWR VPWR _04795_ sky130_fd_sc_hd__and3b_1
XFILLER_50_846 VPWR VGND VPWR VGND sky130_ef_sc_hd__decap_12
X_06422_ cpuregs\[4\]\[4\] cpuregs\[5\]\[4\] net264 VGND VGND VPWR VPWR _02856_ sky130_fd_sc_hd__mux2_1
XFILLER_34_397 VGND VGND VPWR VPWR sky130_fd_sc_hd__fill_2
X_09141_ is_alu_reg_imm _04755_ _04767_ _04769_ VGND VGND VPWR VPWR _04771_ sky130_fd_sc_hd__and4_1
X_06353_ _02787_ _02788_ _01579_ VGND VGND VPWR VPWR _02789_ sky130_fd_sc_hd__mux2_1
X_05304_ _01886_ _01889_ _01887_ VGND VGND VPWR VPWR _01900_ sky130_fd_sc_hd__o21ai_1
X_09072_ instr_lb _01630_ _04737_ latched_is_lb VGND VGND VPWR VPWR _00843_ sky130_fd_sc_hd__a22o_1
X_08023_ decoded_imm_j\[13\] _03700_ VGND VGND VPWR VPWR _03843_ sky130_fd_sc_hd__nand2_1
X_06284_ instr_sll instr_slli _01554_ _02721_ _02718_ VGND VGND VPWR VPWR _02722_
+ sky130_fd_sc_hd__o41a_1
XFILLER_30_29 VPWR VGND VPWR VGND sky130_ef_sc_hd__decap_12
XFILLER_146_29 VPWR VGND VPWR VGND sky130_ef_sc_hd__decap_12
XTAP_TAPCELL_ROW_112_2118 VGND VPWR sky130_fd_sc_hd__tapvpwrvgnd_1
XTAP_TAPCELL_ROW_96_1862 VGND VPWR sky130_fd_sc_hd__tapvpwrvgnd_1
X_05235_ count_instr\[13\] instr_rdinstr count_cycle\[45\] instr_rdcycleh VGND VGND
+ VPWR VPWR _01837_ sky130_fd_sc_hd__a22o_1
XFILLER_116_664 VGND VGND VPWR VPWR sky130_fd_sc_hd__fill_2
XFILLER_116_642 VGND VGND VPWR VPWR sky130_fd_sc_hd__fill_2
XTAP_TAPCELL_ROW_112_2129 VGND VPWR sky130_fd_sc_hd__tapvpwrvgnd_1
XTAP_TAPCELL_ROW_96_1873 VGND VPWR sky130_fd_sc_hd__tapvpwrvgnd_1
X_05166_ net31 _01666_ _01667_ net17 _01772_ VGND VGND VPWR VPWR _01773_ sky130_fd_sc_hd__o221a_1
XFILLER_143_461 VGND VGND VPWR VPWR sky130_fd_sc_hd__decap_4
XFILLER_131_612 VGND VGND VPWR VPWR sky130_fd_sc_hd__decap_4
XFILLER_116_697 VGND VGND VPWR VPWR sky130_fd_sc_hd__decap_3
XFILLER_116_686 VGND VGND VPWR VPWR sky130_fd_sc_hd__fill_2
XFILLER_131_645 VGND VGND VPWR VPWR sky130_fd_sc_hd__decap_8
XFILLER_89_559 VGND VGND VPWR VPWR sky130_fd_sc_hd__fill_1
X_05097_ net171 mem_wordsize\[1\] _01708_ VGND VGND VPWR VPWR _01709_ sky130_fd_sc_hd__and3_1
XFILLER_39_27 VPWR VGND VPWR VGND sky130_ef_sc_hd__decap_12
X_09974_ clknet_leaf_134_clk _00104_ VGND VGND VPWR VPWR cpuregs\[12\]\[4\] sky130_fd_sc_hd__dfxtp_1
X_08925_ net270 _04602_ _01560_ VGND VGND VPWR VPWR _04603_ sky130_fd_sc_hd__o21a_1
XFILLER_131_689 VGND VGND VPWR VPWR sky130_fd_sc_hd__decap_6
XFILLER_85_710 VPWR VGND VPWR VGND sky130_ef_sc_hd__decap_12
X_08856_ net270 _04533_ _04532_ _01560_ VGND VGND VPWR VPWR _04538_ sky130_fd_sc_hd__o211a_1
XFILLER_97_592 VGND VGND VPWR VPWR sky130_fd_sc_hd__fill_1
XFILLER_57_434 VGND VGND VPWR VPWR sky130_fd_sc_hd__fill_1
XTAP_TAPCELL_ROW_127_2361 VGND VPWR sky130_fd_sc_hd__tapvpwrvgnd_1
X_07807_ count_instr\[57\] _03674_ _03676_ VGND VGND VPWR VPWR _00638_ sky130_fd_sc_hd__o21a_1
XFILLER_84_253 VGND VGND VPWR VPWR sky130_fd_sc_hd__fill_1
X_05999_ reg_out\[22\] reg_next_pc\[22\] net596 VGND VGND VPWR VPWR _02503_ sky130_fd_sc_hd__mux2_1
X_08787_ net269 _04471_ _01559_ VGND VGND VPWR VPWR _04473_ sky130_fd_sc_hd__a21o_1
XFILLER_84_275 VGND VGND VPWR VPWR sky130_fd_sc_hd__fill_1
XFILLER_72_415 VGND VGND VPWR VPWR sky130_fd_sc_hd__decap_4
XFILLER_57_489 VGND VGND VPWR VPWR sky130_fd_sc_hd__decap_6
XFILLER_38_681 VGND VGND VPWR VPWR sky130_fd_sc_hd__decap_8
X_07738_ _03633_ net34 _03632_ VGND VGND VPWR VPWR _00612_ sky130_fd_sc_hd__and3b_1
XFILLER_37_180 VGND VGND VPWR VPWR sky130_fd_sc_hd__decap_4
XTAP_TAPCELL_ROW_140_2572 VGND VPWR sky130_fd_sc_hd__tapvpwrvgnd_1
X_07669_ _03589_ net34 _03588_ VGND VGND VPWR VPWR _00587_ sky130_fd_sc_hd__and3b_1
XFILLER_25_364 VGND VGND VPWR VPWR sky130_fd_sc_hd__decap_8
XFILLER_41_835 VGND VGND VPWR VPWR sky130_fd_sc_hd__decap_4
XFILLER_111_87 VGND VGND VPWR VPWR sky130_fd_sc_hd__fill_1
XFILLER_71_47 VGND VGND VPWR VPWR sky130_fd_sc_hd__decap_8
X_09408_ _02633_ cpuregs\[18\]\[12\] _04862_ VGND VGND VPWR VPWR _01042_ sky130_fd_sc_hd__mux2_1
X_10680_ clknet_leaf_123_clk _00778_ VGND VGND VPWR VPWR net63 sky130_fd_sc_hd__dfxtp_1
X_09339_ decoded_imm\[26\] _04746_ _04825_ _04831_ VGND VGND VPWR VPWR _01004_ sky130_fd_sc_hd__o22a_1
XPHY_EDGE_ROW_109_Right_109 VGND VGND VPWR VPWR sky130_fd_sc_hd__decap_3
XFILLER_126_417 VGND VGND VPWR VPWR sky130_fd_sc_hd__decap_3
XFILLER_153_225 VPWR VGND VPWR VGND sky130_ef_sc_hd__decap_12
X_11301_ clknet_leaf_27_clk _01348_ VGND VGND VPWR VPWR cpuregs\[4\]\[30\] sky130_fd_sc_hd__dfxtp_1
X_11232_ clknet_leaf_47_clk _01279_ VGND VGND VPWR VPWR cpuregs\[3\]\[25\] sky130_fd_sc_hd__dfxtp_1
XFILLER_106_141 VGND VGND VPWR VPWR sky130_fd_sc_hd__fill_1
X_11163_ clknet_leaf_75_clk _01210_ VGND VGND VPWR VPWR cpuregs\[23\]\[20\] sky130_fd_sc_hd__dfxtp_1
XFILLER_134_472 VGND VGND VPWR VPWR sky130_fd_sc_hd__decap_4
X_10114_ clknet_leaf_18_clk _00244_ VGND VGND VPWR VPWR cpuregs\[28\]\[16\] sky130_fd_sc_hd__dfxtp_1
X_11094_ clknet_leaf_66_clk _01151_ VGND VGND VPWR VPWR cpuregs\[24\]\[25\] sky130_fd_sc_hd__dfxtp_1
XFILLER_103_881 VPWR VGND VPWR VGND sky130_ef_sc_hd__decap_12
XFILLER_96_88 VGND VGND VPWR VPWR sky130_fd_sc_hd__decap_8
X_10045_ clknet_leaf_147_clk _00175_ VGND VGND VPWR VPWR cpuregs\[13\]\[11\] sky130_fd_sc_hd__dfxtp_1
XFILLER_152_83 VGND VGND VPWR VPWR sky130_fd_sc_hd__fill_1
XFILLER_90_201 VGND VGND VPWR VPWR sky130_fd_sc_hd__fill_1
XFILLER_17_821 VPWR VGND VPWR VGND sky130_ef_sc_hd__decap_12
XFILLER_17_865 VPWR VGND VPWR VGND sky130_ef_sc_hd__decap_12
X_10947_ clknet_leaf_93_clk _01009_ VGND VGND VPWR VPWR decoded_imm\[21\] sky130_fd_sc_hd__dfxtp_1
XFILLER_32_813 VPWR VGND VPWR VGND sky130_ef_sc_hd__decap_12
XTAP_TAPCELL_ROW_63_1338 VGND VPWR sky130_fd_sc_hd__tapvpwrvgnd_1
X_10878_ clknet_leaf_46_clk _00940_ VGND VGND VPWR VPWR cpuregs\[1\]\[22\] sky130_fd_sc_hd__dfxtp_1
XTAP_TAPCELL_ROW_14_554 VGND VPWR sky130_fd_sc_hd__tapvpwrvgnd_1
XFILLER_129_233 VGND VGND VPWR VPWR sky130_fd_sc_hd__fill_1
Xclkbuf_4_14_0_clk clknet_0_clk VGND VGND VPWR VPWR clknet_4_14_0_clk sky130_fd_sc_hd__clkbuf_8
XFILLER_145_715 VGND VGND VPWR VPWR sky130_fd_sc_hd__decap_4
XFILLER_129_277 VGND VGND VPWR VPWR sky130_fd_sc_hd__decap_3
XFILLER_129_255 VGND VGND VPWR VPWR sky130_fd_sc_hd__decap_6
XFILLER_61_91 VPWR VGND VPWR VGND sky130_ef_sc_hd__decap_12
XANTENNA_2 _01578_ VGND VGND VPWR VPWR sky130_fd_sc_hd__diode_2
XTAP_TAPCELL_ROW_78_1581 VGND VPWR sky130_fd_sc_hd__tapvpwrvgnd_1
XFILLER_6_53 VPWR VGND VPWR VGND sky130_ef_sc_hd__decap_12
X_05020_ _01637_ _01642_ VGND VGND VPWR VPWR _01643_ sky130_fd_sc_hd__nor2_1
XFILLER_125_461 VGND VGND VPWR VPWR sky130_fd_sc_hd__decap_6
XFILLER_113_612 VGND VGND VPWR VPWR sky130_fd_sc_hd__decap_4
XFILLER_112_100 VGND VGND VPWR VPWR sky130_fd_sc_hd__fill_1
XFILLER_6_97 VPWR VGND VPWR VGND sky130_ef_sc_hd__decap_12
X_06971_ cpuregs\[24\]\[24\] cpuregs\[25\]\[24\] cpuregs\[26\]\[24\] cpuregs\[27\]\[24\]
+ net267 net261 VGND VGND VPWR VPWR _03385_ sky130_fd_sc_hd__mux4_1
XFILLER_101_829 VGND VGND VPWR VPWR sky130_fd_sc_hd__fill_1
XTAP_TAPCELL_ROW_91_1792 VGND VPWR sky130_fd_sc_hd__tapvpwrvgnd_1
XTAP_TAPCELL_ROW_91_1781 VGND VPWR sky130_fd_sc_hd__tapvpwrvgnd_1
X_09690_ cpuregs\[4\]\[29\] _02704_ net238 VGND VGND VPWR VPWR _01347_ sky130_fd_sc_hd__mux2_1
X_05922_ _02067_ _02240_ _02471_ _02473_ VGND VGND VPWR VPWR alu_out\[31\] sky130_fd_sc_hd__a211o_1
X_08710_ _04389_ _04390_ _01558_ VGND VGND VPWR VPWR _04400_ sky130_fd_sc_hd__mux2_1
X_05853_ net255 _02409_ _02410_ _02412_ VGND VGND VPWR VPWR alu_out\[23\] sky130_fd_sc_hd__a31o_1
X_08641_ net233 _01585_ _04333_ _04334_ VGND VGND VPWR VPWR _00814_ sky130_fd_sc_hd__o22a_1
XTAP_TAPCELL_ROW_109_2080 VGND VPWR sky130_fd_sc_hd__tapvpwrvgnd_1
XFILLER_81_212 VPWR VGND VPWR VGND sky130_ef_sc_hd__decap_12
Xrebuffer25 _04078_ VGND VGND VPWR VPWR net411 sky130_fd_sc_hd__dlygate4sd1_1
Xrebuffer36 net423 VGND VGND VPWR VPWR net422 sky130_fd_sc_hd__dlygate4sd1_1
Xrebuffer14 _03585_ VGND VGND VPWR VPWR net400 sky130_fd_sc_hd__dlygate4sd1_1
X_05784_ _02113_ _02349_ _02350_ net255 VGND VGND VPWR VPWR _02351_ sky130_fd_sc_hd__o211a_1
XFILLER_82_757 VGND VGND VPWR VPWR sky130_fd_sc_hd__decap_6
XFILLER_81_234 VGND VGND VPWR VPWR sky130_fd_sc_hd__fill_2
Xrebuffer47 net434 VGND VGND VPWR VPWR net433 sky130_fd_sc_hd__dlygate4sd1_1
X_08572_ cpuregs\[12\]\[5\] cpuregs\[13\]\[5\] cpuregs\[14\]\[5\] cpuregs\[15\]\[5\]
+ net278 net273 VGND VGND VPWR VPWR _04269_ sky130_fd_sc_hd__mux4_1
XFILLER_26_139 VGND VGND VPWR VPWR sky130_fd_sc_hd__fill_1
Xrebuffer69 net456 VGND VGND VPWR VPWR net455 sky130_fd_sc_hd__buf_2
Xrebuffer58 cpu_state\[1\] VGND VGND VPWR VPWR net444 sky130_fd_sc_hd__dlygate4sd1_1
X_07523_ _02612_ cpuregs\[16\]\[7\] _03570_ VGND VGND VPWR VPWR _00459_ sky130_fd_sc_hd__mux2_1
XTAP_TAPCELL_ROW_122_2291 VGND VPWR sky130_fd_sc_hd__tapvpwrvgnd_1
XTAP_TAPCELL_ROW_122_2280 VGND VPWR sky130_fd_sc_hd__tapvpwrvgnd_1
XFILLER_50_643 VGND VGND VPWR VPWR sky130_fd_sc_hd__fill_1
X_07454_ cpuregs\[15\]\[5\] _02603_ net246 VGND VGND VPWR VPWR _00393_ sky130_fd_sc_hd__mux2_1
X_06405_ cpuregs\[20\]\[4\] cpuregs\[21\]\[4\] cpuregs\[22\]\[4\] cpuregs\[23\]\[4\]
+ net264 net262 VGND VGND VPWR VPWR _02839_ sky130_fd_sc_hd__mux4_1
XTAP_TAPCELL_ROW_33_852 VGND VPWR sky130_fd_sc_hd__tapvpwrvgnd_1
XTAP_TAPCELL_ROW_33_863 VGND VPWR sky130_fd_sc_hd__tapvpwrvgnd_1
XFILLER_148_542 VGND VGND VPWR VPWR sky130_fd_sc_hd__decap_4
XFILLER_148_531 VGND VGND VPWR VPWR sky130_fd_sc_hd__fill_1
XTAP_TAPCELL_ROW_98_1902 VGND VPWR sky130_fd_sc_hd__tapvpwrvgnd_1
X_07385_ cpuregs\[14\]\[3\] _02593_ net247 VGND VGND VPWR VPWR _00327_ sky130_fd_sc_hd__mux2_1
X_09124_ instr_lhu _04747_ _04755_ _04764_ VGND VGND VPWR VPWR _00858_ sky130_fd_sc_hd__a22o_1
X_06336_ cpuregs\[30\]\[2\] cpuregs\[31\]\[2\] net268 VGND VGND VPWR VPWR _02772_
+ sky130_fd_sc_hd__mux2_1
XFILLER_135_225 VGND VGND VPWR VPWR sky130_fd_sc_hd__fill_1
XFILLER_108_439 VPWR VGND VPWR VGND sky130_ef_sc_hd__decap_12
X_06267_ reg_pc\[30\] _02702_ VGND VGND VPWR VPWR _02707_ sky130_fd_sc_hd__nand2_1
X_09055_ _01558_ _04716_ _04718_ net269 VGND VGND VPWR VPWR _04726_ sky130_fd_sc_hd__o211a_1
X_05218_ _01815_ _01819_ _01813_ VGND VGND VPWR VPWR _01821_ sky130_fd_sc_hd__a21oi_1
X_08006_ _03576_ _03827_ VGND VGND VPWR VPWR _03828_ sky130_fd_sc_hd__nor2_1
XFILLER_151_729 VPWR VGND VPWR VGND sky130_ef_sc_hd__decap_12
XFILLER_144_781 VPWR VGND VPWR VGND sky130_ef_sc_hd__decap_12
Xmax_cap260 net261 VGND VGND VPWR VPWR net260 sky130_fd_sc_hd__buf_12
XFILLER_104_623 VGND VGND VPWR VPWR sky130_fd_sc_hd__decap_8
X_06198_ reg_pc\[16\] _02644_ reg_pc\[17\] VGND VGND VPWR VPWR _02651_ sky130_fd_sc_hd__a21oi_1
Xmax_cap271 net272 VGND VGND VPWR VPWR net271 sky130_fd_sc_hd__buf_12
XFILLER_1_205 VPWR VGND VPWR VGND sky130_ef_sc_hd__decap_12
X_05149_ _01741_ _01745_ _01754_ _01755_ VGND VGND VPWR VPWR _01757_ sky130_fd_sc_hd__a211o_1
XFILLER_1_249 VPWR VGND VPWR VGND sky130_ef_sc_hd__decap_12
XTAP_TAPCELL_ROW_129_2401 VGND VPWR sky130_fd_sc_hd__tapvpwrvgnd_1
X_09957_ clknet_4_12_0_clk _00087_ VGND VGND VPWR VPWR net180 sky130_fd_sc_hd__dfxtp_4
X_08908_ _04577_ _04585_ _04586_ _01560_ _00010_ VGND VGND VPWR VPWR _04587_ sky130_fd_sc_hd__a221o_1
XFILLER_106_65 VGND VGND VPWR VPWR sky130_fd_sc_hd__decap_3
XTAP_TAPCELL_ROW_142_2601 VGND VPWR sky130_fd_sc_hd__tapvpwrvgnd_1
X_09888_ cpuregs\[0\]\[18\] VGND VGND VPWR VPWR _01496_ sky130_fd_sc_hd__clkbuf_1
XFILLER_57_231 VGND VGND VPWR VPWR sky130_fd_sc_hd__fill_1
X_08839_ net269 _04518_ _04521_ _04266_ VGND VGND VPWR VPWR _04522_ sky130_fd_sc_hd__o211a_1
XFILLER_73_713 VGND VGND VPWR VPWR sky130_fd_sc_hd__decap_8
XFILLER_57_264 VGND VGND VPWR VPWR sky130_fd_sc_hd__fill_2
XFILLER_122_97 VGND VGND VPWR VPWR sky130_fd_sc_hd__fill_2
XFILLER_72_278 VPWR VGND VPWR VGND sky130_ef_sc_hd__decap_12
X_10801_ clknet_leaf_98_clk _00866_ VGND VGND VPWR VPWR instr_andi sky130_fd_sc_hd__dfxtp_1
XFILLER_14_802 VGND VGND VPWR VPWR sky130_fd_sc_hd__decap_8
XFILLER_14_813 VPWR VGND VPWR VGND sky130_ef_sc_hd__decap_12
XFILLER_26_651 VGND VGND VPWR VPWR sky130_fd_sc_hd__fill_1
X_10732_ clknet_leaf_50_clk _00829_ VGND VGND VPWR VPWR net218 sky130_fd_sc_hd__dfxtp_4
XTAP_TAPCELL_ROW_45_1046 VGND VPWR sky130_fd_sc_hd__tapvpwrvgnd_1
XFILLER_15_51 VGND VGND VPWR VPWR sky130_fd_sc_hd__decap_4
XFILLER_40_153 VPWR VGND VPWR VGND sky130_ef_sc_hd__decap_12
XTAP_TAPCELL_ROW_45_1057 VGND VPWR sky130_fd_sc_hd__tapvpwrvgnd_1
X_10663_ clknet_leaf_91_clk _04891_ VGND VGND VPWR VPWR reg_out\[21\] sky130_fd_sc_hd__dfxtp_1
XTAP_TAPCELL_ROW_11_513 VGND VPWR sky130_fd_sc_hd__tapvpwrvgnd_1
XTAP_TAPCELL_ROW_11_502 VGND VPWR sky130_fd_sc_hd__tapvpwrvgnd_1
XFILLER_127_726 VGND VGND VPWR VPWR sky130_fd_sc_hd__fill_2
X_10594_ clknet_leaf_87_clk _00724_ VGND VGND VPWR VPWR count_cycle\[17\] sky130_fd_sc_hd__dfxtp_1
XTAP_TAPCELL_ROW_153_2774 VGND VPWR sky130_fd_sc_hd__tapvpwrvgnd_1
XFILLER_126_203 VGND VGND VPWR VPWR sky130_fd_sc_hd__fill_1
XTAP_TAPCELL_ROW_153_2796 VGND VPWR sky130_fd_sc_hd__tapvpwrvgnd_1
XTAP_TAPCELL_ROW_153_2785 VGND VPWR sky130_fd_sc_hd__tapvpwrvgnd_1
XFILLER_107_461 VGND VGND VPWR VPWR sky130_fd_sc_hd__decap_8
Xoutput50 net50 VGND VGND VPWR VPWR mem_addr[25] sky130_fd_sc_hd__buf_2
XFILLER_150_740 VPWR VGND VPWR VGND sky130_ef_sc_hd__decap_12
XFILLER_134_280 VGND VGND VPWR VPWR sky130_fd_sc_hd__decap_4
Xoutput61 net61 VGND VGND VPWR VPWR mem_addr[6] sky130_fd_sc_hd__buf_2
X_11215_ clknet_leaf_146_clk _01262_ VGND VGND VPWR VPWR cpuregs\[3\]\[8\] sky130_fd_sc_hd__dfxtp_1
Xoutput83 net83 VGND VGND VPWR VPWR mem_la_addr[27] sky130_fd_sc_hd__buf_2
Xoutput72 net72 VGND VGND VPWR VPWR mem_la_addr[16] sky130_fd_sc_hd__buf_2
X_11146_ clknet_leaf_123_clk _01193_ VGND VGND VPWR VPWR cpuregs\[23\]\[3\] sky130_fd_sc_hd__dfxtp_1
Xoutput94 net94 VGND VGND VPWR VPWR mem_la_addr[8] sky130_fd_sc_hd__buf_2
XFILLER_122_486 VPWR VGND VPWR VGND sky130_ef_sc_hd__decap_12
XFILLER_95_337 VGND VGND VPWR VPWR sky130_fd_sc_hd__decap_6
XFILLER_1_783 VGND VGND VPWR VPWR sky130_fd_sc_hd__fill_1
X_11077_ clknet_leaf_136_clk _01134_ VGND VGND VPWR VPWR cpuregs\[24\]\[8\] sky130_fd_sc_hd__dfxtp_1
X_10028_ clknet_leaf_42_clk _00158_ VGND VGND VPWR VPWR cpuregs\[30\]\[26\] sky130_fd_sc_hd__dfxtp_1
XFILLER_48_253 VGND VGND VPWR VPWR sky130_fd_sc_hd__fill_1
XFILLER_48_231 VGND VGND VPWR VPWR sky130_fd_sc_hd__decap_4
XFILLER_0_293 VPWR VGND VPWR VGND sky130_ef_sc_hd__decap_12
XFILLER_37_905 VGND VGND VPWR VPWR sky130_fd_sc_hd__decap_3
XFILLER_76_584 VGND VGND VPWR VPWR sky130_fd_sc_hd__decap_4
XFILLER_48_275 VGND VGND VPWR VPWR sky130_fd_sc_hd__decap_6
XFILLER_64_779 VGND VGND VPWR VPWR sky130_fd_sc_hd__fill_2
XTAP_TAPCELL_ROW_19_635 VGND VPWR sky130_fd_sc_hd__tapvpwrvgnd_1
XFILLER_17_662 VGND VGND VPWR VPWR sky130_fd_sc_hd__decap_8
XFILLER_17_673 VPWR VGND VPWR VGND sky130_ef_sc_hd__decap_12
XFILLER_20_849 VPWR VGND VPWR VGND sky130_ef_sc_hd__decap_12
XTAP_TAPCELL_ROW_30_811 VGND VPWR sky130_fd_sc_hd__tapvpwrvgnd_1
X_07170_ cpuregs\[12\]\[24\] _02683_ net253 VGND VGND VPWR VPWR _00124_ sky130_fd_sc_hd__mux2_1
X_06121_ reg_out\[2\] alu_out_q\[2\] latched_stalu VGND VGND VPWR VPWR _02589_ sky130_fd_sc_hd__mux2_1
XFILLER_105_409 VGND VGND VPWR VPWR sky130_fd_sc_hd__fill_1
Xclkbuf_leaf_120_clk clknet_4_8_0_clk VGND VGND VPWR VPWR clknet_leaf_120_clk sky130_fd_sc_hd__clkbuf_8
X_06052_ decoded_imm_j\[11\] decoded_imm_j\[4\] VGND VGND VPWR VPWR _02525_ sky130_fd_sc_hd__or2_1
XFILLER_133_729 VGND VGND VPWR VPWR sky130_fd_sc_hd__fill_1
XFILLER_132_228 VGND VGND VPWR VPWR sky130_fd_sc_hd__decap_3
XTAP_TAPCELL_ROW_93_1821 VGND VPWR sky130_fd_sc_hd__tapvpwrvgnd_1
X_05003_ instr_sw _01619_ _01630_ instr_lw _01628_ VGND VGND VPWR VPWR _01631_ sky130_fd_sc_hd__a221o_1
X_09811_ _02657_ cpuregs\[8\]\[18\] _04875_ VGND VGND VPWR VPWR _01464_ sky130_fd_sc_hd__mux2_1
XFILLER_99_676 VGND VGND VPWR VPWR sky130_fd_sc_hd__decap_8
XFILLER_87_838 VGND VGND VPWR VPWR sky130_fd_sc_hd__fill_2
XFILLER_98_197 VGND VGND VPWR VPWR sky130_fd_sc_hd__decap_8
XFILLER_87_849 VGND VGND VPWR VPWR sky130_fd_sc_hd__decap_3
X_09742_ _02646_ cpuregs\[6\]\[15\] _04873_ VGND VGND VPWR VPWR _01397_ sky130_fd_sc_hd__mux2_1
X_06954_ net237 _03353_ _03368_ _03345_ VGND VGND VPWR VPWR _00092_ sky130_fd_sc_hd__a31o_1
XFILLER_95_860 VGND VGND VPWR VPWR sky130_fd_sc_hd__fill_1
XFILLER_28_905 VGND VGND VPWR VPWR sky130_fd_sc_hd__decap_6
XTAP_TAPCELL_ROW_124_2320 VGND VPWR sky130_fd_sc_hd__tapvpwrvgnd_1
XTAP_TAPCELL_ROW_107_2039 VGND VPWR sky130_fd_sc_hd__tapvpwrvgnd_1
X_05905_ _02242_ _02456_ _02458_ VGND VGND VPWR VPWR alu_out\[29\] sky130_fd_sc_hd__o21ai_1
X_06885_ net183 _02721_ _03218_ _01641_ VGND VGND VPWR VPWR _03302_ sky130_fd_sc_hd__o211a_1
XFILLER_95_882 VGND VGND VPWR VPWR sky130_fd_sc_hd__fill_1
X_09673_ cpuregs\[4\]\[12\] _02633_ net238 VGND VGND VPWR VPWR _01330_ sky130_fd_sc_hd__mux2_1
XFILLER_27_426 VGND VGND VPWR VPWR sky130_fd_sc_hd__decap_4
X_05836_ _02092_ _02096_ VGND VGND VPWR VPWR _02397_ sky130_fd_sc_hd__nand2_1
X_08624_ cpuregs\[16\]\[8\] cpuregs\[17\]\[8\] cpuregs\[18\]\[8\] cpuregs\[19\]\[8\]
+ net278 net273 VGND VGND VPWR VPWR _04318_ sky130_fd_sc_hd__mux4_1
XTAP_TAPCELL_ROW_38_933 VGND VPWR sky130_fd_sc_hd__tapvpwrvgnd_1
XTAP_TAPCELL_ROW_38_944 VGND VPWR sky130_fd_sc_hd__tapvpwrvgnd_1
XFILLER_39_297 VGND VGND VPWR VPWR sky130_fd_sc_hd__decap_3
XFILLER_82_587 VGND VGND VPWR VPWR sky130_fd_sc_hd__fill_1
X_05767_ _02153_ _02325_ _02198_ VGND VGND VPWR VPWR _02336_ sky130_fd_sc_hd__a21oi_1
XFILLER_70_716 VGND VGND VPWR VPWR sky130_fd_sc_hd__fill_2
X_08555_ _01653_ _04254_ _04255_ _01586_ VGND VGND VPWR VPWR _04256_ sky130_fd_sc_hd__a211o_1
X_07506_ cpuregs\[26\]\[24\] _02683_ _03568_ VGND VGND VPWR VPWR _00444_ sky130_fd_sc_hd__mux2_1
X_08486_ net70 net39 _04208_ VGND VGND VPWR VPWR _00784_ sky130_fd_sc_hd__mux2_1
XFILLER_52_27 VGND VGND VPWR VPWR sky130_fd_sc_hd__fill_1
X_05698_ _02168_ _02269_ _02169_ VGND VGND VPWR VPWR _02275_ sky130_fd_sc_hd__o21bai_1
X_07437_ cpuregs\[27\]\[21\] _02670_ _03566_ VGND VGND VPWR VPWR _00377_ sky130_fd_sc_hd__mux2_1
XTAP_TAPCELL_ROW_102_1961 VGND VPWR sky130_fd_sc_hd__tapvpwrvgnd_1
XFILLER_50_473 VGND VGND VPWR VPWR sky130_fd_sc_hd__decap_3
XFILLER_22_153 VPWR VGND VPWR VGND sky130_ef_sc_hd__decap_12
X_07368_ _02662_ cpuregs\[9\]\[19\] _03563_ VGND VGND VPWR VPWR _00311_ sky130_fd_sc_hd__mux2_1
XFILLER_7_809 VPWR VGND VPWR VGND sky130_ef_sc_hd__decap_12
XFILLER_149_895 VGND VGND VPWR VPWR sky130_fd_sc_hd__fill_1
X_09107_ mem_rdata_q\[14\] mem_rdata_q\[13\] mem_rdata_q\[12\] VGND VGND VPWR VPWR
+ _04757_ sky130_fd_sc_hd__and3_1
X_06319_ cpuregs\[24\]\[1\] cpuregs\[25\]\[1\] cpuregs\[26\]\[1\] cpuregs\[27\]\[1\]
+ net268 net262 VGND VGND VPWR VPWR _02756_ sky130_fd_sc_hd__mux4_1
XTAP_TAPCELL_ROW_135_2493 VGND VPWR sky130_fd_sc_hd__tapvpwrvgnd_1
X_07299_ cpuregs\[28\]\[17\] _02654_ net249 VGND VGND VPWR VPWR _00245_ sky130_fd_sc_hd__mux2_1
Xclkbuf_leaf_111_clk clknet_4_10_0_clk VGND VGND VPWR VPWR clknet_leaf_111_clk sky130_fd_sc_hd__clkbuf_8
XFILLER_108_269 VGND VGND VPWR VPWR sky130_fd_sc_hd__decap_4
X_09038_ _04703_ _04708_ _04709_ _00010_ _01560_ VGND VGND VPWR VPWR _04710_ sky130_fd_sc_hd__a221o_1
XFILLER_117_31 VPWR VGND VPWR VGND sky130_ef_sc_hd__decap_12
XFILLER_117_97 VPWR VGND VPWR VGND sky130_ef_sc_hd__decap_12
XFILLER_2_569 VPWR VGND VPWR VGND sky130_ef_sc_hd__decap_12
X_11000_ clknet_leaf_127_clk _01062_ VGND VGND VPWR VPWR cpuregs\[19\]\[0\] sky130_fd_sc_hd__dfxtp_1
XFILLER_89_175 VGND VGND VPWR VPWR sky130_fd_sc_hd__fill_1
XFILLER_78_849 VGND VGND VPWR VPWR sky130_fd_sc_hd__decap_6
XFILLER_77_337 VGND VGND VPWR VPWR sky130_fd_sc_hd__decap_8
XFILLER_77_57 VGND VGND VPWR VPWR sky130_fd_sc_hd__decap_6
XFILLER_92_307 VGND VGND VPWR VPWR sky130_fd_sc_hd__fill_1
XFILLER_46_757 VGND VGND VPWR VPWR sky130_fd_sc_hd__decap_8
XFILLER_33_418 VPWR VGND VPWR VGND sky130_ef_sc_hd__decap_12
XFILLER_26_83 VGND VGND VPWR VPWR sky130_fd_sc_hd__fill_1
XFILLER_45_289 VGND VGND VPWR VPWR sky130_fd_sc_hd__fill_2
XFILLER_14_654 VGND VGND VPWR VPWR sky130_fd_sc_hd__fill_2
XFILLER_9_113 VPWR VGND VPWR VGND sky130_ef_sc_hd__decap_12
XFILLER_14_698 VGND VGND VPWR VPWR sky130_fd_sc_hd__fill_2
X_10715_ clknet_leaf_134_clk _00812_ VGND VGND VPWR VPWR net125 sky130_fd_sc_hd__dfxtp_4
X_10646_ clknet_leaf_129_clk _04904_ VGND VGND VPWR VPWR reg_out\[4\] sky130_fd_sc_hd__dfxtp_1
Xrebuffer5 net390 VGND VGND VPWR VPWR net391 sky130_fd_sc_hd__dlymetal6s2s_1
XFILLER_127_545 VPWR VGND VPWR VGND sky130_ef_sc_hd__decap_12
XFILLER_115_707 VPWR VGND VPWR VGND sky130_ef_sc_hd__decap_12
Xclkbuf_leaf_102_clk clknet_4_11_0_clk VGND VGND VPWR VPWR clknet_leaf_102_clk sky130_fd_sc_hd__clkbuf_8
XFILLER_10_893 VPWR VGND VPWR VGND sky130_ef_sc_hd__decap_12
X_10577_ clknet_leaf_110_clk _00707_ VGND VGND VPWR VPWR count_cycle\[0\] sky130_fd_sc_hd__dfxtp_2
XFILLER_115_729 VGND VGND VPWR VPWR sky130_fd_sc_hd__decap_8
XTAP_TAPCELL_ROW_58_1259 VGND VPWR sky130_fd_sc_hd__tapvpwrvgnd_1
XFILLER_5_385 VGND VGND VPWR VPWR sky130_fd_sc_hd__decap_6
XFILLER_68_304 VGND VGND VPWR VPWR sky130_fd_sc_hd__decap_4
XFILLER_110_412 VGND VGND VPWR VPWR sky130_fd_sc_hd__decap_8
X_11129_ clknet_leaf_53_clk _01176_ VGND VGND VPWR VPWR cpuregs\[31\]\[18\] sky130_fd_sc_hd__dfxtp_1
XFILLER_96_679 VPWR VGND VPWR VGND sky130_ef_sc_hd__decap_12
XFILLER_84_808 VGND VGND VPWR VPWR sky130_fd_sc_hd__decap_4
XFILLER_49_540 VGND VGND VPWR VPWR sky130_fd_sc_hd__fill_1
XFILLER_110_489 VGND VGND VPWR VPWR sky130_fd_sc_hd__fill_2
XFILLER_37_724 VGND VGND VPWR VPWR sky130_fd_sc_hd__decap_4
X_06670_ cpuregs\[20\]\[13\] cpuregs\[21\]\[13\] cpuregs\[22\]\[13\] cpuregs\[23\]\[13\]
+ net263 net260 VGND VGND VPWR VPWR _03095_ sky130_fd_sc_hd__mux4_1
X_05621_ net222 net190 VGND VGND VPWR VPWR _02204_ sky130_fd_sc_hd__and2b_1
XFILLER_52_705 VGND VGND VPWR VPWR sky130_fd_sc_hd__fill_1
X_08340_ count_cycle\[29\] _04109_ _04111_ VGND VGND VPWR VPWR _00736_ sky130_fd_sc_hd__o21a_1
X_05552_ net202 net234 VGND VGND VPWR VPWR _02135_ sky130_fd_sc_hd__or2_1
XFILLER_149_125 VPWR VGND VPWR VGND sky130_ef_sc_hd__decap_12
X_05483_ _02052_ _02057_ _02061_ _02065_ VGND VGND VPWR VPWR _02066_ sky130_fd_sc_hd__and4b_1
X_08271_ count_cycle\[4\] count_cycle\[5\] _04063_ VGND VGND VPWR VPWR _04067_ sky130_fd_sc_hd__and3_1
XFILLER_149_169 VPWR VGND VPWR VGND sky130_ef_sc_hd__decap_12
XPHY_EDGE_ROW_17_Left_171 VGND VGND VPWR VPWR sky130_fd_sc_hd__decap_3
X_07222_ cpuregs\[13\]\[6\] _02607_ net251 VGND VGND VPWR VPWR _00170_ sky130_fd_sc_hd__mux2_1
XFILLER_118_523 VGND VGND VPWR VPWR sky130_fd_sc_hd__decap_8
X_07153_ cpuregs\[12\]\[7\] _02612_ net253 VGND VGND VPWR VPWR _00107_ sky130_fd_sc_hd__mux2_1
XFILLER_118_545 VGND VGND VPWR VPWR sky130_fd_sc_hd__decap_3
X_06104_ _00010_ _02574_ _01560_ VGND VGND VPWR VPWR _02575_ sky130_fd_sc_hd__a21oi_1
X_07084_ cpuregs\[8\]\[28\] cpuregs\[9\]\[28\] cpuregs\[10\]\[28\] cpuregs\[11\]\[28\]
+ net266 net261 VGND VGND VPWR VPWR _03494_ sky130_fd_sc_hd__mux4_1
X_06035_ mem_rdata_q\[17\] net9 _01609_ VGND VGND VPWR VPWR _01111_ sky130_fd_sc_hd__mux2_1
XFILLER_114_773 VGND VGND VPWR VPWR sky130_fd_sc_hd__decap_3
XFILLER_59_304 VGND VGND VPWR VPWR sky130_fd_sc_hd__decap_4
XFILLER_99_484 VGND VGND VPWR VPWR sky130_fd_sc_hd__decap_4
XFILLER_87_646 VPWR VGND VPWR VGND sky130_ef_sc_hd__decap_12
XFILLER_59_337 VPWR VGND VPWR VGND sky130_ef_sc_hd__decap_12
XPHY_EDGE_ROW_26_Left_180 VGND VGND VPWR VPWR sky130_fd_sc_hd__decap_3
X_07986_ decoded_imm_j\[9\] _03696_ _03801_ VGND VGND VPWR VPWR _03809_ sky130_fd_sc_hd__a21o_1
X_06937_ _02744_ _03275_ _03350_ _03351_ VGND VGND VPWR VPWR _03352_ sky130_fd_sc_hd__a31o_1
XFILLER_74_307 VGND VGND VPWR VPWR sky130_fd_sc_hd__fill_1
X_09725_ _02712_ cpuregs\[5\]\[31\] _04872_ VGND VGND VPWR VPWR _01381_ sky130_fd_sc_hd__mux2_1
X_09656_ _02704_ cpuregs\[22\]\[29\] _04869_ VGND VGND VPWR VPWR _01315_ sky130_fd_sc_hd__mux2_1
XFILLER_83_852 VGND VGND VPWR VPWR sky130_fd_sc_hd__fill_1
XFILLER_55_521 VGND VGND VPWR VPWR sky130_fd_sc_hd__fill_1
X_06868_ cpuregs\[0\]\[20\] cpuregs\[1\]\[20\] cpuregs\[2\]\[20\] cpuregs\[3\]\[20\]
+ _00012_ _00013_ VGND VGND VPWR VPWR _03286_ sky130_fd_sc_hd__mux4_1
XFILLER_103_55 VGND VGND VPWR VPWR sky130_fd_sc_hd__fill_1
X_08607_ cpuregs\[28\]\[7\] cpuregs\[29\]\[7\] cpuregs\[30\]\[7\] cpuregs\[31\]\[7\]
+ net279 _00008_ VGND VGND VPWR VPWR _04302_ sky130_fd_sc_hd__mux4_1
XTAP_TAPCELL_ROW_2_366 VGND VPWR sky130_fd_sc_hd__tapvpwrvgnd_1
XFILLER_27_256 VGND VGND VPWR VPWR sky130_fd_sc_hd__decap_8
XFILLER_27_267 VPWR VGND VPWR VGND sky130_ef_sc_hd__decap_12
X_09587_ cpuregs\[29\]\[26\] _02691_ _04867_ VGND VGND VPWR VPWR _01248_ sky130_fd_sc_hd__mux2_1
X_05819_ _02114_ _02203_ _02215_ VGND VGND VPWR VPWR _02382_ sky130_fd_sc_hd__o21a_1
X_06799_ net176 _02721_ _02744_ _03218_ VGND VGND VPWR VPWR _03219_ sky130_fd_sc_hd__o211a_1
XFILLER_82_384 VGND VGND VPWR VPWR sky130_fd_sc_hd__decap_6
XFILLER_82_373 VGND VGND VPWR VPWR sky130_fd_sc_hd__fill_2
XFILLER_23_440 VGND VGND VPWR VPWR sky130_fd_sc_hd__decap_8
X_08538_ cpuregs\[12\]\[1\] cpuregs\[13\]\[1\] cpuregs\[14\]\[1\] cpuregs\[15\]\[1\]
+ _00007_ _00008_ VGND VGND VPWR VPWR _04239_ sky130_fd_sc_hd__mux4_1
XFILLER_42_259 VGND VGND VPWR VPWR sky130_fd_sc_hd__fill_1
X_08469_ net195 _04170_ _04175_ _04205_ VGND VGND VPWR VPWR _00771_ sky130_fd_sc_hd__a22o_1
XTAP_TAPCELL_ROW_42_1005 VGND VPWR sky130_fd_sc_hd__tapvpwrvgnd_1
XTAP_TAPCELL_ROW_137_2522 VGND VPWR sky130_fd_sc_hd__tapvpwrvgnd_1
X_10500_ clknet_leaf_86_clk _00630_ VGND VGND VPWR VPWR count_instr\[49\] sky130_fd_sc_hd__dfxtp_1
XFILLER_137_821 VPWR VGND VPWR VGND sky130_ef_sc_hd__decap_12
XFILLER_109_501 VGND VGND VPWR VPWR sky130_fd_sc_hd__decap_3
X_11480_ clknet_leaf_26_clk _01524_ VGND VGND VPWR VPWR cpuregs\[10\]\[14\] sky130_fd_sc_hd__dfxtp_1
XFILLER_11_668 VGND VGND VPWR VPWR sky130_fd_sc_hd__decap_4
XTAP_TAPCELL_ROW_21_663 VGND VPWR sky130_fd_sc_hd__tapvpwrvgnd_1
XFILLER_137_865 VPWR VGND VPWR VGND sky130_ef_sc_hd__decap_12
X_10431_ clknet_leaf_8_clk _00561_ VGND VGND VPWR VPWR cpuregs\[17\]\[13\] sky130_fd_sc_hd__dfxtp_1
XFILLER_12_41 VPWR VGND VPWR VGND sky130_ef_sc_hd__decap_12
XTAP_TAPCELL_ROW_21_674 VGND VPWR sky130_fd_sc_hd__tapvpwrvgnd_1
XFILLER_152_813 VPWR VGND VPWR VGND sky130_ef_sc_hd__decap_12
XTAP_TAPCELL_ROW_150_2733 VGND VPWR sky130_fd_sc_hd__tapvpwrvgnd_1
XFILLER_128_41 VPWR VGND VPWR VGND sky130_ef_sc_hd__decap_12
XFILLER_12_85 VPWR VGND VPWR VGND sky130_ef_sc_hd__decap_12
X_10362_ clknet_leaf_136_clk _00492_ VGND VGND VPWR VPWR cpuregs\[25\]\[8\] sky130_fd_sc_hd__dfxtp_1
XFILLER_128_85 VPWR VGND VPWR VGND sky130_ef_sc_hd__decap_12
X_10293_ clknet_leaf_124_clk _00423_ VGND VGND VPWR VPWR cpuregs\[26\]\[3\] sky130_fd_sc_hd__dfxtp_1
XFILLER_151_367 VGND VGND VPWR VPWR sky130_fd_sc_hd__decap_8
XFILLER_105_740 VGND VGND VPWR VPWR sky130_fd_sc_hd__decap_8
XFILLER_3_889 VGND VGND VPWR VPWR sky130_fd_sc_hd__decap_6
XFILLER_77_101 VGND VGND VPWR VPWR sky130_fd_sc_hd__decap_8
XFILLER_2_377 VPWR VGND VPWR VGND sky130_ef_sc_hd__decap_12
XFILLER_78_679 VGND VGND VPWR VPWR sky130_fd_sc_hd__fill_1
XTAP_TAPCELL_ROW_53_1178 VGND VPWR sky130_fd_sc_hd__tapvpwrvgnd_1
XTAP_TAPCELL_ROW_148_2695 VGND VPWR sky130_fd_sc_hd__tapvpwrvgnd_1
XFILLER_77_167 VGND VGND VPWR VPWR sky130_fd_sc_hd__fill_1
XFILLER_18_201 VGND VGND VPWR VPWR sky130_fd_sc_hd__fill_1
XFILLER_74_841 VPWR VGND VPWR VGND sky130_ef_sc_hd__decap_12
XPHY_EDGE_ROW_16_Right_16 VGND VGND VPWR VPWR sky130_fd_sc_hd__decap_3
XFILLER_19_779 VGND VGND VPWR VPWR sky130_fd_sc_hd__decap_4
XFILLER_73_373 VGND VGND VPWR VPWR sky130_fd_sc_hd__fill_1
XFILLER_61_535 VGND VGND VPWR VPWR sky130_fd_sc_hd__fill_1
XTAP_TAPCELL_ROW_29_796 VGND VPWR sky130_fd_sc_hd__tapvpwrvgnd_1
XFILLER_147_607 VGND VGND VPWR VPWR sky130_fd_sc_hd__decap_8
XFILLER_147_629 VPWR VGND VPWR VGND sky130_ef_sc_hd__decap_12
XFILLER_128_810 VGND VGND VPWR VPWR sky130_fd_sc_hd__fill_2
XTAP_TAPCELL_ROW_40_972 VGND VPWR sky130_fd_sc_hd__tapvpwrvgnd_1
XFILLER_146_139 VGND VGND VPWR VPWR sky130_fd_sc_hd__fill_1
X_10629_ clknet_leaf_84_clk _00759_ VGND VGND VPWR VPWR count_cycle\[52\] sky130_fd_sc_hd__dfxtp_1
XPHY_EDGE_ROW_25_Right_25 VGND VGND VPWR VPWR sky130_fd_sc_hd__decap_3
Xpicorv32_304 VGND VGND VPWR VPWR picorv32_304/HI eoi[23] sky130_fd_sc_hd__conb_1
Xpicorv32_326 VGND VGND VPWR VPWR picorv32_326/HI pcpi_insn[9] sky130_fd_sc_hd__conb_1
Xpicorv32_315 VGND VGND VPWR VPWR picorv32_315/HI mem_la_addr[0] sky130_fd_sc_hd__conb_1
Xpicorv32_348 VGND VGND VPWR VPWR picorv32_348/HI pcpi_insn[31] sky130_fd_sc_hd__conb_1
Xpicorv32_359 VGND VGND VPWR VPWR picorv32_359/HI trace_data[9] sky130_fd_sc_hd__conb_1
Xpicorv32_337 VGND VGND VPWR VPWR picorv32_337/HI pcpi_insn[20] sky130_fd_sc_hd__conb_1
XFILLER_5_193 VPWR VGND VPWR VGND sky130_ef_sc_hd__decap_12
XFILLER_123_570 VPWR VGND VPWR VGND sky130_ef_sc_hd__decap_12
XFILLER_69_646 VGND VGND VPWR VPWR sky130_fd_sc_hd__decap_6
XFILLER_57_808 VGND VGND VPWR VPWR sky130_fd_sc_hd__decap_8
X_07840_ reg_pc\[8\] _01624_ _01628_ _03695_ VGND VGND VPWR VPWR _00652_ sky130_fd_sc_hd__a22o_1
XFILLER_110_253 VGND VGND VPWR VPWR sky130_fd_sc_hd__decap_3
XFILLER_96_498 VGND VGND VPWR VPWR sky130_fd_sc_hd__decap_8
X_07771_ _03649_ count_instr\[43\] count_instr\[42\] count_instr\[44\] VGND VGND VPWR
+ VPWR _03654_ sky130_fd_sc_hd__and4_1
XTAP_TAPCELL_ROW_88_1742 VGND VPWR sky130_fd_sc_hd__tapvpwrvgnd_1
X_06722_ cpuregs\[4\]\[15\] cpuregs\[5\]\[15\] cpuregs\[6\]\[15\] cpuregs\[7\]\[15\]
+ net265 net260 VGND VGND VPWR VPWR _03145_ sky130_fd_sc_hd__mux4_1
X_09510_ cpuregs\[31\]\[15\] _02646_ net240 VGND VGND VPWR VPWR _01173_ sky130_fd_sc_hd__mux2_1
XPHY_EDGE_ROW_34_Right_34 VGND VGND VPWR VPWR sky130_fd_sc_hd__decap_3
X_04983_ mem_do_wdata mem_do_rdata mem_do_rinst _01584_ _01609_ VGND VGND VPWR VPWR
+ _01611_ sky130_fd_sc_hd__o311a_1
XFILLER_64_362 VGND VGND VPWR VPWR sky130_fd_sc_hd__fill_2
XFILLER_25_705 VGND VGND VPWR VPWR sky130_fd_sc_hd__fill_2
XFILLER_37_565 VGND VGND VPWR VPWR sky130_fd_sc_hd__fill_1
XFILLER_91_181 VGND VGND VPWR VPWR sky130_fd_sc_hd__fill_1
XFILLER_80_844 VGND VGND VPWR VPWR sky130_fd_sc_hd__decap_6
X_09441_ _02633_ cpuregs\[19\]\[12\] _04863_ VGND VGND VPWR VPWR _01074_ sky130_fd_sc_hd__mux2_1
XFILLER_64_395 VPWR VGND VPWR VGND sky130_ef_sc_hd__decap_12
X_06653_ _00015_ _03075_ _03078_ _02735_ VGND VGND VPWR VPWR _03079_ sky130_fd_sc_hd__o211a_1
XFILLER_52_524 VGND VGND VPWR VPWR sky130_fd_sc_hd__decap_8
XFILLER_80_866 VGND VGND VPWR VPWR sky130_fd_sc_hd__fill_2
X_09372_ decoded_imm\[10\] _04746_ _04848_ VGND VGND VPWR VPWR _01020_ sky130_fd_sc_hd__o21a_1
X_06584_ net202 net173 _02721_ VGND VGND VPWR VPWR _03012_ sky130_fd_sc_hd__mux2_1
X_05604_ net198 _01573_ _02141_ _02184_ _02185_ VGND VGND VPWR VPWR _02187_ sky130_fd_sc_hd__a221o_1
X_08323_ count_cycle\[23\] _04098_ net34 VGND VGND VPWR VPWR _04101_ sky130_fd_sc_hd__o21ai_1
X_05535_ net173 net205 VGND VGND VPWR VPWR _02118_ sky130_fd_sc_hd__or2_1
XTAP_TAPCELL_ROW_119_2230 VGND VPWR sky130_fd_sc_hd__tapvpwrvgnd_1
XFILLER_20_421 VGND VGND VPWR VPWR sky130_fd_sc_hd__decap_3
XFILLER_119_821 VPWR VGND VPWR VGND sky130_ef_sc_hd__decap_12
XTAP_TAPCELL_ROW_119_2241 VGND VPWR sky130_fd_sc_hd__tapvpwrvgnd_1
X_05466_ net188 net220 VGND VGND VPWR VPWR _02049_ sky130_fd_sc_hd__nor2_1
X_08254_ _04054_ _04055_ VGND VGND VPWR VPWR _04056_ sky130_fd_sc_hd__xnor2_1
XPHY_EDGE_ROW_43_Right_43 VGND VGND VPWR VPWR sky130_fd_sc_hd__decap_3
X_08185_ instr_jal _03991_ _03992_ VGND VGND VPWR VPWR _03993_ sky130_fd_sc_hd__or3_1
X_07205_ cpuregs\[30\]\[23\] _02678_ _03556_ VGND VGND VPWR VPWR _00155_ sky130_fd_sc_hd__mux2_1
XFILLER_119_865 VPWR VGND VPWR VGND sky130_ef_sc_hd__decap_12
X_05397_ count_instr\[26\] instr_rdinstr count_cycle\[58\] instr_rdcycleh VGND VGND
+ VPWR VPWR _01986_ sky130_fd_sc_hd__a22o_1
XFILLER_152_109 VPWR VGND VPWR VGND sky130_ef_sc_hd__decap_12
XFILLER_145_150 VPWR VGND VPWR VGND sky130_ef_sc_hd__decap_12
XFILLER_134_813 VPWR VGND VPWR VGND sky130_ef_sc_hd__decap_12
XTAP_TAPCELL_ROW_132_2441 VGND VPWR sky130_fd_sc_hd__tapvpwrvgnd_1
XFILLER_118_353 VGND VGND VPWR VPWR sky130_fd_sc_hd__decap_8
X_07136_ _03540_ _03541_ _01579_ VGND VGND VPWR VPWR _03544_ sky130_fd_sc_hd__mux2_1
X_07067_ _03475_ _03476_ VGND VGND VPWR VPWR _03477_ sky130_fd_sc_hd__and2_1
XFILLER_133_367 VPWR VGND VPWR VGND sky130_ef_sc_hd__decap_12
X_06018_ net195 _02512_ _01582_ VGND VGND VPWR VPWR net88 sky130_fd_sc_hd__mux2_2
XFILLER_0_804 VGND VGND VPWR VPWR sky130_fd_sc_hd__decap_4
XFILLER_133_389 VGND VGND VPWR VPWR sky130_fd_sc_hd__decap_3
XFILLER_102_710 VGND VGND VPWR VPWR sky130_fd_sc_hd__decap_6
XTAP_TAPCELL_ROW_7_447 VGND VPWR sky130_fd_sc_hd__tapvpwrvgnd_1
XTAP_TAPCELL_ROW_7_436 VGND VPWR sky130_fd_sc_hd__tapvpwrvgnd_1
XFILLER_59_134 VPWR VGND VPWR VGND sky130_ef_sc_hd__decap_12
XFILLER_102_798 VPWR VGND VPWR VGND sky130_ef_sc_hd__decap_12
XFILLER_101_264 VPWR VGND VPWR VGND sky130_ef_sc_hd__decap_12
XFILLER_59_178 VGND VGND VPWR VPWR sky130_fd_sc_hd__decap_4
XPHY_EDGE_ROW_52_Right_52 VGND VGND VPWR VPWR sky130_fd_sc_hd__decap_3
XFILLER_114_76 VGND VGND VPWR VPWR sky130_fd_sc_hd__decap_8
X_09708_ _02641_ cpuregs\[5\]\[14\] _04872_ VGND VGND VPWR VPWR _01364_ sky130_fd_sc_hd__mux2_1
X_07969_ _03576_ _03793_ VGND VGND VPWR VPWR _03794_ sky130_fd_sc_hd__nor2_1
X_10980_ clknet_leaf_6_clk _01042_ VGND VGND VPWR VPWR cpuregs\[18\]\[12\] sky130_fd_sc_hd__dfxtp_1
XFILLER_83_682 VGND VGND VPWR VPWR sky130_fd_sc_hd__decap_8
X_09639_ _02633_ cpuregs\[22\]\[12\] _04869_ VGND VGND VPWR VPWR _01298_ sky130_fd_sc_hd__mux2_1
XFILLER_43_535 VGND VGND VPWR VPWR sky130_fd_sc_hd__decap_4
XFILLER_130_53 VPWR VGND VPWR VGND sky130_ef_sc_hd__decap_12
XFILLER_70_354 VGND VGND VPWR VPWR sky130_fd_sc_hd__fill_1
XTAP_TAPCELL_ROW_26_744 VGND VPWR sky130_fd_sc_hd__tapvpwrvgnd_1
XTAP_TAPCELL_ROW_26_755 VGND VPWR sky130_fd_sc_hd__tapvpwrvgnd_1
XFILLER_70_387 VGND VGND VPWR VPWR sky130_fd_sc_hd__decap_3
XFILLER_24_782 VPWR VGND VPWR VGND sky130_ef_sc_hd__decap_12
XPHY_EDGE_ROW_61_Right_61 VGND VGND VPWR VPWR sky130_fd_sc_hd__decap_3
XFILLER_11_443 VGND VGND VPWR VPWR sky130_fd_sc_hd__decap_4
XFILLER_23_51 VGND VGND VPWR VPWR sky130_fd_sc_hd__decap_4
XFILLER_139_51 VGND VGND VPWR VPWR sky130_fd_sc_hd__decap_4
X_11463_ clknet_leaf_36_clk _01507_ VGND VGND VPWR VPWR cpuregs\[0\]\[29\] sky130_fd_sc_hd__dfxtp_1
XFILLER_7_458 VGND VGND VPWR VPWR sky130_fd_sc_hd__decap_4
X_10414_ clknet_leaf_40_clk _00544_ VGND VGND VPWR VPWR cpuregs\[20\]\[28\] sky130_fd_sc_hd__dfxtp_1
XFILLER_99_33 VGND VGND VPWR VPWR sky130_fd_sc_hd__decap_8
XFILLER_152_643 VGND VGND VPWR VPWR sky130_fd_sc_hd__fill_1
X_11394_ clknet_leaf_69_clk _01438_ VGND VGND VPWR VPWR cpuregs\[7\]\[24\] sky130_fd_sc_hd__dfxtp_1
XFILLER_136_183 VPWR VGND VPWR VGND sky130_ef_sc_hd__decap_12
XFILLER_124_334 VGND VGND VPWR VPWR sky130_fd_sc_hd__decap_3
XFILLER_109_386 VGND VGND VPWR VPWR sky130_fd_sc_hd__decap_6
XTAP_TAPCELL_ROW_55_1207 VGND VPWR sky130_fd_sc_hd__tapvpwrvgnd_1
X_10345_ clknet_leaf_52_clk _00475_ VGND VGND VPWR VPWR cpuregs\[16\]\[23\] sky130_fd_sc_hd__dfxtp_1
XFILLER_98_708 VPWR VGND VPWR VGND sky130_ef_sc_hd__decap_12
XTAP_TAPCELL_ROW_55_1218 VGND VPWR sky130_fd_sc_hd__tapvpwrvgnd_1
XFILLER_3_653 VPWR VGND VPWR VGND sky130_ef_sc_hd__decap_12
XFILLER_140_849 VPWR VGND VPWR VGND sky130_ef_sc_hd__decap_12
X_10276_ clknet_leaf_54_clk _00406_ VGND VGND VPWR VPWR cpuregs\[15\]\[18\] sky130_fd_sc_hd__dfxtp_1
XPHY_EDGE_ROW_70_Right_70 VGND VGND VPWR VPWR sky130_fd_sc_hd__decap_3
XFILLER_3_697 VPWR VGND VPWR VGND sky130_ef_sc_hd__decap_12
XFILLER_2_141 VPWR VGND VPWR VGND sky130_ef_sc_hd__decap_12
XFILLER_105_592 VPWR VGND VPWR VGND sky130_ef_sc_hd__decap_12
XFILLER_78_432 VGND VGND VPWR VPWR sky130_fd_sc_hd__decap_6
XFILLER_38_307 VGND VGND VPWR VPWR sky130_fd_sc_hd__fill_1
XFILLER_19_521 VGND VGND VPWR VPWR sky130_fd_sc_hd__decap_6
XFILLER_34_557 VPWR VGND VPWR VGND sky130_ef_sc_hd__decap_12
XTAP_TAPCELL_ROW_83_1661 VGND VPWR sky130_fd_sc_hd__tapvpwrvgnd_1
XFILLER_61_365 VPWR VGND VPWR VGND sky130_ef_sc_hd__decap_12
XFILLER_148_905 VGND VGND VPWR VPWR sky130_fd_sc_hd__decap_6
X_05320_ net13 _01665_ _01856_ VGND VGND VPWR VPWR _01915_ sky130_fd_sc_hd__a21o_1
X_05251_ reg_pc\[15\] decoded_imm\[15\] VGND VGND VPWR VPWR _01851_ sky130_fd_sc_hd__or2_1
X_05182_ count_cycle\[9\] _01588_ net256 _01787_ VGND VGND VPWR VPWR _01788_ sky130_fd_sc_hd__o211a_1
XFILLER_128_695 VGND VGND VPWR VPWR sky130_fd_sc_hd__decap_4
XFILLER_116_835 VGND VGND VPWR VPWR sky130_fd_sc_hd__fill_1
XTAP_TAPCELL_ROW_114_2160 VGND VPWR sky130_fd_sc_hd__tapvpwrvgnd_1
XFILLER_142_131 VGND VGND VPWR VPWR sky130_fd_sc_hd__decap_8
X_09990_ clknet_leaf_74_clk _00120_ VGND VGND VPWR VPWR cpuregs\[12\]\[20\] sky130_fd_sc_hd__dfxtp_1
X_08941_ cpuregs\[12\]\[25\] cpuregs\[13\]\[25\] cpuregs\[14\]\[25\] cpuregs\[15\]\[25\]
+ net280 net274 VGND VGND VPWR VPWR _04618_ sky130_fd_sc_hd__mux4_1
XFILLER_142_197 VGND VGND VPWR VPWR sky130_fd_sc_hd__decap_4
X_08872_ _04547_ _04548_ _01558_ VGND VGND VPWR VPWR _04553_ sky130_fd_sc_hd__mux2_1
X_07823_ count_instr\[63\] _03684_ _03686_ VGND VGND VPWR VPWR _00644_ sky130_fd_sc_hd__o21a_1
XFILLER_84_402 VGND VGND VPWR VPWR sky130_fd_sc_hd__decap_8
XFILLER_28_29 VPWR VGND VPWR VGND sky130_ef_sc_hd__decap_12
XFILLER_96_295 VGND VGND VPWR VPWR sky130_fd_sc_hd__decap_4
X_04966_ instr_sw instr_sh _01589_ _01595_ VGND VGND VPWR VPWR _01596_ sky130_fd_sc_hd__or4_1
X_07754_ _03643_ net34 _03642_ VGND VGND VPWR VPWR _00618_ sky130_fd_sc_hd__and3b_1
X_06705_ reg_pc\[14\] _02751_ _03128_ _02715_ VGND VGND VPWR VPWR _03129_ sky130_fd_sc_hd__a211o_1
X_07685_ _03599_ net34 _03598_ VGND VGND VPWR VPWR _00593_ sky130_fd_sc_hd__and3b_1
XFILLER_65_671 VGND VGND VPWR VPWR sky130_fd_sc_hd__fill_1
XFILLER_25_513 VGND VGND VPWR VPWR sky130_fd_sc_hd__decap_3
X_09424_ _02699_ cpuregs\[18\]\[28\] _04862_ VGND VGND VPWR VPWR _01058_ sky130_fd_sc_hd__mux2_1
Xclkbuf_leaf_91_clk clknet_4_15_0_clk VGND VGND VPWR VPWR clknet_leaf_91_clk sky130_fd_sc_hd__clkbuf_8
XFILLER_80_652 VPWR VGND VPWR VGND sky130_ef_sc_hd__decap_12
X_06636_ _01622_ _03060_ _03061_ VGND VGND VPWR VPWR _03062_ sky130_fd_sc_hd__and3_1
XFILLER_64_181 VPWR VGND VPWR VGND sky130_ef_sc_hd__decap_12
XFILLER_52_365 VPWR VGND VPWR VGND sky130_ef_sc_hd__decap_12
XTAP_TAPCELL_ROW_23_703 VGND VPWR sky130_fd_sc_hd__tapvpwrvgnd_1
XFILLER_100_23 VGND VGND VPWR VPWR sky130_fd_sc_hd__decap_4
X_09355_ decoded_imm\[18\] _04746_ _04824_ _04839_ VGND VGND VPWR VPWR _01012_ sky130_fd_sc_hd__o22a_1
X_06567_ cpuregs\[0\]\[9\] cpuregs\[1\]\[9\] cpuregs\[2\]\[9\] cpuregs\[3\]\[9\] net263
+ net259 VGND VGND VPWR VPWR _02996_ sky130_fd_sc_hd__mux4_1
XFILLER_40_538 VGND VGND VPWR VPWR sky130_fd_sc_hd__fill_1
X_09286_ net142 net104 _04206_ VGND VGND VPWR VPWR _00972_ sky130_fd_sc_hd__mux2_1
X_05518_ net181 net213 VGND VGND VPWR VPWR _02101_ sky130_fd_sc_hd__nor2_1
X_08306_ _04088_ _04089_ VGND VGND VPWR VPWR _00724_ sky130_fd_sc_hd__nor2_1
XFILLER_60_27 VGND VGND VPWR VPWR sky130_fd_sc_hd__fill_1
XFILLER_21_774 VGND VGND VPWR VPWR sky130_fd_sc_hd__decap_8
X_06498_ _02927_ _02928_ VGND VGND VPWR VPWR _02929_ sky130_fd_sc_hd__xnor2_1
X_08237_ _01549_ _04040_ VGND VGND VPWR VPWR _00704_ sky130_fd_sc_hd__nor2_1
X_05449_ count_instr\[30\] instr_rdinstr count_cycle\[62\] instr_rdcycleh VGND VGND
+ VPWR VPWR _02034_ sky130_fd_sc_hd__a22o_1
XFILLER_21_785 VPWR VGND VPWR VGND sky130_ef_sc_hd__decap_12
XFILLER_119_673 VGND VGND VPWR VPWR sky130_fd_sc_hd__fill_2
XFILLER_134_621 VGND VGND VPWR VPWR sky130_fd_sc_hd__decap_3
X_08168_ _03974_ _03975_ instr_jal VGND VGND VPWR VPWR _03977_ sky130_fd_sc_hd__o21ai_1
XFILLER_118_161 VGND VGND VPWR VPWR sky130_fd_sc_hd__fill_2
X_08099_ instr_jal _03911_ _03912_ _03913_ VGND VGND VPWR VPWR _03914_ sky130_fd_sc_hd__a22o_1
X_07119_ _03476_ _03479_ _03501_ VGND VGND VPWR VPWR _03527_ sky130_fd_sc_hd__a21oi_2
XFILLER_134_687 VGND VGND VPWR VPWR sky130_fd_sc_hd__fill_1
XFILLER_122_849 VPWR VGND VPWR VGND sky130_ef_sc_hd__decap_12
XFILLER_0_601 VGND VGND VPWR VPWR sky130_fd_sc_hd__decap_4
X_10130_ clknet_leaf_118_clk _00260_ VGND VGND VPWR VPWR cpuregs\[21\]\[0\] sky130_fd_sc_hd__dfxtp_1
X_10061_ clknet_leaf_41_clk _00191_ VGND VGND VPWR VPWR cpuregs\[13\]\[27\] sky130_fd_sc_hd__dfxtp_1
XFILLER_0_645 VGND VGND VPWR VPWR sky130_fd_sc_hd__fill_2
XFILLER_125_75 VGND VGND VPWR VPWR sky130_fd_sc_hd__decap_8
XFILLER_85_35 VPWR VGND VPWR VGND sky130_ef_sc_hd__decap_12
XFILLER_75_413 VGND VGND VPWR VPWR sky130_fd_sc_hd__decap_6
XTAP_TAPCELL_ROW_50_1137 VGND VPWR sky130_fd_sc_hd__tapvpwrvgnd_1
XTAP_TAPCELL_ROW_50_1126 VGND VPWR sky130_fd_sc_hd__tapvpwrvgnd_1
XTAP_TAPCELL_ROW_145_2654 VGND VPWR sky130_fd_sc_hd__tapvpwrvgnd_1
XFILLER_130_893 VPWR VGND VPWR VGND sky130_ef_sc_hd__decap_12
XFILLER_29_830 VGND VGND VPWR VPWR sky130_fd_sc_hd__decap_8
XFILLER_29_841 VPWR VGND VPWR VGND sky130_ef_sc_hd__decap_12
XFILLER_75_468 VGND VGND VPWR VPWR sky130_fd_sc_hd__decap_8
X_10963_ clknet_leaf_129_clk _01025_ VGND VGND VPWR VPWR decoded_imm\[5\] sky130_fd_sc_hd__dfxtp_2
Xclkbuf_leaf_82_clk clknet_4_15_0_clk VGND VGND VPWR VPWR clknet_leaf_82_clk sky130_fd_sc_hd__clkbuf_8
X_10894_ clknet_leaf_29_clk _00956_ VGND VGND VPWR VPWR net135 sky130_fd_sc_hd__dfxtp_1
XFILLER_31_505 VGND VGND VPWR VPWR sky130_fd_sc_hd__decap_6
XTAP_TAPCELL_ROW_48_1099 VGND VPWR sky130_fd_sc_hd__tapvpwrvgnd_1
XFILLER_31_549 VGND VGND VPWR VPWR sky130_fd_sc_hd__fill_1
XFILLER_137_492 VGND VGND VPWR VPWR sky130_fd_sc_hd__decap_3
X_11446_ clknet_leaf_9_clk _01490_ VGND VGND VPWR VPWR cpuregs\[0\]\[12\] sky130_fd_sc_hd__dfxtp_1
X_11377_ clknet_leaf_148_clk _01421_ VGND VGND VPWR VPWR cpuregs\[7\]\[7\] sky130_fd_sc_hd__dfxtp_1
XFILLER_3_461 VPWR VGND VPWR VGND sky130_ef_sc_hd__decap_12
X_10328_ clknet_leaf_3_clk _00458_ VGND VGND VPWR VPWR cpuregs\[16\]\[6\] sky130_fd_sc_hd__dfxtp_1
XFILLER_79_752 VGND VGND VPWR VPWR sky130_fd_sc_hd__fill_1
XFILLER_79_785 VGND VGND VPWR VPWR sky130_fd_sc_hd__decap_8
XFILLER_79_774 VGND VGND VPWR VPWR sky130_fd_sc_hd__decap_8
XFILLER_78_251 VGND VGND VPWR VPWR sky130_fd_sc_hd__fill_1
X_10259_ clknet_leaf_117_clk _00389_ VGND VGND VPWR VPWR cpuregs\[15\]\[1\] sky130_fd_sc_hd__dfxtp_1
XFILLER_120_381 VGND VGND VPWR VPWR sky130_fd_sc_hd__fill_1
XFILLER_35_833 VGND VGND VPWR VPWR sky130_fd_sc_hd__decap_6
XFILLER_47_671 VGND VGND VPWR VPWR sky130_fd_sc_hd__fill_1
Xclkbuf_leaf_73_clk clknet_4_13_0_clk VGND VGND VPWR VPWR clknet_leaf_73_clk sky130_fd_sc_hd__clkbuf_8
XFILLER_81_449 VGND VGND VPWR VPWR sky130_fd_sc_hd__fill_1
XFILLER_34_321 VPWR VGND VPWR VGND sky130_ef_sc_hd__decap_12
X_07470_ cpuregs\[15\]\[21\] _02670_ net246 VGND VGND VPWR VPWR _00409_ sky130_fd_sc_hd__mux2_1
XFILLER_62_674 VGND VGND VPWR VPWR sky130_fd_sc_hd__fill_1
XFILLER_22_516 VGND VGND VPWR VPWR sky130_fd_sc_hd__decap_8
XFILLER_34_365 VPWR VGND VPWR VGND sky130_ef_sc_hd__decap_12
XFILLER_50_869 VGND VGND VPWR VPWR sky130_fd_sc_hd__fill_2
XFILLER_50_858 VGND VGND VPWR VPWR sky130_fd_sc_hd__decap_3
XTAP_TAPCELL_ROW_17_596 VGND VPWR sky130_fd_sc_hd__tapvpwrvgnd_1
X_06421_ _01578_ _02854_ VGND VGND VPWR VPWR _02855_ sky130_fd_sc_hd__or2_1
X_09140_ instr_slli _04747_ _04770_ is_alu_reg_imm VGND VGND VPWR VPWR _00868_ sky130_fd_sc_hd__a22o_1
X_06352_ cpuregs\[0\]\[2\] cpuregs\[1\]\[2\] cpuregs\[2\]\[2\] cpuregs\[3\]\[2\] net268
+ net262 VGND VGND VPWR VPWR _02788_ sky130_fd_sc_hd__mux4_1
XFILLER_148_757 VGND VGND VPWR VPWR sky130_fd_sc_hd__decap_6
XFILLER_147_234 VGND VGND VPWR VPWR sky130_fd_sc_hd__decap_6
XFILLER_147_223 VGND VGND VPWR VPWR sky130_fd_sc_hd__fill_1
X_05303_ _01897_ _01898_ VGND VGND VPWR VPWR _01899_ sky130_fd_sc_hd__nand2_1
X_09071_ instr_lh _01630_ _04737_ latched_is_lh VGND VGND VPWR VPWR _00842_ sky130_fd_sc_hd__a22o_1
X_06283_ instr_srl instr_srli _02719_ VGND VGND VPWR VPWR _02721_ sky130_fd_sc_hd__or3_4
X_08022_ decoded_imm_j\[13\] _03700_ VGND VGND VPWR VPWR _03842_ sky130_fd_sc_hd__or2_1
XTAP_TAPCELL_ROW_96_1863 VGND VPWR sky130_fd_sc_hd__tapvpwrvgnd_1
X_05234_ _01771_ _01835_ cpu_state\[6\] VGND VGND VPWR VPWR _01836_ sky130_fd_sc_hd__o21a_1
XTAP_TAPCELL_ROW_112_2119 VGND VPWR sky130_fd_sc_hd__tapvpwrvgnd_1
XTAP_TAPCELL_ROW_96_1874 VGND VPWR sky130_fd_sc_hd__tapvpwrvgnd_1
XFILLER_89_505 VGND VGND VPWR VPWR sky130_fd_sc_hd__decap_8
X_05165_ _01545_ latched_is_lh _01672_ VGND VGND VPWR VPWR _01772_ sky130_fd_sc_hd__o21a_2
XFILLER_103_304 VGND VGND VPWR VPWR sky130_fd_sc_hd__decap_3
X_05096_ net3 net20 net606 VGND VGND VPWR VPWR _01708_ sky130_fd_sc_hd__mux2_1
X_09973_ clknet_leaf_124_clk _00103_ VGND VGND VPWR VPWR cpuregs\[12\]\[3\] sky130_fd_sc_hd__dfxtp_1
X_08924_ cpuregs\[0\]\[24\] cpuregs\[1\]\[24\] cpuregs\[2\]\[24\] cpuregs\[3\]\[24\]
+ net280 net274 VGND VGND VPWR VPWR _04602_ sky130_fd_sc_hd__mux4_1
XFILLER_143_495 VGND VGND VPWR VPWR sky130_fd_sc_hd__decap_8
XFILLER_39_39 VGND VGND VPWR VPWR sky130_fd_sc_hd__fill_1
XFILLER_58_903 VGND VGND VPWR VPWR sky130_fd_sc_hd__fill_1
X_08855_ _04527_ _04528_ _01558_ VGND VGND VPWR VPWR _04537_ sky130_fd_sc_hd__mux2_1
XFILLER_111_370 VGND VGND VPWR VPWR sky130_fd_sc_hd__fill_1
XFILLER_85_722 VGND VGND VPWR VPWR sky130_fd_sc_hd__decap_6
XTAP_TAPCELL_ROW_127_2362 VGND VPWR sky130_fd_sc_hd__tapvpwrvgnd_1
X_07806_ count_instr\[57\] _03674_ _01549_ VGND VGND VPWR VPWR _03676_ sky130_fd_sc_hd__a21oi_1
X_08786_ _01558_ _04464_ _04463_ _01560_ VGND VGND VPWR VPWR _04472_ sky130_fd_sc_hd__o211a_1
XPHY_EDGE_ROW_2_Right_2 VGND VGND VPWR VPWR sky130_fd_sc_hd__decap_3
X_05998_ net184 _02502_ _01582_ VGND VGND VPWR VPWR net77 sky130_fd_sc_hd__mux2_1
X_07737_ count_instr\[31\] count_instr\[30\] net394 VGND VGND VPWR VPWR _03633_ sky130_fd_sc_hd__and3_1
Xclkbuf_leaf_64_clk clknet_4_13_0_clk VGND VGND VPWR VPWR clknet_leaf_64_clk sky130_fd_sc_hd__clkbuf_8
XFILLER_65_490 VPWR VGND VPWR VGND sky130_ef_sc_hd__decap_12
X_04949_ mem_do_rinst mem_do_prefetch VGND VGND VPWR VPWR _01582_ sky130_fd_sc_hd__or2_4
XTAP_TAPCELL_ROW_140_2573 VGND VPWR sky130_fd_sc_hd__tapvpwrvgnd_1
XFILLER_80_460 VGND VGND VPWR VPWR sky130_fd_sc_hd__fill_1
X_07668_ count_instr\[6\] count_instr\[5\] _03585_ VGND VGND VPWR VPWR _03589_ sky130_fd_sc_hd__and3_1
XPHY_EDGE_ROW_9_Left_163 VGND VGND VPWR VPWR sky130_fd_sc_hd__decap_3
XFILLER_13_505 VGND VGND VPWR VPWR sky130_fd_sc_hd__decap_8
X_07599_ cpuregs\[20\]\[16\] _02649_ net245 VGND VGND VPWR VPWR _00532_ sky130_fd_sc_hd__mux2_1
XFILLER_52_195 VGND VGND VPWR VPWR sky130_fd_sc_hd__fill_1
X_09407_ _02630_ cpuregs\[18\]\[11\] _04862_ VGND VGND VPWR VPWR _01041_ sky130_fd_sc_hd__mux2_1
X_06619_ cpuregs\[0\]\[11\] cpuregs\[1\]\[11\] cpuregs\[2\]\[11\] cpuregs\[3\]\[11\]
+ net268 net259 VGND VGND VPWR VPWR _03046_ sky130_fd_sc_hd__mux4_1
X_09338_ mem_rdata_q\[26\] _01589_ VGND VGND VPWR VPWR _04831_ sky130_fd_sc_hd__and2_1
X_11300_ clknet_leaf_32_clk _01347_ VGND VGND VPWR VPWR cpuregs\[4\]\[29\] sky130_fd_sc_hd__dfxtp_1
XFILLER_21_593 VGND VGND VPWR VPWR sky130_fd_sc_hd__fill_1
X_09269_ mem_state\[1\] _04806_ _04809_ _04810_ VGND VGND VPWR VPWR _00955_ sky130_fd_sc_hd__a22o_1
XFILLER_153_237 VPWR VGND VPWR VGND sky130_ef_sc_hd__decap_12
XFILLER_119_470 VGND VGND VPWR VPWR sky130_fd_sc_hd__decap_6
XFILLER_5_726 VGND VGND VPWR VPWR sky130_fd_sc_hd__fill_2
X_11231_ clknet_leaf_69_clk _01278_ VGND VGND VPWR VPWR cpuregs\[3\]\[24\] sky130_fd_sc_hd__dfxtp_1
XFILLER_20_41 VPWR VGND VPWR VGND sky130_ef_sc_hd__decap_12
X_11162_ clknet_leaf_71_clk _01209_ VGND VGND VPWR VPWR cpuregs\[23\]\[19\] sky130_fd_sc_hd__dfxtp_1
XFILLER_136_41 VPWR VGND VPWR VGND sky130_ef_sc_hd__decap_12
XFILLER_20_85 VGND VGND VPWR VPWR sky130_fd_sc_hd__decap_6
XFILLER_136_85 VGND VGND VPWR VPWR sky130_fd_sc_hd__fill_2
XFILLER_106_197 VGND VGND VPWR VPWR sky130_fd_sc_hd__decap_8
X_10113_ clknet_leaf_16_clk _00243_ VGND VGND VPWR VPWR cpuregs\[28\]\[15\] sky130_fd_sc_hd__dfxtp_1
XFILLER_136_96 VGND VGND VPWR VPWR sky130_fd_sc_hd__decap_6
X_11093_ clknet_leaf_64_clk _01150_ VGND VGND VPWR VPWR cpuregs\[24\]\[24\] sky130_fd_sc_hd__dfxtp_1
XFILLER_121_156 VPWR VGND VPWR VGND sky130_ef_sc_hd__decap_12
XFILLER_121_145 VGND VGND VPWR VPWR sky130_fd_sc_hd__fill_2
XFILLER_103_893 VGND VGND VPWR VPWR sky130_fd_sc_hd__decap_3
XFILLER_102_381 VGND VGND VPWR VPWR sky130_fd_sc_hd__decap_4
XFILLER_88_593 VGND VGND VPWR VPWR sky130_fd_sc_hd__fill_1
X_10044_ clknet_leaf_13_clk _00174_ VGND VGND VPWR VPWR cpuregs\[13\]\[10\] sky130_fd_sc_hd__dfxtp_1
XFILLER_102_392 VGND VGND VPWR VPWR sky130_fd_sc_hd__fill_2
Xclkbuf_leaf_55_clk clknet_4_6_0_clk VGND VGND VPWR VPWR clknet_leaf_55_clk sky130_fd_sc_hd__clkbuf_8
XFILLER_91_747 VPWR VGND VPWR VGND sky130_ef_sc_hd__decap_12
XFILLER_16_332 VPWR VGND VPWR VGND sky130_ef_sc_hd__decap_12
XFILLER_17_833 VGND VGND VPWR VPWR sky130_fd_sc_hd__decap_6
X_10946_ clknet_leaf_92_clk _01008_ VGND VGND VPWR VPWR decoded_imm\[22\] sky130_fd_sc_hd__dfxtp_2
XFILLER_16_365 VGND VGND VPWR VPWR sky130_fd_sc_hd__decap_3
XFILLER_17_877 VPWR VGND VPWR VGND sky130_ef_sc_hd__decap_12
XFILLER_32_825 VPWR VGND VPWR VGND sky130_ef_sc_hd__decap_12
X_10877_ clknet_leaf_75_clk _00939_ VGND VGND VPWR VPWR cpuregs\[1\]\[21\] sky130_fd_sc_hd__dfxtp_1
XTAP_TAPCELL_ROW_63_1339 VGND VPWR sky130_fd_sc_hd__tapvpwrvgnd_1
XTAP_TAPCELL_ROW_14_555 VGND VPWR sky130_fd_sc_hd__tapvpwrvgnd_1
XFILLER_32_869 VPWR VGND VPWR VGND sky130_ef_sc_hd__decap_12
XFILLER_12_582 VGND VGND VPWR VPWR sky130_fd_sc_hd__decap_6
XANTENNA_3 _01579_ VGND VGND VPWR VPWR sky130_fd_sc_hd__diode_2
X_11429_ clknet_leaf_34_clk _01473_ VGND VGND VPWR VPWR cpuregs\[8\]\[27\] sky130_fd_sc_hd__dfxtp_1
XTAP_TAPCELL_ROW_78_1582 VGND VPWR sky130_fd_sc_hd__tapvpwrvgnd_1
XFILLER_6_65 VPWR VGND VPWR VGND sky130_ef_sc_hd__decap_12
XFILLER_99_847 VGND VGND VPWR VPWR sky130_fd_sc_hd__fill_1
XFILLER_140_410 VGND VGND VPWR VPWR sky130_fd_sc_hd__decap_8
XFILLER_113_635 VGND VGND VPWR VPWR sky130_fd_sc_hd__decap_6
XFILLER_4_781 VPWR VGND VPWR VGND sky130_ef_sc_hd__decap_12
XFILLER_140_454 VPWR VGND VPWR VGND sky130_ef_sc_hd__decap_12
X_06970_ _01579_ _03383_ VGND VGND VPWR VPWR _03384_ sky130_fd_sc_hd__or2_1
XFILLER_100_307 VGND VGND VPWR VPWR sky130_fd_sc_hd__fill_1
XTAP_TAPCELL_ROW_91_1793 VGND VPWR sky130_fd_sc_hd__tapvpwrvgnd_1
XTAP_TAPCELL_ROW_91_1782 VGND VPWR sky130_fd_sc_hd__tapvpwrvgnd_1
XFILLER_67_711 VPWR VGND VPWR VGND sky130_ef_sc_hd__decap_12
X_05921_ net195 net227 _02238_ _02472_ VGND VGND VPWR VPWR _02473_ sky130_fd_sc_hd__a31o_1
XFILLER_39_435 VGND VGND VPWR VPWR sky130_fd_sc_hd__decap_3
X_05852_ _02085_ _02240_ _02411_ VGND VGND VPWR VPWR _02412_ sky130_fd_sc_hd__a21o_1
XFILLER_94_530 VGND VGND VPWR VPWR sky130_fd_sc_hd__fill_2
X_08640_ decoded_imm\[8\] _01654_ _01586_ VGND VGND VPWR VPWR _04334_ sky130_fd_sc_hd__a21o_1
XTAP_TAPCELL_ROW_109_2081 VGND VPWR sky130_fd_sc_hd__tapvpwrvgnd_1
XTAP_TAPCELL_ROW_109_2070 VGND VPWR sky130_fd_sc_hd__tapvpwrvgnd_1
XFILLER_82_725 VGND VGND VPWR VPWR sky130_fd_sc_hd__decap_4
Xrebuffer26 _03600_ VGND VGND VPWR VPWR net412 sky130_fd_sc_hd__dlygate4sd1_1
Xrebuffer15 _04063_ VGND VGND VPWR VPWR net401 sky130_fd_sc_hd__dlygate4sd1_1
Xclkbuf_leaf_46_clk clknet_4_7_0_clk VGND VGND VPWR VPWR clknet_leaf_46_clk sky130_fd_sc_hd__clkbuf_8
X_05783_ _02113_ _02349_ VGND VGND VPWR VPWR _02350_ sky130_fd_sc_hd__nand2_1
XFILLER_70_909 VGND VGND VPWR VPWR sky130_fd_sc_hd__decap_3
Xrebuffer48 net435 VGND VGND VPWR VPWR net434 sky130_fd_sc_hd__dlygate4sd1_1
Xrebuffer59 _04073_ VGND VGND VPWR VPWR net445 sky130_fd_sc_hd__dlygate4sd1_1
Xrebuffer37 net424 VGND VGND VPWR VPWR net423 sky130_fd_sc_hd__dlygate4sd1_1
X_08571_ _00009_ _04267_ VGND VGND VPWR VPWR _04268_ sky130_fd_sc_hd__or2_1
XFILLER_81_268 VPWR VGND VPWR VGND sky130_ef_sc_hd__decap_12
X_07522_ _02607_ cpuregs\[16\]\[6\] _03570_ VGND VGND VPWR VPWR _00458_ sky130_fd_sc_hd__mux2_1
XTAP_TAPCELL_ROW_122_2281 VGND VPWR sky130_fd_sc_hd__tapvpwrvgnd_1
XFILLER_90_791 VGND VGND VPWR VPWR sky130_fd_sc_hd__decap_4
XFILLER_62_471 VGND VGND VPWR VPWR sky130_fd_sc_hd__decap_4
X_07453_ cpuregs\[15\]\[4\] _02598_ net246 VGND VGND VPWR VPWR _00392_ sky130_fd_sc_hd__mux2_1
XFILLER_22_335 VGND VGND VPWR VPWR sky130_fd_sc_hd__decap_8
XTAP_TAPCELL_ROW_33_853 VGND VPWR sky130_fd_sc_hd__tapvpwrvgnd_1
XTAP_TAPCELL_ROW_33_864 VGND VPWR sky130_fd_sc_hd__tapvpwrvgnd_1
X_06404_ cpuregs\[16\]\[4\] cpuregs\[17\]\[4\] cpuregs\[18\]\[4\] cpuregs\[19\]\[4\]
+ net264 net262 VGND VGND VPWR VPWR _02838_ sky130_fd_sc_hd__mux4_1
XTAP_TAPCELL_ROW_98_1903 VGND VPWR sky130_fd_sc_hd__tapvpwrvgnd_1
X_09123_ instr_lbu _04747_ _04754_ _04764_ VGND VGND VPWR VPWR _00857_ sky130_fd_sc_hd__a22o_1
X_07384_ cpuregs\[14\]\[2\] _02590_ net247 VGND VGND VPWR VPWR _00326_ sky130_fd_sc_hd__mux2_1
X_06335_ cpuregs\[24\]\[2\] cpuregs\[25\]\[2\] cpuregs\[26\]\[2\] cpuregs\[27\]\[2\]
+ net268 net262 VGND VGND VPWR VPWR _02771_ sky130_fd_sc_hd__mux4_1
X_06266_ reg_pc\[30\] _02702_ VGND VGND VPWR VPWR _02706_ sky130_fd_sc_hd__or2_1
X_09054_ _04715_ _04723_ _04724_ _01560_ _00010_ VGND VGND VPWR VPWR _04725_ sky130_fd_sc_hd__a221o_1
X_05217_ _01813_ _01815_ _01819_ VGND VGND VPWR VPWR _01820_ sky130_fd_sc_hd__nand3_1
X_08005_ _01551_ _03822_ _03823_ _03826_ VGND VGND VPWR VPWR _03827_ sky130_fd_sc_hd__o31a_1
Xmax_cap261 _00013_ VGND VGND VPWR VPWR net261 sky130_fd_sc_hd__buf_12
XFILLER_104_613 VGND VGND VPWR VPWR sky130_fd_sc_hd__fill_2
XFILLER_104_602 VGND VGND VPWR VPWR sky130_fd_sc_hd__decap_4
X_06197_ reg_out\[17\] alu_out_q\[17\] net587 VGND VGND VPWR VPWR _02650_ sky130_fd_sc_hd__mux2_1
XFILLER_144_793 VPWR VGND VPWR VGND sky130_ef_sc_hd__decap_12
X_05148_ _01754_ _01755_ _01741_ _01745_ VGND VGND VPWR VPWR _01756_ sky130_fd_sc_hd__o211ai_1
XFILLER_1_217 VGND VGND VPWR VPWR sky130_fd_sc_hd__decap_6
Xmax_cap272 net273 VGND VGND VPWR VPWR net272 sky130_fd_sc_hd__buf_12
XTAP_TAPCELL_ROW_129_2402 VGND VPWR sky130_fd_sc_hd__tapvpwrvgnd_1
XFILLER_103_167 VGND VGND VPWR VPWR sky130_fd_sc_hd__fill_1
X_09956_ clknet_leaf_92_clk _00086_ VGND VGND VPWR VPWR net179 sky130_fd_sc_hd__dfxtp_4
X_05079_ net10 _01669_ net130 net23 _01691_ VGND VGND VPWR VPWR _01692_ sky130_fd_sc_hd__a221o_1
X_08907_ _04580_ _04581_ _01558_ VGND VGND VPWR VPWR _04586_ sky130_fd_sc_hd__mux2_1
X_09887_ cpuregs\[0\]\[17\] VGND VGND VPWR VPWR _01495_ sky130_fd_sc_hd__clkbuf_1
XFILLER_106_77 VGND VGND VPWR VPWR sky130_fd_sc_hd__decap_6
XFILLER_58_744 VPWR VGND VPWR VGND sky130_ef_sc_hd__decap_12
XTAP_TAPCELL_ROW_142_2602 VGND VPWR sky130_fd_sc_hd__tapvpwrvgnd_1
X_08838_ _01559_ _04519_ _04520_ _04513_ _01560_ VGND VGND VPWR VPWR _04521_ sky130_fd_sc_hd__a221o_1
XPHY_EDGE_ROW_142_Right_142 VGND VGND VPWR VPWR sky130_fd_sc_hd__decap_3
XFILLER_57_287 VGND VGND VPWR VPWR sky130_fd_sc_hd__fill_1
Xclkbuf_leaf_37_clk clknet_4_5_0_clk VGND VGND VPWR VPWR clknet_leaf_37_clk sky130_fd_sc_hd__clkbuf_8
X_08769_ _04453_ _04455_ _04266_ _04452_ VGND VGND VPWR VPWR _04456_ sky130_fd_sc_hd__o211a_1
XFILLER_45_449 VPWR VGND VPWR VGND sky130_ef_sc_hd__decap_12
X_10800_ clknet_leaf_97_clk _00865_ VGND VGND VPWR VPWR instr_ori sky130_fd_sc_hd__dfxtp_1
X_10731_ clknet_leaf_50_clk _00828_ VGND VGND VPWR VPWR net217 sky130_fd_sc_hd__dfxtp_4
XFILLER_13_324 VPWR VGND VPWR VGND sky130_ef_sc_hd__decap_12
XFILLER_14_825 VPWR VGND VPWR VGND sky130_ef_sc_hd__decap_12
XFILLER_9_306 VGND VGND VPWR VPWR sky130_fd_sc_hd__fill_1
XFILLER_14_869 VPWR VGND VPWR VGND sky130_ef_sc_hd__decap_12
XTAP_TAPCELL_ROW_45_1047 VGND VPWR sky130_fd_sc_hd__tapvpwrvgnd_1
XTAP_TAPCELL_ROW_45_1058 VGND VPWR sky130_fd_sc_hd__tapvpwrvgnd_1
X_10662_ clknet_leaf_90_clk _04890_ VGND VGND VPWR VPWR reg_out\[20\] sky130_fd_sc_hd__dfxtp_1
XTAP_TAPCELL_ROW_11_514 VGND VPWR sky130_fd_sc_hd__tapvpwrvgnd_1
XTAP_TAPCELL_ROW_11_503 VGND VPWR sky130_fd_sc_hd__tapvpwrvgnd_1
XFILLER_40_165 VGND VGND VPWR VPWR sky130_fd_sc_hd__fill_1
X_10593_ clknet_leaf_86_clk _00723_ VGND VGND VPWR VPWR count_cycle\[16\] sky130_fd_sc_hd__dfxtp_1
XFILLER_127_738 VGND VGND VPWR VPWR sky130_fd_sc_hd__decap_8
XFILLER_31_51 VGND VGND VPWR VPWR sky130_fd_sc_hd__decap_4
XTAP_TAPCELL_ROW_153_2797 VGND VPWR sky130_fd_sc_hd__tapvpwrvgnd_1
XTAP_TAPCELL_ROW_153_2786 VGND VPWR sky130_fd_sc_hd__tapvpwrvgnd_1
XTAP_TAPCELL_ROW_153_2775 VGND VPWR sky130_fd_sc_hd__tapvpwrvgnd_1
XFILLER_147_51 VGND VGND VPWR VPWR sky130_fd_sc_hd__decap_4
XFILLER_141_218 VGND VGND VPWR VPWR sky130_fd_sc_hd__decap_6
XFILLER_135_782 VGND VGND VPWR VPWR sky130_fd_sc_hd__fill_2
X_11214_ clknet_leaf_148_clk _01261_ VGND VGND VPWR VPWR cpuregs\[3\]\[7\] sky130_fd_sc_hd__dfxtp_1
Xoutput51 net51 VGND VGND VPWR VPWR mem_addr[26] sky130_fd_sc_hd__buf_2
Xoutput40 net40 VGND VGND VPWR VPWR mem_addr[15] sky130_fd_sc_hd__buf_2
Xoutput84 net84 VGND VGND VPWR VPWR mem_la_addr[28] sky130_fd_sc_hd__buf_2
XFILLER_150_752 VGND VGND VPWR VPWR sky130_fd_sc_hd__decap_4
XFILLER_110_616 VPWR VGND VPWR VGND sky130_ef_sc_hd__decap_12
Xoutput73 net73 VGND VGND VPWR VPWR mem_la_addr[17] sky130_fd_sc_hd__buf_2
X_11145_ clknet_leaf_122_clk _01192_ VGND VGND VPWR VPWR cpuregs\[23\]\[2\] sky130_fd_sc_hd__dfxtp_1
Xoutput62 net62 VGND VGND VPWR VPWR mem_addr[7] sky130_fd_sc_hd__buf_2
XFILLER_122_498 VGND VGND VPWR VPWR sky130_fd_sc_hd__decap_3
Xoutput95 net95 VGND VGND VPWR VPWR mem_la_addr[9] sky130_fd_sc_hd__buf_2
X_11076_ clknet_leaf_142_clk _01133_ VGND VGND VPWR VPWR cpuregs\[24\]\[7\] sky130_fd_sc_hd__dfxtp_1
X_10027_ clknet_leaf_49_clk _00157_ VGND VGND VPWR VPWR cpuregs\[30\]\[25\] sky130_fd_sc_hd__dfxtp_1
XFILLER_76_541 VGND VGND VPWR VPWR sky130_fd_sc_hd__decap_3
XFILLER_91_533 VGND VGND VPWR VPWR sky130_fd_sc_hd__fill_1
Xclkbuf_leaf_28_clk clknet_4_4_0_clk VGND VGND VPWR VPWR clknet_leaf_28_clk sky130_fd_sc_hd__clkbuf_8
XFILLER_63_213 VGND VGND VPWR VPWR sky130_fd_sc_hd__decap_8
XFILLER_52_909 VGND VGND VPWR VPWR sky130_fd_sc_hd__decap_3
XFILLER_48_298 VGND VGND VPWR VPWR sky130_fd_sc_hd__decap_6
XTAP_TAPCELL_ROW_19_636 VGND VPWR sky130_fd_sc_hd__tapvpwrvgnd_1
XFILLER_17_685 VGND VGND VPWR VPWR sky130_fd_sc_hd__decap_4
X_10929_ clknet_leaf_113_clk _00991_ VGND VGND VPWR VPWR net170 sky130_fd_sc_hd__dfxtp_1
XFILLER_16_195 VGND VGND VPWR VPWR sky130_fd_sc_hd__fill_1
XFILLER_20_806 VGND VGND VPWR VPWR sky130_fd_sc_hd__decap_6
XTAP_TAPCELL_ROW_30_812 VGND VPWR sky130_fd_sc_hd__tapvpwrvgnd_1
XFILLER_12_390 VGND VGND VPWR VPWR sky130_fd_sc_hd__fill_1
XFILLER_9_895 VGND VGND VPWR VPWR sky130_fd_sc_hd__fill_1
X_06120_ _02588_ cpuregs\[11\]\[1\] _02582_ VGND VGND VPWR VPWR _00038_ sky130_fd_sc_hd__mux2_1
XFILLER_133_708 VPWR VGND VPWR VGND sky130_ef_sc_hd__decap_12
X_06051_ _02519_ _02520_ _02523_ _00010_ _00011_ VGND VGND VPWR VPWR _02524_ sky130_fd_sc_hd__a221o_1
XFILLER_114_911 VGND VGND VPWR VPWR sky130_fd_sc_hd__fill_1
XTAP_TAPCELL_ROW_93_1822 VGND VPWR sky130_fd_sc_hd__tapvpwrvgnd_1
X_05002_ mem_do_rdata _01549_ _01615_ VGND VGND VPWR VPWR _01630_ sky130_fd_sc_hd__nor3_2
XFILLER_126_793 VPWR VGND VPWR VGND sky130_ef_sc_hd__decap_12
XFILLER_125_281 VGND VGND VPWR VPWR sky130_fd_sc_hd__decap_4
XPHY_EDGE_ROW_99_Right_99 VGND VGND VPWR VPWR sky130_fd_sc_hd__decap_3
X_09810_ _02654_ cpuregs\[8\]\[17\] _04875_ VGND VGND VPWR VPWR _01463_ sky130_fd_sc_hd__mux2_1
XFILLER_87_806 VGND VGND VPWR VPWR sky130_fd_sc_hd__decap_8
XFILLER_141_785 VPWR VGND VPWR VGND sky130_ef_sc_hd__decap_12
X_06953_ reg_pc\[23\] _02751_ _03367_ _02715_ VGND VGND VPWR VPWR _03368_ sky130_fd_sc_hd__a211o_1
XFILLER_113_498 VGND VGND VPWR VPWR sky130_fd_sc_hd__fill_1
XFILLER_113_476 VGND VGND VPWR VPWR sky130_fd_sc_hd__fill_1
XFILLER_99_699 VGND VGND VPWR VPWR sky130_fd_sc_hd__fill_2
X_09741_ _02641_ cpuregs\[6\]\[14\] _04873_ VGND VGND VPWR VPWR _01396_ sky130_fd_sc_hd__mux2_1
X_05904_ _02072_ _02238_ _02457_ _02074_ VGND VGND VPWR VPWR _02458_ sky130_fd_sc_hd__o2bb2a_1
XTAP_TAPCELL_ROW_124_2321 VGND VPWR sky130_fd_sc_hd__tapvpwrvgnd_1
XTAP_TAPCELL_ROW_124_2310 VGND VPWR sky130_fd_sc_hd__tapvpwrvgnd_1
X_06884_ _01621_ _03298_ _03299_ _03300_ VGND VGND VPWR VPWR _03301_ sky130_fd_sc_hd__nor4_1
X_09672_ cpuregs\[4\]\[11\] _02630_ net238 VGND VGND VPWR VPWR _01329_ sky130_fd_sc_hd__mux2_1
X_05835_ _02097_ _02388_ _02218_ VGND VGND VPWR VPWR _02396_ sky130_fd_sc_hd__a21o_1
Xclkbuf_leaf_19_clk clknet_4_6_0_clk VGND VGND VPWR VPWR clknet_leaf_19_clk sky130_fd_sc_hd__clkbuf_8
XFILLER_55_758 VGND VGND VPWR VPWR sky130_fd_sc_hd__decap_8
XFILLER_54_213 VGND VGND VPWR VPWR sky130_fd_sc_hd__decap_4
XFILLER_27_449 VGND VGND VPWR VPWR sky130_fd_sc_hd__decap_4
XFILLER_36_29 VPWR VGND VPWR VGND sky130_ef_sc_hd__decap_12
X_08623_ cpuregs\[20\]\[8\] cpuregs\[21\]\[8\] cpuregs\[22\]\[8\] cpuregs\[23\]\[8\]
+ net278 net273 VGND VGND VPWR VPWR _04317_ sky130_fd_sc_hd__mux4_1
XTAP_TAPCELL_ROW_38_934 VGND VPWR sky130_fd_sc_hd__tapvpwrvgnd_1
XTAP_TAPCELL_ROW_38_945 VGND VPWR sky130_fd_sc_hd__tapvpwrvgnd_1
XFILLER_43_909 VGND VGND VPWR VPWR sky130_fd_sc_hd__decap_3
X_05766_ _02333_ _02334_ VGND VGND VPWR VPWR _02335_ sky130_fd_sc_hd__or2_1
X_08554_ decoded_imm\[1\] _01653_ VGND VGND VPWR VPWR _04255_ sky130_fd_sc_hd__nor2_1
X_07505_ cpuregs\[26\]\[23\] _02678_ _03568_ VGND VGND VPWR VPWR _00443_ sky130_fd_sc_hd__mux2_1
X_08485_ net69 net38 _04208_ VGND VGND VPWR VPWR _00783_ sky130_fd_sc_hd__mux2_1
X_05697_ _02168_ _02238_ _02272_ _02274_ VGND VGND VPWR VPWR alu_out\[5\] sky130_fd_sc_hd__a211o_1
XFILLER_149_841 VPWR VGND VPWR VGND sky130_ef_sc_hd__decap_12
X_07436_ cpuregs\[27\]\[20\] _02665_ _03566_ VGND VGND VPWR VPWR _00376_ sky130_fd_sc_hd__mux2_1
XTAP_TAPCELL_ROW_102_1962 VGND VPWR sky130_fd_sc_hd__tapvpwrvgnd_1
XFILLER_11_839 VGND VGND VPWR VPWR sky130_fd_sc_hd__fill_1
XFILLER_148_340 VGND VGND VPWR VPWR sky130_fd_sc_hd__decap_8
X_07367_ _02657_ cpuregs\[9\]\[18\] _03563_ VGND VGND VPWR VPWR _00310_ sky130_fd_sc_hd__mux2_1
XPHY_EDGE_ROW_99_Left_253 VGND VGND VPWR VPWR sky130_fd_sc_hd__decap_3
X_09106_ instr_bltu _04748_ _04750_ _04756_ VGND VGND VPWR VPWR _00851_ sky130_fd_sc_hd__a22o_1
XFILLER_6_309 VGND VGND VPWR VPWR sky130_fd_sc_hd__fill_1
X_06318_ cpuregs\[8\]\[1\] cpuregs\[9\]\[1\] cpuregs\[10\]\[1\] cpuregs\[11\]\[1\]
+ net268 net262 VGND VGND VPWR VPWR _02755_ sky130_fd_sc_hd__mux4_1
X_09037_ _04700_ _04701_ _01558_ VGND VGND VPWR VPWR _04709_ sky130_fd_sc_hd__mux2_1
X_07298_ cpuregs\[28\]\[16\] _02649_ net249 VGND VGND VPWR VPWR _00244_ sky130_fd_sc_hd__mux2_1
XTAP_TAPCELL_ROW_135_2494 VGND VPWR sky130_fd_sc_hd__tapvpwrvgnd_1
X_06249_ reg_out\[27\] alu_out_q\[27\] net587 VGND VGND VPWR VPWR _02692_ sky130_fd_sc_hd__mux2_1
XFILLER_2_504 VPWR VGND VPWR VGND sky130_ef_sc_hd__decap_12
XFILLER_117_43 VPWR VGND VPWR VGND sky130_ef_sc_hd__decap_12
XFILLER_116_292 VGND VGND VPWR VPWR sky130_fd_sc_hd__decap_6
XFILLER_77_305 VPWR VGND VPWR VGND sky130_ef_sc_hd__decap_12
Xclkbuf_4_13_0_clk clknet_0_clk VGND VGND VPWR VPWR clknet_4_13_0_clk sky130_fd_sc_hd__clkbuf_8
X_09939_ clknet_leaf_127_clk _00069_ VGND VGND VPWR VPWR net171 sky130_fd_sc_hd__dfxtp_4
XFILLER_93_24 VPWR VGND VPWR VGND sky130_ef_sc_hd__decap_12
XFILLER_93_57 VPWR VGND VPWR VGND sky130_ef_sc_hd__decap_12
XFILLER_85_393 VGND VGND VPWR VPWR sky130_fd_sc_hd__decap_6
XFILLER_93_79 VGND VGND VPWR VPWR sky130_fd_sc_hd__decap_8
XFILLER_41_441 VGND VGND VPWR VPWR sky130_fd_sc_hd__fill_1
XFILLER_9_125 VPWR VGND VPWR VGND sky130_ef_sc_hd__decap_12
XFILLER_13_154 VPWR VGND VPWR VGND sky130_ef_sc_hd__decap_12
X_10714_ clknet_leaf_138_clk _00811_ VGND VGND VPWR VPWR net124 sky130_fd_sc_hd__dfxtp_4
XFILLER_41_474 VGND VGND VPWR VPWR sky130_fd_sc_hd__fill_1
X_10645_ clknet_leaf_129_clk _04903_ VGND VGND VPWR VPWR reg_out\[3\] sky130_fd_sc_hd__dfxtp_1
XFILLER_10_861 VGND VGND VPWR VPWR sky130_fd_sc_hd__decap_6
XFILLER_9_169 VGND VGND VPWR VPWR sky130_fd_sc_hd__decap_8
XFILLER_127_557 VGND VGND VPWR VPWR sky130_fd_sc_hd__decap_3
X_10576_ clknet_leaf_59_clk _00706_ VGND VGND VPWR VPWR reg_next_pc\[31\] sky130_fd_sc_hd__dfxtp_1
Xrebuffer6 net410 VGND VGND VPWR VPWR net392 sky130_fd_sc_hd__dlygate4sd1_1
XFILLER_115_719 VGND VGND VPWR VPWR sky130_fd_sc_hd__decap_8
XTAP_TAPCELL_ROW_75_1530 VGND VPWR sky130_fd_sc_hd__tapvpwrvgnd_1
XFILLER_142_538 VGND VGND VPWR VPWR sky130_fd_sc_hd__fill_2
XFILLER_107_281 VPWR VGND VPWR VGND sky130_ef_sc_hd__decap_12
XFILLER_47_7 VGND VGND VPWR VPWR sky130_fd_sc_hd__fill_1
XFILLER_150_560 VGND VGND VPWR VPWR sky130_fd_sc_hd__fill_1
XFILLER_123_785 VPWR VGND VPWR VGND sky130_ef_sc_hd__decap_12
X_11128_ clknet_leaf_21_clk _01175_ VGND VGND VPWR VPWR cpuregs\[31\]\[17\] sky130_fd_sc_hd__dfxtp_1
XFILLER_3_55 VGND VGND VPWR VPWR sky130_fd_sc_hd__fill_1
XFILLER_1_581 VPWR VGND VPWR VGND sky130_ef_sc_hd__decap_12
XFILLER_49_552 VGND VGND VPWR VPWR sky130_fd_sc_hd__fill_2
X_11059_ clknet_leaf_101_clk _01116_ VGND VGND VPWR VPWR mem_rdata_q\[22\] sky130_fd_sc_hd__dfxtp_1
XFILLER_37_714 VGND VGND VPWR VPWR sky130_fd_sc_hd__fill_1
XFILLER_64_533 VGND VGND VPWR VPWR sky130_fd_sc_hd__decap_3
XFILLER_36_213 VGND VGND VPWR VPWR sky130_fd_sc_hd__fill_1
X_05620_ _02171_ _02192_ _02202_ VGND VGND VPWR VPWR _02203_ sky130_fd_sc_hd__a21boi_2
XFILLER_51_205 VGND VGND VPWR VPWR sky130_fd_sc_hd__decap_4
X_05551_ net202 net234 VGND VGND VPWR VPWR _02134_ sky130_fd_sc_hd__nor2_1
XFILLER_60_750 VGND VGND VPWR VPWR sky130_fd_sc_hd__decap_3
XFILLER_17_493 VGND VGND VPWR VPWR sky130_fd_sc_hd__decap_8
XFILLER_149_137 VPWR VGND VPWR VGND sky130_ef_sc_hd__decap_12
X_05482_ _02062_ _02064_ VGND VGND VPWR VPWR _02065_ sky130_fd_sc_hd__or2_1
XFILLER_60_772 VGND VGND VPWR VPWR sky130_fd_sc_hd__fill_1
X_08270_ count_cycle\[4\] net402 count_cycle\[5\] VGND VGND VPWR VPWR _04066_ sky130_fd_sc_hd__a21o_1
XFILLER_146_800 VPWR VGND VPWR VGND sky130_ef_sc_hd__decap_12
X_07221_ cpuregs\[13\]\[5\] _02603_ net251 VGND VGND VPWR VPWR _00169_ sky130_fd_sc_hd__mux2_1
X_07152_ cpuregs\[12\]\[6\] _02607_ net253 VGND VGND VPWR VPWR _00106_ sky130_fd_sc_hd__mux2_1
XFILLER_9_692 VGND VGND VPWR VPWR sky130_fd_sc_hd__fill_2
X_06103_ _02572_ _02573_ _01558_ VGND VGND VPWR VPWR _02574_ sky130_fd_sc_hd__mux2_1
X_07083_ cpuregs\[12\]\[28\] cpuregs\[13\]\[28\] cpuregs\[14\]\[28\] cpuregs\[15\]\[28\]
+ net266 net261 VGND VGND VPWR VPWR _03493_ sky130_fd_sc_hd__mux4_1
XFILLER_133_505 VGND VGND VPWR VPWR sky130_fd_sc_hd__decap_6
XFILLER_106_719 VGND VGND VPWR VPWR sky130_fd_sc_hd__fill_2
Xclkbuf_leaf_8_clk clknet_4_1_0_clk VGND VGND VPWR VPWR clknet_leaf_8_clk sky130_fd_sc_hd__clkbuf_8
XFILLER_133_549 VGND VGND VPWR VPWR sky130_fd_sc_hd__decap_4
XFILLER_133_527 VGND VGND VPWR VPWR sky130_fd_sc_hd__decap_3
X_06034_ decoded_imm_j\[16\] _01110_ _02513_ VGND VGND VPWR VPWR _00033_ sky130_fd_sc_hd__mux2_1
XFILLER_101_402 VGND VGND VPWR VPWR sky130_fd_sc_hd__fill_2
XFILLER_87_669 VGND VGND VPWR VPWR sky130_fd_sc_hd__decap_3
XFILLER_87_658 VGND VGND VPWR VPWR sky130_fd_sc_hd__fill_2
XFILLER_86_135 VGND VGND VPWR VPWR sky130_fd_sc_hd__decap_4
XFILLER_75_809 VPWR VGND VPWR VGND sky130_ef_sc_hd__decap_12
XFILLER_68_850 VGND VGND VPWR VPWR sky130_fd_sc_hd__fill_1
X_07985_ _03806_ _03807_ VGND VGND VPWR VPWR _03808_ sky130_fd_sc_hd__and2_1
XFILLER_59_349 VGND VGND VPWR VPWR sky130_fd_sc_hd__decap_3
XFILLER_101_479 VGND VGND VPWR VPWR sky130_fd_sc_hd__decap_8
X_06936_ net185 _02721_ _03276_ _01641_ VGND VGND VPWR VPWR _03351_ sky130_fd_sc_hd__o211a_1
X_09724_ _02709_ cpuregs\[5\]\[30\] _04872_ VGND VGND VPWR VPWR _01380_ sky130_fd_sc_hd__mux2_1
X_06867_ cpuregs\[4\]\[20\] cpuregs\[5\]\[20\] cpuregs\[6\]\[20\] cpuregs\[7\]\[20\]
+ _00012_ _00013_ VGND VGND VPWR VPWR _03285_ sky130_fd_sc_hd__mux4_1
X_09655_ _02699_ cpuregs\[22\]\[28\] _04869_ VGND VGND VPWR VPWR _01314_ sky130_fd_sc_hd__mux2_1
XFILLER_83_831 VGND VGND VPWR VPWR sky130_fd_sc_hd__fill_2
XFILLER_67_393 VGND VGND VPWR VPWR sky130_fd_sc_hd__decap_4
XTAP_TAPCELL_ROW_2_356 VGND VPWR sky130_fd_sc_hd__tapvpwrvgnd_1
X_05818_ _02380_ VGND VGND VPWR VPWR _02381_ sky130_fd_sc_hd__inv_2
XFILLER_83_864 VGND VGND VPWR VPWR sky130_fd_sc_hd__decap_4
XTAP_TAPCELL_ROW_2_367 VGND VPWR sky130_fd_sc_hd__tapvpwrvgnd_1
X_08606_ cpuregs\[16\]\[7\] cpuregs\[17\]\[7\] cpuregs\[18\]\[7\] cpuregs\[19\]\[7\]
+ net279 _00008_ VGND VGND VPWR VPWR _04301_ sky130_fd_sc_hd__mux4_1
X_09586_ cpuregs\[29\]\[25\] _02688_ _04867_ VGND VGND VPWR VPWR _01247_ sky130_fd_sc_hd__mux2_1
X_06798_ net185 net254 VGND VGND VPWR VPWR _03218_ sky130_fd_sc_hd__or2_1
XFILLER_83_897 VGND VGND VPWR VPWR sky130_fd_sc_hd__decap_6
XFILLER_70_525 VGND VGND VPWR VPWR sky130_fd_sc_hd__decap_6
XFILLER_27_279 VGND VGND VPWR VPWR sky130_fd_sc_hd__fill_1
XFILLER_42_216 VGND VGND VPWR VPWR sky130_fd_sc_hd__fill_2
X_05749_ _02156_ _02318_ VGND VGND VPWR VPWR _02320_ sky130_fd_sc_hd__or2_1
X_08537_ cpuregs\[8\]\[1\] cpuregs\[9\]\[1\] cpuregs\[10\]\[1\] cpuregs\[11\]\[1\]
+ net279 _00008_ VGND VGND VPWR VPWR _04238_ sky130_fd_sc_hd__mux4_1
X_08468_ _02714_ _04204_ _04170_ VGND VGND VPWR VPWR _04205_ sky130_fd_sc_hd__a21oi_1
XTAP_TAPCELL_ROW_42_1006 VGND VPWR sky130_fd_sc_hd__tapvpwrvgnd_1
XTAP_TAPCELL_ROW_137_2523 VGND VPWR sky130_fd_sc_hd__tapvpwrvgnd_1
X_07419_ cpuregs\[27\]\[3\] _02593_ _03566_ VGND VGND VPWR VPWR _00359_ sky130_fd_sc_hd__mux2_1
XFILLER_23_485 VGND VGND VPWR VPWR sky130_fd_sc_hd__decap_8
XFILLER_137_833 VGND VGND VPWR VPWR sky130_fd_sc_hd__decap_6
X_08399_ _04148_ net34 _04147_ VGND VGND VPWR VPWR _00758_ sky130_fd_sc_hd__and3b_1
X_10430_ clknet_leaf_8_clk _00560_ VGND VGND VPWR VPWR cpuregs\[17\]\[12\] sky130_fd_sc_hd__dfxtp_1
XTAP_TAPCELL_ROW_21_664 VGND VPWR sky130_fd_sc_hd__tapvpwrvgnd_1
XFILLER_109_557 VGND VGND VPWR VPWR sky130_fd_sc_hd__decap_3
XFILLER_6_139 VGND VGND VPWR VPWR sky130_fd_sc_hd__fill_1
XFILLER_12_53 VPWR VGND VPWR VGND sky130_ef_sc_hd__decap_12
XTAP_TAPCELL_ROW_21_675 VGND VPWR sky130_fd_sc_hd__tapvpwrvgnd_1
XFILLER_152_825 VPWR VGND VPWR VGND sky130_ef_sc_hd__decap_12
XTAP_TAPCELL_ROW_150_2734 VGND VPWR sky130_fd_sc_hd__tapvpwrvgnd_1
XFILLER_137_877 VPWR VGND VPWR VGND sky130_ef_sc_hd__decap_12
XFILLER_136_365 VGND VGND VPWR VPWR sky130_fd_sc_hd__decap_6
XFILLER_128_53 VPWR VGND VPWR VGND sky130_ef_sc_hd__decap_12
XFILLER_109_579 VPWR VGND VPWR VGND sky130_ef_sc_hd__decap_12
XFILLER_12_97 VGND VGND VPWR VPWR sky130_fd_sc_hd__decap_6
X_10361_ clknet_leaf_145_clk _00491_ VGND VGND VPWR VPWR cpuregs\[25\]\[7\] sky130_fd_sc_hd__dfxtp_1
XFILLER_128_97 VGND VGND VPWR VPWR sky130_fd_sc_hd__decap_6
XFILLER_2_301 VGND VGND VPWR VPWR sky130_fd_sc_hd__decap_6
X_10292_ clknet_leaf_120_clk _00422_ VGND VGND VPWR VPWR cpuregs\[26\]\[2\] sky130_fd_sc_hd__dfxtp_1
XFILLER_152_869 VPWR VGND VPWR VGND sky130_ef_sc_hd__decap_12
XFILLER_105_763 VPWR VGND VPWR VGND sky130_ef_sc_hd__decap_12
XFILLER_5_3 VPWR VGND VPWR VGND sky130_ef_sc_hd__decap_12
XFILLER_144_41 VPWR VGND VPWR VGND sky130_ef_sc_hd__decap_12
XFILLER_105_785 VGND VGND VPWR VPWR sky130_fd_sc_hd__decap_8
XFILLER_104_262 VGND VGND VPWR VPWR sky130_fd_sc_hd__decap_3
XFILLER_77_113 VPWR VGND VPWR VGND sky130_ef_sc_hd__decap_12
XFILLER_2_389 VPWR VGND VPWR VGND sky130_ef_sc_hd__decap_12
XTAP_TAPCELL_ROW_53_1179 VGND VPWR sky130_fd_sc_hd__tapvpwrvgnd_1
XTAP_TAPCELL_ROW_148_2696 VGND VPWR sky130_fd_sc_hd__tapvpwrvgnd_1
XFILLER_144_85 VGND VGND VPWR VPWR sky130_fd_sc_hd__decap_6
XFILLER_59_883 VGND VGND VPWR VPWR sky130_fd_sc_hd__decap_3
XFILLER_59_872 VGND VGND VPWR VPWR sky130_fd_sc_hd__fill_1
XFILLER_58_371 VGND VGND VPWR VPWR sky130_fd_sc_hd__decap_8
XFILLER_19_725 VGND VGND VPWR VPWR sky130_fd_sc_hd__decap_3
XFILLER_74_853 VGND VGND VPWR VPWR sky130_fd_sc_hd__fill_2
XFILLER_46_544 VPWR VGND VPWR VGND sky130_ef_sc_hd__decap_12
XTAP_TAPCELL_ROW_29_797 VGND VPWR sky130_fd_sc_hd__tapvpwrvgnd_1
XFILLER_41_260 VGND VGND VPWR VPWR sky130_fd_sc_hd__decap_4
XTAP_TAPCELL_ROW_40_973 VGND VPWR sky130_fd_sc_hd__tapvpwrvgnd_1
XFILLER_139_181 VGND VGND VPWR VPWR sky130_fd_sc_hd__decap_4
XFILLER_127_310 VGND VGND VPWR VPWR sky130_fd_sc_hd__fill_1
X_10628_ clknet_leaf_85_clk _00758_ VGND VGND VPWR VPWR count_cycle\[51\] sky130_fd_sc_hd__dfxtp_1
Xpicorv32_327 VGND VGND VPWR VPWR picorv32_327/HI pcpi_insn[10] sky130_fd_sc_hd__conb_1
XFILLER_127_354 VGND VGND VPWR VPWR sky130_fd_sc_hd__fill_1
XFILLER_115_505 VPWR VGND VPWR VGND sky130_ef_sc_hd__decap_12
X_10559_ clknet_leaf_95_clk _00689_ VGND VGND VPWR VPWR reg_next_pc\[14\] sky130_fd_sc_hd__dfxtp_1
Xpicorv32_316 VGND VGND VPWR VPWR picorv32_316/HI mem_la_addr[1] sky130_fd_sc_hd__conb_1
Xpicorv32_305 VGND VGND VPWR VPWR picorv32_305/HI eoi[24] sky130_fd_sc_hd__conb_1
XFILLER_142_313 VGND VGND VPWR VPWR sky130_fd_sc_hd__fill_1
XFILLER_5_161 VGND VGND VPWR VPWR sky130_fd_sc_hd__decap_6
Xpicorv32_349 VGND VGND VPWR VPWR picorv32_349/HI pcpi_valid sky130_fd_sc_hd__conb_1
Xpicorv32_338 VGND VGND VPWR VPWR picorv32_338/HI pcpi_insn[21] sky130_fd_sc_hd__conb_1
XFILLER_130_508 VGND VGND VPWR VPWR sky130_fd_sc_hd__decap_3
XFILLER_123_582 VGND VGND VPWR VPWR sky130_fd_sc_hd__decap_4
XFILLER_38_3 VPWR VGND VPWR VGND sky130_ef_sc_hd__decap_12
XFILLER_111_766 VPWR VGND VPWR VGND sky130_ef_sc_hd__decap_12
X_07770_ _03653_ net34 _03652_ VGND VGND VPWR VPWR _00624_ sky130_fd_sc_hd__and3b_1
X_04982_ net33 net134 VGND VGND VPWR VPWR _01610_ sky130_fd_sc_hd__nand2_1
XTAP_TAPCELL_ROW_88_1743 VGND VPWR sky130_fd_sc_hd__tapvpwrvgnd_1
XTAP_TAPCELL_ROW_88_1732 VGND VPWR sky130_fd_sc_hd__tapvpwrvgnd_1
X_06721_ cpuregs\[24\]\[15\] cpuregs\[25\]\[15\] cpuregs\[26\]\[15\] cpuregs\[27\]\[15\]
+ net264 net259 VGND VGND VPWR VPWR _03144_ sky130_fd_sc_hd__mux4_1
XFILLER_49_393 VGND VGND VPWR VPWR sky130_fd_sc_hd__decap_8
X_09440_ _02630_ cpuregs\[19\]\[11\] _04863_ VGND VGND VPWR VPWR _01073_ sky130_fd_sc_hd__mux2_1
XFILLER_65_897 VGND VGND VPWR VPWR sky130_fd_sc_hd__fill_2
X_06652_ _03073_ _03076_ _03077_ _01581_ _01580_ VGND VGND VPWR VPWR _03078_ sky130_fd_sc_hd__a221o_1
X_09371_ instr_jal decoded_imm_j\[10\] _04823_ mem_rdata_q\[30\] _04747_ VGND VGND
+ VPWR VPWR _04848_ sky130_fd_sc_hd__a221o_1
X_06583_ _03009_ _03010_ VGND VGND VPWR VPWR _03011_ sky130_fd_sc_hd__nor2_1
X_05603_ _02141_ _02184_ _02185_ VGND VGND VPWR VPWR _02186_ sky130_fd_sc_hd__a21oi_1
XFILLER_17_290 VGND VGND VPWR VPWR sky130_fd_sc_hd__decap_3
X_08322_ count_cycle\[23\] _04098_ VGND VGND VPWR VPWR _04100_ sky130_fd_sc_hd__and2_1
X_05534_ _02116_ VGND VGND VPWR VPWR _02117_ sky130_fd_sc_hd__inv_2
X_08253_ decoded_imm_j\[20\] _03720_ VGND VGND VPWR VPWR _04055_ sky130_fd_sc_hd__xnor2_1
X_07204_ cpuregs\[30\]\[22\] _02675_ _03556_ VGND VGND VPWR VPWR _00154_ sky130_fd_sc_hd__mux2_1
XTAP_TAPCELL_ROW_119_2242 VGND VPWR sky130_fd_sc_hd__tapvpwrvgnd_1
XTAP_TAPCELL_ROW_119_2231 VGND VPWR sky130_fd_sc_hd__tapvpwrvgnd_1
X_05465_ instr_bne is_sltiu_bltu_sltu _02047_ VGND VGND VPWR VPWR _02048_ sky130_fd_sc_hd__or3_1
X_08184_ _03712_ _03978_ VGND VGND VPWR VPWR _03992_ sky130_fd_sc_hd__and2_1
XFILLER_119_833 VGND VGND VPWR VPWR sky130_fd_sc_hd__decap_6
X_05396_ net19 _01665_ _01856_ VGND VGND VPWR VPWR _01985_ sky130_fd_sc_hd__a21o_1
XFILLER_20_477 VGND VGND VPWR VPWR sky130_fd_sc_hd__decap_4
XFILLER_134_825 VPWR VGND VPWR VGND sky130_ef_sc_hd__decap_12
XFILLER_119_877 VPWR VGND VPWR VGND sky130_ef_sc_hd__decap_12
XFILLER_106_505 VPWR VGND VPWR VGND sky130_ef_sc_hd__decap_12
X_07135_ _00014_ _03537_ _00016_ VGND VGND VPWR VPWR _03543_ sky130_fd_sc_hd__o21a_1
XFILLER_145_162 VGND VGND VPWR VPWR sky130_fd_sc_hd__decap_6
XTAP_TAPCELL_ROW_132_2442 VGND VPWR sky130_fd_sc_hd__tapvpwrvgnd_1
XFILLER_133_313 VGND VGND VPWR VPWR sky130_fd_sc_hd__fill_1
X_07066_ decoded_imm\[28\] net191 VGND VGND VPWR VPWR _03476_ sky130_fd_sc_hd__nand2_1
XFILLER_134_869 VPWR VGND VPWR VGND sky130_ef_sc_hd__decap_12
X_06017_ reg_out\[31\] reg_next_pc\[31\] net596 VGND VGND VPWR VPWR _02512_ sky130_fd_sc_hd__mux2_1
Xoutput230 net230 VGND VGND VPWR VPWR pcpi_rs2[5] sky130_fd_sc_hd__buf_2
XFILLER_133_379 VGND VGND VPWR VPWR sky130_fd_sc_hd__decap_4
XTAP_TAPCELL_ROW_7_448 VGND VPWR sky130_fd_sc_hd__tapvpwrvgnd_1
XTAP_TAPCELL_ROW_7_437 VGND VPWR sky130_fd_sc_hd__tapvpwrvgnd_1
XFILLER_102_733 VPWR VGND VPWR VGND sky130_ef_sc_hd__decap_12
XFILLER_59_146 VPWR VGND VPWR VGND sky130_ef_sc_hd__decap_12
XFILLER_58_49 VGND VGND VPWR VPWR sky130_fd_sc_hd__fill_1
XFILLER_75_617 VGND VGND VPWR VPWR sky130_fd_sc_hd__fill_2
X_07968_ instr_jal _03785_ _03786_ _03790_ _03792_ VGND VGND VPWR VPWR _03793_ sky130_fd_sc_hd__o32a_1
X_06919_ cpuregs\[0\]\[22\] cpuregs\[1\]\[22\] cpuregs\[2\]\[22\] cpuregs\[3\]\[22\]
+ net267 net261 VGND VGND VPWR VPWR _03335_ sky130_fd_sc_hd__mux4_1
XFILLER_101_276 VGND VGND VPWR VPWR sky130_fd_sc_hd__decap_4
XFILLER_74_15 VPWR VGND VPWR VGND sky130_ef_sc_hd__decap_12
X_09707_ _02638_ cpuregs\[5\]\[13\] _04872_ VGND VGND VPWR VPWR _01363_ sky130_fd_sc_hd__mux2_1
XFILLER_56_853 VGND VGND VPWR VPWR sky130_fd_sc_hd__decap_6
X_07899_ instr_jal _03728_ _03729_ _03724_ VGND VGND VPWR VPWR _03730_ sky130_fd_sc_hd__a31o_1
X_09638_ _02630_ cpuregs\[22\]\[11\] _04869_ VGND VGND VPWR VPWR _01297_ sky130_fd_sc_hd__mux2_1
XFILLER_82_182 VPWR VGND VPWR VGND sky130_ef_sc_hd__decap_12
XFILLER_55_396 VPWR VGND VPWR VGND sky130_ef_sc_hd__decap_12
XTAP_TAPCELL_ROW_26_745 VGND VPWR sky130_fd_sc_hd__tapvpwrvgnd_1
X_09569_ cpuregs\[29\]\[8\] _02616_ net239 VGND VGND VPWR VPWR _01230_ sky130_fd_sc_hd__mux2_1
XFILLER_43_547 VGND VGND VPWR VPWR sky130_fd_sc_hd__decap_6
XFILLER_130_65 VGND VGND VPWR VPWR sky130_fd_sc_hd__decap_8
XFILLER_24_750 VGND VGND VPWR VPWR sky130_fd_sc_hd__decap_6
XFILLER_142_3 VPWR VGND VPWR VGND sky130_ef_sc_hd__decap_12
XFILLER_8_905 VGND VGND VPWR VPWR sky130_fd_sc_hd__decap_6
XFILLER_24_794 VPWR VGND VPWR VGND sky130_ef_sc_hd__decap_12
X_11462_ clknet_leaf_39_clk _01506_ VGND VGND VPWR VPWR cpuregs\[0\]\[28\] sky130_fd_sc_hd__dfxtp_1
XFILLER_109_332 VGND VGND VPWR VPWR sky130_fd_sc_hd__decap_4
X_11393_ clknet_leaf_42_clk _01437_ VGND VGND VPWR VPWR cpuregs\[7\]\[23\] sky130_fd_sc_hd__dfxtp_1
X_10413_ clknet_leaf_35_clk _00543_ VGND VGND VPWR VPWR cpuregs\[20\]\[27\] sky130_fd_sc_hd__dfxtp_1
X_10344_ clknet_leaf_47_clk _00474_ VGND VGND VPWR VPWR cpuregs\[16\]\[22\] sky130_fd_sc_hd__dfxtp_1
XFILLER_109_398 VGND VGND VPWR VPWR sky130_fd_sc_hd__decap_4
XFILLER_136_195 VGND VGND VPWR VPWR sky130_fd_sc_hd__fill_1
XTAP_TAPCELL_ROW_55_1219 VGND VPWR sky130_fd_sc_hd__tapvpwrvgnd_1
XTAP_TAPCELL_ROW_55_1208 VGND VPWR sky130_fd_sc_hd__tapvpwrvgnd_1
X_10275_ clknet_leaf_25_clk _00405_ VGND VGND VPWR VPWR cpuregs\[15\]\[17\] sky130_fd_sc_hd__dfxtp_1
XFILLER_3_665 VGND VGND VPWR VPWR sky130_fd_sc_hd__decap_6
XFILLER_2_153 VPWR VGND VPWR VGND sky130_ef_sc_hd__decap_12
XFILLER_2_197 VPWR VGND VPWR VGND sky130_ef_sc_hd__decap_12
XFILLER_78_477 VPWR VGND VPWR VGND sky130_ef_sc_hd__decap_12
XPHY_EDGE_ROW_45_Left_199 VGND VGND VPWR VPWR sky130_fd_sc_hd__decap_3
XFILLER_47_897 VGND VGND VPWR VPWR sky130_fd_sc_hd__decap_4
XFILLER_19_577 VGND VGND VPWR VPWR sky130_fd_sc_hd__fill_1
XFILLER_46_363 VGND VGND VPWR VPWR sky130_fd_sc_hd__fill_1
XTAP_TAPCELL_ROW_83_1662 VGND VPWR sky130_fd_sc_hd__tapvpwrvgnd_1
XFILLER_14_293 VGND VGND VPWR VPWR sky130_fd_sc_hd__fill_2
X_05250_ cpu_state\[4\] net176 _01845_ _01847_ _01850_ VGND VGND VPWR VPWR _04883_
+ sky130_fd_sc_hd__a2111o_1
X_05181_ count_instr\[41\] instr_rdinstrh net257 _01786_ VGND VGND VPWR VPWR _01787_
+ sky130_fd_sc_hd__a211o_1
XTAP_TAPCELL_ROW_114_2150 VGND VPWR sky130_fd_sc_hd__tapvpwrvgnd_1
XFILLER_116_869 VPWR VGND VPWR VGND sky130_ef_sc_hd__decap_12
XTAP_TAPCELL_ROW_114_2161 VGND VPWR sky130_fd_sc_hd__tapvpwrvgnd_1
X_08940_ net270 _04616_ VGND VGND VPWR VPWR _04617_ sky130_fd_sc_hd__or2_1
XFILLER_142_165 VGND VGND VPWR VPWR sky130_fd_sc_hd__fill_1
XFILLER_131_839 VGND VGND VPWR VPWR sky130_fd_sc_hd__fill_1
X_08871_ _01558_ _04542_ net269 VGND VGND VPWR VPWR _04552_ sky130_fd_sc_hd__o21a_1
XFILLER_130_349 VPWR VGND VPWR VGND sky130_ef_sc_hd__decap_12
X_07822_ _03684_ count_instr\[63\] _01549_ VGND VGND VPWR VPWR _03686_ sky130_fd_sc_hd__a21oi_2
XFILLER_96_241 VGND VGND VPWR VPWR sky130_fd_sc_hd__decap_8
XFILLER_57_617 VPWR VGND VPWR VGND sky130_ef_sc_hd__decap_12
XFILLER_69_488 VPWR VGND VPWR VGND sky130_ef_sc_hd__decap_12
X_04965_ instr_fence instr_and instr_lbu instr_lb VGND VGND VPWR VPWR _01595_ sky130_fd_sc_hd__or4_1
X_07753_ count_instr\[37\] count_instr\[36\] _03639_ VGND VGND VPWR VPWR _03643_ sky130_fd_sc_hd__and3_1
X_06704_ _00015_ _03124_ _03127_ _02735_ VGND VGND VPWR VPWR _03128_ sky130_fd_sc_hd__o211a_1
X_07684_ count_instr\[12\] count_instr\[11\] _03595_ VGND VGND VPWR VPWR _03599_ sky130_fd_sc_hd__and3_1
XFILLER_65_694 VGND VGND VPWR VPWR sky130_fd_sc_hd__decap_3
XFILLER_53_823 VGND VGND VPWR VPWR sky130_fd_sc_hd__fill_1
XFILLER_25_503 VGND VGND VPWR VPWR sky130_fd_sc_hd__fill_1
XFILLER_25_525 VGND VGND VPWR VPWR sky130_fd_sc_hd__decap_8
X_09423_ _02696_ cpuregs\[18\]\[27\] _04862_ VGND VGND VPWR VPWR _01057_ sky130_fd_sc_hd__mux2_1
X_06635_ _03033_ _03059_ _03058_ VGND VGND VPWR VPWR _03061_ sky130_fd_sc_hd__o21bai_1
XFILLER_64_193 VGND VGND VPWR VPWR sky130_fd_sc_hd__decap_3
XFILLER_44_29 VPWR VGND VPWR VGND sky130_ef_sc_hd__decap_12
X_09354_ instr_jal decoded_imm_j\[18\] _01589_ mem_rdata_q\[18\] VGND VGND VPWR VPWR
+ _04839_ sky130_fd_sc_hd__a22o_1
XFILLER_80_664 VGND VGND VPWR VPWR sky130_fd_sc_hd__fill_1
XFILLER_52_377 VPWR VGND VPWR VGND sky130_ef_sc_hd__decap_12
XTAP_TAPCELL_ROW_23_704 VGND VPWR sky130_fd_sc_hd__tapvpwrvgnd_1
X_08305_ count_cycle\[17\] _04085_ net34 VGND VGND VPWR VPWR _04089_ sky130_fd_sc_hd__o21ai_1
X_06566_ cpuregs\[4\]\[9\] cpuregs\[5\]\[9\] cpuregs\[6\]\[9\] cpuregs\[7\]\[9\] net263
+ net259 VGND VGND VPWR VPWR _02995_ sky130_fd_sc_hd__mux4_1
XFILLER_33_580 VPWR VGND VPWR VGND sky130_ef_sc_hd__decap_12
XFILLER_40_528 VGND VGND VPWR VPWR sky130_fd_sc_hd__fill_1
X_05517_ _02099_ VGND VGND VPWR VPWR _02100_ sky130_fd_sc_hd__inv_2
XFILLER_100_57 VGND VGND VPWR VPWR sky130_fd_sc_hd__fill_1
X_09285_ net141 net103 _04206_ VGND VGND VPWR VPWR _00971_ sky130_fd_sc_hd__mux2_1
X_06497_ _02897_ _02900_ _02899_ VGND VGND VPWR VPWR _02928_ sky130_fd_sc_hd__o21ai_1
X_08236_ _03575_ _04038_ _04039_ VGND VGND VPWR VPWR _04040_ sky130_fd_sc_hd__a21oi_1
X_05448_ cpu_state\[4\] net194 VGND VGND VPWR VPWR _02033_ sky130_fd_sc_hd__and2_1
XFILLER_21_797 VPWR VGND VPWR VGND sky130_ef_sc_hd__decap_12
X_08167_ _03974_ _03975_ VGND VGND VPWR VPWR _03976_ sky130_fd_sc_hd__and2_1
XFILLER_119_641 VGND VGND VPWR VPWR sky130_fd_sc_hd__decap_8
XFILLER_134_611 VGND VGND VPWR VPWR sky130_fd_sc_hd__decap_4
X_05379_ reg_pc\[25\] decoded_imm\[25\] VGND VGND VPWR VPWR _01969_ sky130_fd_sc_hd__nor2_1
X_07118_ decoded_imm\[30\] net194 VGND VGND VPWR VPWR _03526_ sky130_fd_sc_hd__or2_1
XFILLER_122_806 VGND VGND VPWR VPWR sky130_fd_sc_hd__decap_6
XFILLER_106_346 VGND VGND VPWR VPWR sky130_fd_sc_hd__fill_2
X_08098_ _03705_ _03902_ _01551_ VGND VGND VPWR VPWR _03913_ sky130_fd_sc_hd__o21a_1
X_07049_ cpuregs\[16\]\[27\] cpuregs\[17\]\[27\] cpuregs\[18\]\[27\] cpuregs\[19\]\[27\]
+ net266 net261 VGND VGND VPWR VPWR _03460_ sky130_fd_sc_hd__mux4_1
XFILLER_88_720 VPWR VGND VPWR VGND sky130_ef_sc_hd__decap_12
XFILLER_79_208 VPWR VGND VPWR VGND sky130_ef_sc_hd__decap_12
X_10060_ clknet_leaf_44_clk _00190_ VGND VGND VPWR VPWR cpuregs\[13\]\[26\] sky130_fd_sc_hd__dfxtp_1
XFILLER_88_742 VPWR VGND VPWR VGND sky130_ef_sc_hd__decap_12
XFILLER_130_861 VGND VGND VPWR VPWR sky130_fd_sc_hd__decap_6
XTAP_TAPCELL_ROW_50_1127 VGND VPWR sky130_fd_sc_hd__tapvpwrvgnd_1
XFILLER_0_657 VGND VGND VPWR VPWR sky130_fd_sc_hd__decap_4
XTAP_TAPCELL_ROW_145_2655 VGND VPWR sky130_fd_sc_hd__tapvpwrvgnd_1
XTAP_TAPCELL_ROW_145_2644 VGND VPWR sky130_fd_sc_hd__tapvpwrvgnd_1
XFILLER_85_47 VGND VGND VPWR VPWR sky130_fd_sc_hd__decap_8
XTAP_TAPCELL_ROW_50_1138 VGND VPWR sky130_fd_sc_hd__tapvpwrvgnd_1
XFILLER_18_41 VPWR VGND VPWR VGND sky130_ef_sc_hd__decap_12
XFILLER_29_853 VPWR VGND VPWR VGND sky130_ef_sc_hd__decap_12
X_10962_ clknet_leaf_129_clk _01024_ VGND VGND VPWR VPWR decoded_imm\[6\] sky130_fd_sc_hd__dfxtp_2
XFILLER_18_85 VPWR VGND VPWR VGND sky130_ef_sc_hd__decap_12
XFILLER_28_363 VGND VGND VPWR VPWR sky130_fd_sc_hd__fill_1
XFILLER_28_374 VGND VGND VPWR VPWR sky130_fd_sc_hd__decap_8
XFILLER_29_897 VGND VGND VPWR VPWR sky130_fd_sc_hd__decap_8
XFILLER_43_333 VGND VGND VPWR VPWR sky130_fd_sc_hd__decap_3
XFILLER_70_141 VGND VGND VPWR VPWR sky130_fd_sc_hd__decap_4
X_10893_ clknet_leaf_109_clk _00955_ VGND VGND VPWR VPWR mem_state\[1\] sky130_fd_sc_hd__dfxtp_1
XTAP_TAPCELL_ROW_65_1370 VGND VPWR sky130_fd_sc_hd__tapvpwrvgnd_1
XFILLER_129_405 VPWR VGND VPWR VGND sky130_ef_sc_hd__decap_12
XFILLER_129_449 VPWR VGND VPWR VGND sky130_ef_sc_hd__decap_12
XFILLER_7_223 VGND VGND VPWR VPWR sky130_fd_sc_hd__fill_1
XFILLER_144_419 VGND VGND VPWR VPWR sky130_fd_sc_hd__fill_1
X_11445_ clknet_leaf_147_clk _01489_ VGND VGND VPWR VPWR cpuregs\[0\]\[11\] sky130_fd_sc_hd__dfxtp_1
XFILLER_50_83 VGND VGND VPWR VPWR sky130_fd_sc_hd__fill_1
XFILLER_152_430 VGND VGND VPWR VPWR sky130_fd_sc_hd__decap_4
X_11376_ clknet_leaf_4_clk _01420_ VGND VGND VPWR VPWR cpuregs\[7\]\[6\] sky130_fd_sc_hd__dfxtp_1
XFILLER_152_474 VGND VGND VPWR VPWR sky130_fd_sc_hd__fill_2
XFILLER_113_828 VGND VGND VPWR VPWR sky130_fd_sc_hd__decap_3
XFILLER_112_305 VGND VGND VPWR VPWR sky130_fd_sc_hd__decap_3
X_10327_ clknet_leaf_140_clk _00457_ VGND VGND VPWR VPWR cpuregs\[16\]\[5\] sky130_fd_sc_hd__dfxtp_1
XFILLER_106_891 VPWR VGND VPWR VGND sky130_ef_sc_hd__decap_12
XFILLER_3_495 VGND VGND VPWR VPWR sky130_fd_sc_hd__decap_8
XFILLER_3_473 VPWR VGND VPWR VGND sky130_ef_sc_hd__decap_12
X_10258_ clknet_leaf_126_clk _00388_ VGND VGND VPWR VPWR cpuregs\[15\]\[0\] sky130_fd_sc_hd__dfxtp_1
XFILLER_39_617 VPWR VGND VPWR VGND sky130_ef_sc_hd__decap_12
X_10189_ clknet_leaf_35_clk _00319_ VGND VGND VPWR VPWR cpuregs\[9\]\[27\] sky130_fd_sc_hd__dfxtp_1
XFILLER_94_734 VGND VGND VPWR VPWR sky130_fd_sc_hd__decap_4
XPHY_EDGE_ROW_53_Left_207 VGND VGND VPWR VPWR sky130_fd_sc_hd__decap_3
XFILLER_34_333 VGND VGND VPWR VPWR sky130_fd_sc_hd__decap_8
XFILLER_22_506 VGND VGND VPWR VPWR sky130_fd_sc_hd__fill_1
X_06420_ cpuregs\[6\]\[4\] cpuregs\[7\]\[4\] net264 VGND VGND VPWR VPWR _02854_ sky130_fd_sc_hd__mux2_1
XFILLER_34_377 VGND VGND VPWR VPWR sky130_fd_sc_hd__decap_4
XTAP_TAPCELL_ROW_17_597 VGND VPWR sky130_fd_sc_hd__tapvpwrvgnd_1
XFILLER_148_725 VGND VGND VPWR VPWR sky130_fd_sc_hd__decap_8
X_06351_ cpuregs\[4\]\[2\] cpuregs\[5\]\[2\] cpuregs\[6\]\[2\] cpuregs\[7\]\[2\] net268
+ net262 VGND VGND VPWR VPWR _02787_ sky130_fd_sc_hd__mux4_1
X_05302_ reg_pc\[19\] decoded_imm\[19\] VGND VGND VPWR VPWR _01898_ sky130_fd_sc_hd__nand2_1
X_06282_ instr_srl instr_srli _02719_ VGND VGND VPWR VPWR _02720_ sky130_fd_sc_hd__nor3_4
XPHY_EDGE_ROW_62_Left_216 VGND VGND VPWR VPWR sky130_fd_sc_hd__decap_3
X_09070_ _01547_ cpu_state\[6\] _01615_ mem_do_rdata net34 VGND VGND VPWR VPWR _04737_
+ sky130_fd_sc_hd__o221a_1
X_08021_ _03700_ _03834_ _03840_ VGND VGND VPWR VPWR _03841_ sky130_fd_sc_hd__o21a_1
X_05233_ net5 _01666_ _01667_ net22 _01772_ VGND VGND VPWR VPWR _01835_ sky130_fd_sc_hd__o221a_1
XFILLER_147_279 VGND VGND VPWR VPWR sky130_fd_sc_hd__fill_1
XFILLER_116_611 VGND VGND VPWR VPWR sky130_fd_sc_hd__fill_1
XFILLER_128_493 VGND VGND VPWR VPWR sky130_fd_sc_hd__decap_4
XTAP_TAPCELL_ROW_96_1875 VGND VPWR sky130_fd_sc_hd__tapvpwrvgnd_1
XTAP_TAPCELL_ROW_96_1864 VGND VPWR sky130_fd_sc_hd__tapvpwrvgnd_1
X_05164_ latched_is_lb _01760_ VGND VGND VPWR VPWR _01771_ sky130_fd_sc_hd__and2_2
XPHY_EDGE_ROW_123_Right_123 VGND VGND VPWR VPWR sky130_fd_sc_hd__decap_3
XFILLER_103_316 VGND VGND VPWR VPWR sky130_fd_sc_hd__decap_4
X_09972_ clknet_leaf_120_clk _00102_ VGND VGND VPWR VPWR cpuregs\[12\]\[2\] sky130_fd_sc_hd__dfxtp_1
X_05095_ _01703_ _01706_ VGND VGND VPWR VPWR _01707_ sky130_fd_sc_hd__xnor2_1
X_08923_ _01558_ _04600_ VGND VGND VPWR VPWR _04601_ sky130_fd_sc_hd__or2_1
XFILLER_115_198 VGND VGND VPWR VPWR sky130_fd_sc_hd__decap_4
XFILLER_97_561 VGND VGND VPWR VPWR sky130_fd_sc_hd__fill_1
XPHY_EDGE_ROW_71_Left_225 VGND VGND VPWR VPWR sky130_fd_sc_hd__decap_3
XFILLER_69_241 VGND VGND VPWR VPWR sky130_fd_sc_hd__fill_1
X_08854_ _04526_ _04534_ _04535_ _01560_ _00010_ VGND VGND VPWR VPWR _04536_ sky130_fd_sc_hd__a221o_1
XFILLER_85_745 VGND VGND VPWR VPWR sky130_fd_sc_hd__decap_6
XFILLER_69_263 VGND VGND VPWR VPWR sky130_fd_sc_hd__fill_1
XTAP_TAPCELL_ROW_127_2363 VGND VPWR sky130_fd_sc_hd__tapvpwrvgnd_1
X_05997_ reg_out\[21\] reg_next_pc\[21\] net597 VGND VGND VPWR VPWR _02502_ sky130_fd_sc_hd__mux2_1
X_07805_ _03675_ _03674_ VGND VGND VPWR VPWR _00637_ sky130_fd_sc_hd__nor2_1
X_08785_ _04460_ _04461_ _01558_ VGND VGND VPWR VPWR _04471_ sky130_fd_sc_hd__mux2_1
XFILLER_57_447 VGND VGND VPWR VPWR sky130_fd_sc_hd__fill_1
X_07736_ count_instr\[30\] _03629_ count_instr\[31\] VGND VGND VPWR VPWR _03632_ sky130_fd_sc_hd__a21o_1
X_04948_ _00016_ VGND VGND VPWR VPWR _01581_ sky130_fd_sc_hd__inv_16
XFILLER_37_160 VGND VGND VPWR VPWR sky130_fd_sc_hd__decap_8
XFILLER_38_661 VPWR VGND VPWR VGND sky130_ef_sc_hd__decap_12
XTAP_TAPCELL_ROW_140_2574 VGND VPWR sky130_fd_sc_hd__tapvpwrvgnd_1
X_07667_ count_instr\[5\] net400 count_instr\[6\] VGND VGND VPWR VPWR _03588_ sky130_fd_sc_hd__a21o_1
XFILLER_53_664 VGND VGND VPWR VPWR sky130_fd_sc_hd__fill_2
XFILLER_52_141 VGND VGND VPWR VPWR sky130_fd_sc_hd__decap_3
XFILLER_26_867 VGND VGND VPWR VPWR sky130_fd_sc_hd__fill_1
X_07598_ cpuregs\[20\]\[15\] _02646_ net245 VGND VGND VPWR VPWR _00531_ sky130_fd_sc_hd__mux2_1
X_09406_ _02624_ cpuregs\[18\]\[10\] _04862_ VGND VGND VPWR VPWR _01040_ sky130_fd_sc_hd__mux2_1
X_06618_ cpuregs\[4\]\[11\] cpuregs\[5\]\[11\] cpuregs\[6\]\[11\] cpuregs\[7\]\[11\]
+ net268 net259 VGND VGND VPWR VPWR _03045_ sky130_fd_sc_hd__mux4_1
XFILLER_41_848 VPWR VGND VPWR VGND sky130_ef_sc_hd__decap_12
X_09337_ decoded_imm\[27\] _04746_ _04825_ _04830_ VGND VGND VPWR VPWR _01003_ sky130_fd_sc_hd__o22a_1
XPHY_EDGE_ROW_80_Left_234 VGND VGND VPWR VPWR sky130_fd_sc_hd__decap_3
X_06549_ decoded_imm\[9\] net202 VGND VGND VPWR VPWR _02978_ sky130_fd_sc_hd__xor2_1
XFILLER_21_550 VGND VGND VPWR VPWR sky130_fd_sc_hd__decap_8
XFILLER_21_572 VGND VGND VPWR VPWR sky130_fd_sc_hd__fill_1
X_09268_ mem_do_wdata _01583_ _04807_ VGND VGND VPWR VPWR _04810_ sky130_fd_sc_hd__a21bo_1
X_08219_ _03716_ _04007_ VGND VGND VPWR VPWR _04024_ sky130_fd_sc_hd__and2_1
X_09199_ mem_rdata_q\[9\] net32 _01609_ VGND VGND VPWR VPWR _01103_ sky130_fd_sc_hd__mux2_1
XFILLER_153_249 VGND VGND VPWR VPWR sky130_fd_sc_hd__decap_3
X_11230_ clknet_leaf_42_clk _01277_ VGND VGND VPWR VPWR cpuregs\[3\]\[23\] sky130_fd_sc_hd__dfxtp_1
XFILLER_107_633 VPWR VGND VPWR VGND sky130_ef_sc_hd__decap_12
XFILLER_136_53 VPWR VGND VPWR VGND sky130_ef_sc_hd__decap_12
X_11161_ clknet_leaf_34_clk _01208_ VGND VGND VPWR VPWR cpuregs\[23\]\[18\] sky130_fd_sc_hd__dfxtp_1
XFILLER_20_53 VPWR VGND VPWR VGND sky130_ef_sc_hd__decap_12
XFILLER_134_485 VGND VGND VPWR VPWR sky130_fd_sc_hd__fill_2
XFILLER_121_113 VPWR VGND VPWR VGND sky130_ef_sc_hd__decap_12
XFILLER_121_102 VGND VGND VPWR VPWR sky130_fd_sc_hd__fill_2
X_10112_ clknet_leaf_25_clk _00242_ VGND VGND VPWR VPWR cpuregs\[28\]\[14\] sky130_fd_sc_hd__dfxtp_1
XFILLER_0_421 VGND VGND VPWR VPWR sky130_fd_sc_hd__fill_2
X_11092_ clknet_leaf_51_clk _01149_ VGND VGND VPWR VPWR cpuregs\[24\]\[23\] sky130_fd_sc_hd__dfxtp_1
XFILLER_76_701 VPWR VGND VPWR VGND sky130_ef_sc_hd__decap_12
XFILLER_76_734 VGND VGND VPWR VPWR sky130_fd_sc_hd__decap_8
XFILLER_48_436 VGND VGND VPWR VPWR sky130_fd_sc_hd__fill_2
XFILLER_48_414 VGND VGND VPWR VPWR sky130_fd_sc_hd__decap_6
X_10043_ clknet_leaf_1_clk _00173_ VGND VGND VPWR VPWR cpuregs\[13\]\[9\] sky130_fd_sc_hd__dfxtp_1
XFILLER_152_41 VPWR VGND VPWR VGND sky130_ef_sc_hd__decap_12
XFILLER_48_469 VGND VGND VPWR VPWR sky130_fd_sc_hd__decap_6
XFILLER_29_73 VGND VGND VPWR VPWR sky130_fd_sc_hd__fill_2
XFILLER_152_85 VPWR VGND VPWR VGND sky130_ef_sc_hd__decap_12
XTAP_TAPCELL_ROW_67_1410 VGND VPWR sky130_fd_sc_hd__tapvpwrvgnd_1
XFILLER_91_759 VGND VGND VPWR VPWR sky130_fd_sc_hd__decap_8
XFILLER_28_182 VGND VGND VPWR VPWR sky130_fd_sc_hd__decap_4
XPHY_EDGE_ROW_119_Left_273 VGND VGND VPWR VPWR sky130_fd_sc_hd__decap_3
X_10945_ clknet_leaf_94_clk _01007_ VGND VGND VPWR VPWR decoded_imm\[23\] sky130_fd_sc_hd__dfxtp_1
XFILLER_16_344 VGND VGND VPWR VPWR sky130_fd_sc_hd__fill_2
XFILLER_16_355 VGND VGND VPWR VPWR sky130_fd_sc_hd__decap_8
XFILLER_17_889 VGND VGND VPWR VPWR sky130_fd_sc_hd__decap_6
XFILLER_32_804 VGND VGND VPWR VPWR sky130_fd_sc_hd__decap_8
XFILLER_43_130 VGND VGND VPWR VPWR sky130_fd_sc_hd__decap_6
XFILLER_45_83 VGND VGND VPWR VPWR sky130_fd_sc_hd__decap_8
X_10876_ clknet_leaf_77_clk _00938_ VGND VGND VPWR VPWR cpuregs\[1\]\[20\] sky130_fd_sc_hd__dfxtp_1
XTAP_TAPCELL_ROW_80_1610 VGND VPWR sky130_fd_sc_hd__tapvpwrvgnd_1
XFILLER_71_494 VGND VGND VPWR VPWR sky130_fd_sc_hd__decap_4
XFILLER_32_837 VPWR VGND VPWR VGND sky130_ef_sc_hd__decap_12
XTAP_TAPCELL_ROW_14_556 VGND VPWR sky130_fd_sc_hd__tapvpwrvgnd_1
XFILLER_40_881 VPWR VGND VPWR VGND sky130_ef_sc_hd__decap_12
XFILLER_8_554 VGND VGND VPWR VPWR sky130_fd_sc_hd__fill_1
XFILLER_144_205 VGND VGND VPWR VPWR sky130_fd_sc_hd__fill_2
XFILLER_138_791 VPWR VGND VPWR VGND sky130_ef_sc_hd__decap_12
X_11428_ clknet_leaf_43_clk _01472_ VGND VGND VPWR VPWR cpuregs\[8\]\[26\] sky130_fd_sc_hd__dfxtp_1
XTAP_TAPCELL_ROW_78_1572 VGND VPWR sky130_fd_sc_hd__tapvpwrvgnd_1
XANTENNA_4 _01724_ VGND VGND VPWR VPWR sky130_fd_sc_hd__diode_2
XFILLER_153_783 VGND VGND VPWR VPWR sky130_fd_sc_hd__fill_1
X_11359_ clknet_leaf_74_clk _01403_ VGND VGND VPWR VPWR cpuregs\[6\]\[21\] sky130_fd_sc_hd__dfxtp_1
XPHY_EDGE_ROW_128_Left_282 VGND VGND VPWR VPWR sky130_fd_sc_hd__decap_3
XFILLER_98_303 VGND VGND VPWR VPWR sky130_fd_sc_hd__decap_4
XTAP_TAPCELL_ROW_78_1583 VGND VPWR sky130_fd_sc_hd__tapvpwrvgnd_1
XFILLER_6_77 VGND VGND VPWR VPWR sky130_fd_sc_hd__decap_6
XFILLER_113_625 VGND VGND VPWR VPWR sky130_fd_sc_hd__decap_3
XFILLER_4_793 VPWR VGND VPWR VGND sky130_ef_sc_hd__decap_12
XFILLER_3_281 VPWR VGND VPWR VGND sky130_ef_sc_hd__decap_12
XFILLER_140_477 VGND VGND VPWR VPWR sky130_fd_sc_hd__fill_2
XFILLER_140_466 VGND VGND VPWR VPWR sky130_fd_sc_hd__decap_8
XTAP_TAPCELL_ROW_91_1783 VGND VPWR sky130_fd_sc_hd__tapvpwrvgnd_1
XFILLER_140_499 VGND VGND VPWR VPWR sky130_fd_sc_hd__fill_1
XTAP_TAPCELL_ROW_91_1794 VGND VPWR sky130_fd_sc_hd__tapvpwrvgnd_1
X_05920_ net195 net227 _02237_ VGND VGND VPWR VPWR _02472_ sky130_fd_sc_hd__o21a_1
XFILLER_79_572 VGND VGND VPWR VPWR sky130_fd_sc_hd__fill_1
XFILLER_67_723 VGND VGND VPWR VPWR sky130_fd_sc_hd__decap_4
XFILLER_20_3 VPWR VGND VPWR VGND sky130_ef_sc_hd__decap_12
X_05851_ _02084_ _02237_ _02238_ _02082_ VGND VGND VPWR VPWR _02411_ sky130_fd_sc_hd__a22o_1
XFILLER_39_447 VGND VGND VPWR VPWR sky130_fd_sc_hd__fill_1
XTAP_TAPCELL_ROW_109_2082 VGND VPWR sky130_fd_sc_hd__tapvpwrvgnd_1
XTAP_TAPCELL_ROW_109_2071 VGND VPWR sky130_fd_sc_hd__tapvpwrvgnd_1
Xrebuffer27 _03600_ VGND VGND VPWR VPWR net413 sky130_fd_sc_hd__dlygate4sd1_1
XFILLER_54_428 VGND VGND VPWR VPWR sky130_fd_sc_hd__fill_2
Xrebuffer16 _04063_ VGND VGND VPWR VPWR net402 sky130_fd_sc_hd__dlygate4sd1_1
X_08570_ cpuregs\[8\]\[5\] cpuregs\[9\]\[5\] cpuregs\[10\]\[5\] cpuregs\[11\]\[5\]
+ net278 net273 VGND VGND VPWR VPWR _04267_ sky130_fd_sc_hd__mux4_1
XPHY_EDGE_ROW_137_Left_291 VGND VGND VPWR VPWR sky130_fd_sc_hd__decap_3
X_05782_ _02348_ _02203_ instr_sub VGND VGND VPWR VPWR _02349_ sky130_fd_sc_hd__mux2_1
Xrebuffer49 net436 VGND VGND VPWR VPWR net435 sky130_fd_sc_hd__dlygate4sd1_1
Xrebuffer38 net425 VGND VGND VPWR VPWR net424 sky130_fd_sc_hd__dlygate4sd1_1
X_07521_ _02603_ cpuregs\[16\]\[5\] _03570_ VGND VGND VPWR VPWR _00457_ sky130_fd_sc_hd__mux2_1
XFILLER_81_258 VGND VGND VPWR VPWR sky130_fd_sc_hd__fill_1
XFILLER_34_141 VGND VGND VPWR VPWR sky130_fd_sc_hd__decap_8
XTAP_TAPCELL_ROW_122_2282 VGND VPWR sky130_fd_sc_hd__tapvpwrvgnd_1
X_07452_ cpuregs\[15\]\[3\] _02593_ net246 VGND VGND VPWR VPWR _00391_ sky130_fd_sc_hd__mux2_1
XFILLER_34_174 VGND VGND VPWR VPWR sky130_fd_sc_hd__fill_2
XFILLER_35_686 VGND VGND VPWR VPWR sky130_fd_sc_hd__fill_1
XFILLER_50_667 VGND VGND VPWR VPWR sky130_fd_sc_hd__decap_4
XFILLER_50_645 VGND VGND VPWR VPWR sky130_fd_sc_hd__decap_6
X_07383_ cpuregs\[14\]\[1\] _02588_ net247 VGND VGND VPWR VPWR _00325_ sky130_fd_sc_hd__mux2_1
XTAP_TAPCELL_ROW_33_854 VGND VPWR sky130_fd_sc_hd__tapvpwrvgnd_1
X_06403_ net196 _02725_ _02835_ _02837_ VGND VGND VPWR VPWR _00072_ sky130_fd_sc_hd__a22o_1
XTAP_TAPCELL_ROW_98_1904 VGND VPWR sky130_fd_sc_hd__tapvpwrvgnd_1
X_09122_ is_lb_lh_lw_lbu_lhu _04746_ VGND VGND VPWR VPWR _04764_ sky130_fd_sc_hd__and2_1
XTAP_TAPCELL_ROW_33_865 VGND VPWR sky130_fd_sc_hd__tapvpwrvgnd_1
X_06334_ net606 _02770_ _02724_ VGND VGND VPWR VPWR _00070_ sky130_fd_sc_hd__mux2_1
XFILLER_108_419 VGND VGND VPWR VPWR sky130_fd_sc_hd__fill_1
X_06265_ reg_out\[30\] alu_out_q\[30\] net587 VGND VGND VPWR VPWR _02705_ sky130_fd_sc_hd__mux2_1
X_09053_ _04719_ _04720_ _01558_ VGND VGND VPWR VPWR _04724_ sky130_fd_sc_hd__mux2_1
X_06196_ _02649_ cpuregs\[11\]\[16\] _02582_ VGND VGND VPWR VPWR _00053_ sky130_fd_sc_hd__mux2_1
X_08004_ instr_jal _03824_ _03825_ VGND VGND VPWR VPWR _03826_ sky130_fd_sc_hd__or3b_1
X_05216_ _01816_ _01817_ _01818_ _01765_ VGND VGND VPWR VPWR _01819_ sky130_fd_sc_hd__o22a_1
Xmax_cap262 _00013_ VGND VGND VPWR VPWR net262 sky130_fd_sc_hd__buf_12
X_05147_ reg_pc\[7\] decoded_imm\[7\] VGND VGND VPWR VPWR _01755_ sky130_fd_sc_hd__nor2_1
Xmax_cap251 _03558_ VGND VGND VPWR VPWR net251 sky130_fd_sc_hd__buf_12
Xmax_cap240 _04865_ VGND VGND VPWR VPWR net240 sky130_fd_sc_hd__buf_12
XFILLER_103_113 VGND VGND VPWR VPWR sky130_fd_sc_hd__decap_6
Xmax_cap273 _00008_ VGND VGND VPWR VPWR net273 sky130_fd_sc_hd__buf_12
XTAP_TAPCELL_ROW_129_2403 VGND VPWR sky130_fd_sc_hd__tapvpwrvgnd_1
X_09955_ clknet_leaf_59_clk _00085_ VGND VGND VPWR VPWR net178 sky130_fd_sc_hd__dfxtp_4
X_05078_ net171 mem_wordsize\[1\] _01690_ VGND VGND VPWR VPWR _01691_ sky130_fd_sc_hd__and3_1
X_08906_ _01558_ _04575_ net269 VGND VGND VPWR VPWR _04585_ sky130_fd_sc_hd__o21a_1
X_09886_ cpuregs\[0\]\[16\] VGND VGND VPWR VPWR _01494_ sky130_fd_sc_hd__clkbuf_1
XFILLER_98_881 VGND VGND VPWR VPWR sky130_fd_sc_hd__fill_2
XTAP_TAPCELL_ROW_142_2603 VGND VPWR sky130_fd_sc_hd__tapvpwrvgnd_1
X_08837_ _01558_ _04511_ _00010_ VGND VGND VPWR VPWR _04520_ sky130_fd_sc_hd__o21a_1
XFILLER_100_842 VPWR VGND VPWR VGND sky130_ef_sc_hd__decap_12
XFILLER_85_553 VGND VGND VPWR VPWR sky130_fd_sc_hd__decap_6
X_08768_ net269 _04454_ _01559_ VGND VGND VPWR VPWR _04455_ sky130_fd_sc_hd__a21o_1
XFILLER_72_236 VPWR VGND VPWR VGND sky130_ef_sc_hd__decap_12
XFILLER_45_439 VGND VGND VPWR VPWR sky130_fd_sc_hd__decap_8
XFILLER_122_77 VGND VGND VPWR VPWR sky130_fd_sc_hd__fill_1
X_07719_ _03620_ _03621_ VGND VGND VPWR VPWR _00605_ sky130_fd_sc_hd__nor2_1
X_08699_ cpuregs\[28\]\[12\] cpuregs\[29\]\[12\] cpuregs\[30\]\[12\] cpuregs\[31\]\[12\]
+ net277 net271 VGND VGND VPWR VPWR _04389_ sky130_fd_sc_hd__mux4_1
XFILLER_26_642 VGND VGND VPWR VPWR sky130_fd_sc_hd__fill_2
X_10730_ clknet_leaf_74_clk _00827_ VGND VGND VPWR VPWR net216 sky130_fd_sc_hd__dfxtp_2
XFILLER_13_314 VGND VGND VPWR VPWR sky130_fd_sc_hd__fill_1
XFILLER_14_837 VPWR VGND VPWR VGND sky130_ef_sc_hd__decap_12
XFILLER_25_185 VGND VGND VPWR VPWR sky130_fd_sc_hd__fill_2
XFILLER_41_612 VGND VGND VPWR VPWR sky130_fd_sc_hd__decap_4
X_10661_ clknet_leaf_90_clk _04888_ VGND VGND VPWR VPWR reg_out\[19\] sky130_fd_sc_hd__dfxtp_1
XTAP_TAPCELL_ROW_45_1048 VGND VPWR sky130_fd_sc_hd__tapvpwrvgnd_1
XTAP_TAPCELL_ROW_45_1059 VGND VPWR sky130_fd_sc_hd__tapvpwrvgnd_1
XTAP_TAPCELL_ROW_11_504 VGND VPWR sky130_fd_sc_hd__tapvpwrvgnd_1
XFILLER_22_881 VPWR VGND VPWR VGND sky130_ef_sc_hd__decap_12
X_10592_ clknet_leaf_87_clk _00722_ VGND VGND VPWR VPWR count_cycle\[15\] sky130_fd_sc_hd__dfxtp_1
XTAP_TAPCELL_ROW_11_515 VGND VPWR sky130_fd_sc_hd__tapvpwrvgnd_1
XFILLER_139_577 VGND VGND VPWR VPWR sky130_fd_sc_hd__fill_1
XTAP_TAPCELL_ROW_153_2798 VGND VPWR sky130_fd_sc_hd__tapvpwrvgnd_1
XTAP_TAPCELL_ROW_153_2787 VGND VPWR sky130_fd_sc_hd__tapvpwrvgnd_1
XTAP_TAPCELL_ROW_153_2776 VGND VPWR sky130_fd_sc_hd__tapvpwrvgnd_1
X_11213_ clknet_leaf_4_clk _01260_ VGND VGND VPWR VPWR cpuregs\[3\]\[6\] sky130_fd_sc_hd__dfxtp_1
Xoutput52 net52 VGND VGND VPWR VPWR mem_addr[27] sky130_fd_sc_hd__buf_2
Xoutput41 net41 VGND VGND VPWR VPWR mem_addr[16] sky130_fd_sc_hd__buf_2
Xoutput85 net85 VGND VGND VPWR VPWR mem_la_addr[29] sky130_fd_sc_hd__buf_2
Xoutput74 net74 VGND VGND VPWR VPWR mem_la_addr[18] sky130_fd_sc_hd__buf_2
Xoutput63 net63 VGND VGND VPWR VPWR mem_addr[8] sky130_fd_sc_hd__buf_2
XFILLER_1_741 VPWR VGND VPWR VGND sky130_ef_sc_hd__decap_12
X_11144_ clknet_leaf_116_clk _01191_ VGND VGND VPWR VPWR cpuregs\[23\]\[1\] sky130_fd_sc_hd__dfxtp_1
XFILLER_110_628 VGND VGND VPWR VPWR sky130_fd_sc_hd__decap_8
XFILLER_1_785 VPWR VGND VPWR VGND sky130_ef_sc_hd__decap_12
Xoutput96 net96 VGND VGND VPWR VPWR mem_la_read sky130_fd_sc_hd__buf_2
X_11075_ clknet_leaf_13_clk _01132_ VGND VGND VPWR VPWR cpuregs\[24\]\[6\] sky130_fd_sc_hd__dfxtp_1
X_10026_ clknet_leaf_67_clk _00156_ VGND VGND VPWR VPWR cpuregs\[30\]\[24\] sky130_fd_sc_hd__dfxtp_1
XFILLER_103_691 VGND VGND VPWR VPWR sky130_fd_sc_hd__decap_3
XFILLER_63_225 VPWR VGND VPWR VGND sky130_ef_sc_hd__decap_12
XTAP_TAPCELL_ROW_19_637 VGND VPWR sky130_fd_sc_hd__tapvpwrvgnd_1
XFILLER_63_269 VGND VGND VPWR VPWR sky130_fd_sc_hd__fill_2
XFILLER_16_141 VGND VGND VPWR VPWR sky130_fd_sc_hd__decap_8
X_10928_ clknet_leaf_106_clk _00990_ VGND VGND VPWR VPWR net169 sky130_fd_sc_hd__dfxtp_1
X_10859_ clknet_leaf_123_clk _00921_ VGND VGND VPWR VPWR cpuregs\[1\]\[3\] sky130_fd_sc_hd__dfxtp_1
XTAP_TAPCELL_ROW_30_813 VGND VPWR sky130_fd_sc_hd__tapvpwrvgnd_1
XFILLER_9_841 VPWR VGND VPWR VGND sky130_ef_sc_hd__decap_12
XFILLER_118_717 VGND VGND VPWR VPWR sky130_fd_sc_hd__decap_4
X_06050_ _02521_ _02522_ _01558_ VGND VGND VPWR VPWR _02523_ sky130_fd_sc_hd__mux2_1
XFILLER_132_208 VPWR VGND VPWR VGND sky130_ef_sc_hd__decap_12
XTAP_TAPCELL_ROW_93_1823 VGND VPWR sky130_fd_sc_hd__tapvpwrvgnd_1
XTAP_TAPCELL_ROW_93_1812 VGND VPWR sky130_fd_sc_hd__tapvpwrvgnd_1
X_05001_ cpu_state\[1\] net34 VGND VGND VPWR VPWR _01629_ sky130_fd_sc_hd__nand2_1
XFILLER_113_411 VPWR VGND VPWR VGND sky130_ef_sc_hd__decap_12
XFILLER_113_433 VPWR VGND VPWR VGND sky130_ef_sc_hd__decap_12
XFILLER_101_606 VGND VGND VPWR VPWR sky130_fd_sc_hd__decap_8
XFILLER_141_797 VPWR VGND VPWR VGND sky130_ef_sc_hd__decap_12
X_06952_ _00015_ _03363_ _03366_ _02735_ VGND VGND VPWR VPWR _03367_ sky130_fd_sc_hd__o211a_1
XFILLER_101_617 VPWR VGND VPWR VGND sky130_ef_sc_hd__decap_12
XFILLER_98_188 VGND VGND VPWR VPWR sky130_fd_sc_hd__decap_8
X_09740_ _02638_ cpuregs\[6\]\[13\] _04873_ VGND VGND VPWR VPWR _01395_ sky130_fd_sc_hd__mux2_1
.ends
